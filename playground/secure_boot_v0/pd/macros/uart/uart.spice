* NGSPICE file created from uart.ext - technology: gf180mcuD

* Black-box entry subcircuit for gf180mcu_fd_sc_mcu7t5v0__fill_1 abstract view
.subckt gf180mcu_fd_sc_mcu7t5v0__fill_1 VDD VNW VPW VSS
.ends

* Black-box entry subcircuit for gf180mcu_fd_sc_mcu7t5v0__dffq_1 abstract view
.subckt gf180mcu_fd_sc_mcu7t5v0__dffq_1 D CLK Q VDD VNW VPW VSS
.ends

* Black-box entry subcircuit for gf180mcu_fd_sc_mcu7t5v0__filltie abstract view
.subckt gf180mcu_fd_sc_mcu7t5v0__filltie VDD VSS
.ends

* Black-box entry subcircuit for gf180mcu_fd_sc_mcu7t5v0__fill_2 abstract view
.subckt gf180mcu_fd_sc_mcu7t5v0__fill_2 VDD VNW VPW VSS
.ends

* Black-box entry subcircuit for gf180mcu_fd_sc_mcu7t5v0__nand2_1 abstract view
.subckt gf180mcu_fd_sc_mcu7t5v0__nand2_1 A1 A2 ZN VDD VNW VPW VSS
.ends

* Black-box entry subcircuit for gf180mcu_fd_sc_mcu7t5v0__fillcap_4 abstract view
.subckt gf180mcu_fd_sc_mcu7t5v0__fillcap_4 VDD VNW VPW VSS
.ends

* Black-box entry subcircuit for gf180mcu_fd_sc_mcu7t5v0__oai22_1 abstract view
.subckt gf180mcu_fd_sc_mcu7t5v0__oai22_1 A1 A2 B1 B2 ZN VDD VNW VPW VSS
.ends

* Black-box entry subcircuit for gf180mcu_fd_sc_mcu7t5v0__fillcap_64 abstract view
.subckt gf180mcu_fd_sc_mcu7t5v0__fillcap_64 VDD VNW VPW VSS
.ends

* Black-box entry subcircuit for gf180mcu_fd_sc_mcu7t5v0__fillcap_8 abstract view
.subckt gf180mcu_fd_sc_mcu7t5v0__fillcap_8 VDD VNW VPW VSS
.ends

* Black-box entry subcircuit for gf180mcu_fd_sc_mcu7t5v0__oai21_1 abstract view
.subckt gf180mcu_fd_sc_mcu7t5v0__oai21_1 A1 A2 B ZN VDD VNW VPW VSS
.ends

* Black-box entry subcircuit for gf180mcu_fd_sc_mcu7t5v0__xor2_1 abstract view
.subckt gf180mcu_fd_sc_mcu7t5v0__xor2_1 A1 A2 Z VDD VNW VPW VSS
.ends

* Black-box entry subcircuit for gf180mcu_fd_sc_mcu7t5v0__xor3_1 abstract view
.subckt gf180mcu_fd_sc_mcu7t5v0__xor3_1 A1 A2 A3 Z VDD VNW VPW VSS
.ends

* Black-box entry subcircuit for gf180mcu_fd_sc_mcu7t5v0__aoi21_1 abstract view
.subckt gf180mcu_fd_sc_mcu7t5v0__aoi21_1 A1 A2 B ZN VDD VNW VPW VSS
.ends

* Black-box entry subcircuit for gf180mcu_fd_sc_mcu7t5v0__nor3_1 abstract view
.subckt gf180mcu_fd_sc_mcu7t5v0__nor3_1 A1 A2 A3 ZN VDD VNW VPW VSS
.ends

* Black-box entry subcircuit for gf180mcu_fd_sc_mcu7t5v0__and2_1 abstract view
.subckt gf180mcu_fd_sc_mcu7t5v0__and2_1 A1 A2 Z VDD VNW VPW VSS
.ends

* Black-box entry subcircuit for gf180mcu_fd_sc_mcu7t5v0__and3_1 abstract view
.subckt gf180mcu_fd_sc_mcu7t5v0__and3_1 A1 A2 A3 Z VDD VNW VPW VSS
.ends

* Black-box entry subcircuit for gf180mcu_fd_sc_mcu7t5v0__nor2_1 abstract view
.subckt gf180mcu_fd_sc_mcu7t5v0__nor2_1 A1 A2 ZN VDD VNW VPW VSS
.ends

* Black-box entry subcircuit for gf180mcu_fd_sc_mcu7t5v0__oai222_1 abstract view
.subckt gf180mcu_fd_sc_mcu7t5v0__oai222_1 A1 A2 B1 B2 C1 C2 ZN VDD VNW VPW VSS
.ends

* Black-box entry subcircuit for gf180mcu_fd_sc_mcu7t5v0__fillcap_32 abstract view
.subckt gf180mcu_fd_sc_mcu7t5v0__fillcap_32 VDD VNW VPW VSS
.ends

* Black-box entry subcircuit for gf180mcu_fd_sc_mcu7t5v0__buf_1 abstract view
.subckt gf180mcu_fd_sc_mcu7t5v0__buf_1 I Z VDD VNW VPW VSS
.ends

* Black-box entry subcircuit for gf180mcu_fd_sc_mcu7t5v0__fillcap_16 abstract view
.subckt gf180mcu_fd_sc_mcu7t5v0__fillcap_16 VDD VNW VPW VSS
.ends

* Black-box entry subcircuit for gf180mcu_fd_sc_mcu7t5v0__clkbuf_4 abstract view
.subckt gf180mcu_fd_sc_mcu7t5v0__clkbuf_4 I Z VDD VNW VPW VSS
.ends

* Black-box entry subcircuit for gf180mcu_fd_sc_mcu7t5v0__dffrnq_1 abstract view
.subckt gf180mcu_fd_sc_mcu7t5v0__dffrnq_1 D RN CLK Q VDD VNW VPW VSS
.ends

* Black-box entry subcircuit for gf180mcu_fd_sc_mcu7t5v0__oai32_1 abstract view
.subckt gf180mcu_fd_sc_mcu7t5v0__oai32_1 A1 A2 A3 B1 B2 ZN VDD VNW VPW VSS
.ends

* Black-box entry subcircuit for gf180mcu_fd_sc_mcu7t5v0__mux2_2 abstract view
.subckt gf180mcu_fd_sc_mcu7t5v0__mux2_2 I0 I1 S Z VDD VNW VPW VSS
.ends

* Black-box entry subcircuit for gf180mcu_fd_sc_mcu7t5v0__endcap abstract view
.subckt gf180mcu_fd_sc_mcu7t5v0__endcap VDD VSS
.ends

* Black-box entry subcircuit for gf180mcu_fd_sc_mcu7t5v0__aoi22_1 abstract view
.subckt gf180mcu_fd_sc_mcu7t5v0__aoi22_1 A1 A2 B1 B2 ZN VDD VNW VPW VSS
.ends

* Black-box entry subcircuit for gf180mcu_fd_sc_mcu7t5v0__clkinv_1 abstract view
.subckt gf180mcu_fd_sc_mcu7t5v0__clkinv_1 I ZN VDD VNW VPW VSS
.ends

* Black-box entry subcircuit for gf180mcu_fd_sc_mcu7t5v0__xnor3_1 abstract view
.subckt gf180mcu_fd_sc_mcu7t5v0__xnor3_1 A1 A2 A3 ZN VDD VNW VPW VSS
.ends

* Black-box entry subcircuit for gf180mcu_fd_sc_mcu7t5v0__oai221_1 abstract view
.subckt gf180mcu_fd_sc_mcu7t5v0__oai221_1 A1 A2 B1 B2 C ZN VDD VNW VPW VSS
.ends

* Black-box entry subcircuit for gf180mcu_fd_sc_mcu7t5v0__antenna abstract view
.subckt gf180mcu_fd_sc_mcu7t5v0__antenna I VDD VNW VPW VSS
.ends

* Black-box entry subcircuit for gf180mcu_fd_sc_mcu7t5v0__or2_1 abstract view
.subckt gf180mcu_fd_sc_mcu7t5v0__or2_1 A1 A2 Z VDD VNW VPW VSS
.ends

* Black-box entry subcircuit for gf180mcu_fd_sc_mcu7t5v0__clkbuf_8 abstract view
.subckt gf180mcu_fd_sc_mcu7t5v0__clkbuf_8 I Z VDD VNW VPW VSS
.ends

* Black-box entry subcircuit for gf180mcu_fd_sc_mcu7t5v0__buf_4 abstract view
.subckt gf180mcu_fd_sc_mcu7t5v0__buf_4 I Z VDD VNW VPW VSS
.ends

* Black-box entry subcircuit for gf180mcu_fd_sc_mcu7t5v0__dlyd_1 abstract view
.subckt gf180mcu_fd_sc_mcu7t5v0__dlyd_1 I Z VDD VNW VPW VSS
.ends

* Black-box entry subcircuit for gf180mcu_fd_sc_mcu7t5v0__and4_1 abstract view
.subckt gf180mcu_fd_sc_mcu7t5v0__and4_1 A1 A2 A3 A4 Z VDD VNW VPW VSS
.ends

* Black-box entry subcircuit for gf180mcu_fd_sc_mcu7t5v0__aoi211_1 abstract view
.subckt gf180mcu_fd_sc_mcu7t5v0__aoi211_1 A1 A2 B C ZN VDD VNW VPW VSS
.ends

* Black-box entry subcircuit for gf180mcu_fd_sc_mcu7t5v0__nor2_2 abstract view
.subckt gf180mcu_fd_sc_mcu7t5v0__nor2_2 A1 A2 ZN VDD VNW VPW VSS
.ends

* Black-box entry subcircuit for gf180mcu_fd_sc_mcu7t5v0__inv_2 abstract view
.subckt gf180mcu_fd_sc_mcu7t5v0__inv_2 I ZN VDD VNW VPW VSS
.ends

* Black-box entry subcircuit for gf180mcu_fd_sc_mcu7t5v0__oai211_1 abstract view
.subckt gf180mcu_fd_sc_mcu7t5v0__oai211_1 A1 A2 B C ZN VDD VNW VPW VSS
.ends

* Black-box entry subcircuit for gf180mcu_fd_sc_mcu7t5v0__nor4_1 abstract view
.subckt gf180mcu_fd_sc_mcu7t5v0__nor4_1 A1 A2 A3 A4 ZN VDD VNW VPW VSS
.ends

* Black-box entry subcircuit for gf180mcu_fd_sc_mcu7t5v0__oai31_1 abstract view
.subckt gf180mcu_fd_sc_mcu7t5v0__oai31_1 A1 A2 A3 B ZN VDD VNW VPW VSS
.ends

* Black-box entry subcircuit for gf180mcu_fd_sc_mcu7t5v0__dffsnq_1 abstract view
.subckt gf180mcu_fd_sc_mcu7t5v0__dffsnq_1 D SETN CLK Q VDD VNW VPW VSS
.ends

* Black-box entry subcircuit for gf180mcu_fd_sc_mcu7t5v0__nand3_1 abstract view
.subckt gf180mcu_fd_sc_mcu7t5v0__nand3_1 A1 A2 A3 ZN VDD VNW VPW VSS
.ends

* Black-box entry subcircuit for gf180mcu_fd_sc_mcu7t5v0__clkbuf_16 abstract view
.subckt gf180mcu_fd_sc_mcu7t5v0__clkbuf_16 I Z VDD VNW VPW VSS
.ends

* Black-box entry subcircuit for gf180mcu_fd_sc_mcu7t5v0__clkbuf_2 abstract view
.subckt gf180mcu_fd_sc_mcu7t5v0__clkbuf_2 I Z VDD VNW VPW VSS
.ends

* Black-box entry subcircuit for gf180mcu_fd_sc_mcu7t5v0__or3_1 abstract view
.subckt gf180mcu_fd_sc_mcu7t5v0__or3_1 A1 A2 A3 Z VDD VNW VPW VSS
.ends

* Black-box entry subcircuit for gf180mcu_fd_sc_mcu7t5v0__inv_4 abstract view
.subckt gf180mcu_fd_sc_mcu7t5v0__inv_4 I ZN VDD VNW VPW VSS
.ends

* Black-box entry subcircuit for gf180mcu_fd_sc_mcu7t5v0__buf_2 abstract view
.subckt gf180mcu_fd_sc_mcu7t5v0__buf_2 I Z VDD VNW VPW VSS
.ends

* Black-box entry subcircuit for gf180mcu_fd_sc_mcu7t5v0__aoi222_1 abstract view
.subckt gf180mcu_fd_sc_mcu7t5v0__aoi222_1 A1 A2 B1 B2 C1 C2 ZN VDD VNW VPW VSS
.ends

* Black-box entry subcircuit for gf180mcu_fd_sc_mcu7t5v0__nand4_1 abstract view
.subckt gf180mcu_fd_sc_mcu7t5v0__nand4_1 A1 A2 A3 A4 ZN VDD VNW VPW VSS
.ends

* Black-box entry subcircuit for gf180mcu_fd_sc_mcu7t5v0__clkinv_12 abstract view
.subckt gf180mcu_fd_sc_mcu7t5v0__clkinv_12 I ZN VDD VNW VPW VSS
.ends

* Black-box entry subcircuit for gf180mcu_fd_sc_mcu7t5v0__buf_3 abstract view
.subckt gf180mcu_fd_sc_mcu7t5v0__buf_3 I Z VDD VNW VPW VSS
.ends

* Black-box entry subcircuit for gf180mcu_fd_sc_mcu7t5v0__inv_3 abstract view
.subckt gf180mcu_fd_sc_mcu7t5v0__inv_3 I ZN VDD VNW VPW VSS
.ends

* Black-box entry subcircuit for gf180mcu_fd_sc_mcu7t5v0__inv_12 abstract view
.subckt gf180mcu_fd_sc_mcu7t5v0__inv_12 I ZN VDD VNW VPW VSS
.ends

* Black-box entry subcircuit for gf180mcu_fd_sc_mcu7t5v0__aoi221_1 abstract view
.subckt gf180mcu_fd_sc_mcu7t5v0__aoi221_1 A1 A2 B1 B2 C ZN VDD VNW VPW VSS
.ends

* Black-box entry subcircuit for gf180mcu_fd_sc_mcu7t5v0__clkinv_2 abstract view
.subckt gf180mcu_fd_sc_mcu7t5v0__clkinv_2 I ZN VDD VNW VPW VSS
.ends

* Black-box entry subcircuit for gf180mcu_fd_sc_mcu7t5v0__clkinv_8 abstract view
.subckt gf180mcu_fd_sc_mcu7t5v0__clkinv_8 I ZN VDD VNW VPW VSS
.ends

* Black-box entry subcircuit for gf180mcu_fd_sc_mcu7t5v0__clkinv_16 abstract view
.subckt gf180mcu_fd_sc_mcu7t5v0__clkinv_16 I ZN VDD VNW VPW VSS
.ends

* Black-box entry subcircuit for gf180mcu_fd_sc_mcu7t5v0__xnor2_1 abstract view
.subckt gf180mcu_fd_sc_mcu7t5v0__xnor2_1 A1 A2 ZN VDD VNW VPW VSS
.ends

* Black-box entry subcircuit for gf180mcu_fd_sc_mcu7t5v0__or4_1 abstract view
.subckt gf180mcu_fd_sc_mcu7t5v0__or4_1 A1 A2 A3 A4 Z VDD VNW VPW VSS
.ends

* Black-box entry subcircuit for gf180mcu_fd_sc_mcu7t5v0__clkinv_20 abstract view
.subckt gf180mcu_fd_sc_mcu7t5v0__clkinv_20 I ZN VDD VNW VPW VSS
.ends

* Black-box entry subcircuit for gf180mcu_fd_sc_mcu7t5v0__nor3_4 abstract view
.subckt gf180mcu_fd_sc_mcu7t5v0__nor3_4 A1 A2 A3 ZN VDD VNW VPW VSS
.ends

* Black-box entry subcircuit for gf180mcu_fd_sc_mcu7t5v0__oai21_2 abstract view
.subckt gf180mcu_fd_sc_mcu7t5v0__oai21_2 A1 A2 B ZN VDD VNW VPW VSS
.ends

* Black-box entry subcircuit for gf180mcu_fd_sc_mcu7t5v0__tiel abstract view
.subckt gf180mcu_fd_sc_mcu7t5v0__tiel ZN VDD VNW VPW VSS
.ends

* Black-box entry subcircuit for gf180mcu_fd_sc_mcu7t5v0__nor4_4 abstract view
.subckt gf180mcu_fd_sc_mcu7t5v0__nor4_4 A1 A2 A3 A4 ZN VDD VNW VPW VSS
.ends

* Black-box entry subcircuit for gf180mcu_fd_sc_mcu7t5v0__nor3_2 abstract view
.subckt gf180mcu_fd_sc_mcu7t5v0__nor3_2 A1 A2 A3 ZN VDD VNW VPW VSS
.ends

* Black-box entry subcircuit for gf180mcu_fd_sc_mcu7t5v0__oai31_2 abstract view
.subckt gf180mcu_fd_sc_mcu7t5v0__oai31_2 A1 A2 A3 B ZN VDD VNW VPW VSS
.ends

* Black-box entry subcircuit for gf180mcu_fd_sc_mcu7t5v0__clkinv_3 abstract view
.subckt gf180mcu_fd_sc_mcu7t5v0__clkinv_3 I ZN VDD VNW VPW VSS
.ends

* Black-box entry subcircuit for gf180mcu_fd_sc_mcu7t5v0__tieh abstract view
.subckt gf180mcu_fd_sc_mcu7t5v0__tieh Z VDD VNW VPW VSS
.ends

* Black-box entry subcircuit for gf180mcu_fd_sc_mcu7t5v0__nand2_2 abstract view
.subckt gf180mcu_fd_sc_mcu7t5v0__nand2_2 A1 A2 ZN VDD VNW VPW VSS
.ends

* Black-box entry subcircuit for gf180mcu_fd_sc_mcu7t5v0__aoi21_2 abstract view
.subckt gf180mcu_fd_sc_mcu7t5v0__aoi21_2 A1 A2 B ZN VDD VNW VPW VSS
.ends

.subckt uart VDD VSS alert_rx_i[0] alert_rx_i[1] alert_rx_i[2] alert_rx_i[3] alert_tx_o[0]
+ alert_tx_o[1] cio_rx_i cio_tx_en_o cio_tx_o clk_i intr_rx_break_err_o intr_rx_frame_err_o
+ intr_rx_overflow_o intr_rx_parity_err_o intr_rx_timeout_o intr_rx_watermark_o intr_tx_done_o
+ intr_tx_empty_o intr_tx_watermark_o lsio_trigger_o racl_error_o[0] racl_error_o[10]
+ racl_error_o[11] racl_error_o[12] racl_error_o[13] racl_error_o[14] racl_error_o[15]
+ racl_error_o[16] racl_error_o[17] racl_error_o[18] racl_error_o[19] racl_error_o[1]
+ racl_error_o[20] racl_error_o[21] racl_error_o[22] racl_error_o[23] racl_error_o[24]
+ racl_error_o[25] racl_error_o[26] racl_error_o[27] racl_error_o[28] racl_error_o[29]
+ racl_error_o[2] racl_error_o[30] racl_error_o[31] racl_error_o[32] racl_error_o[33]
+ racl_error_o[34] racl_error_o[35] racl_error_o[36] racl_error_o[37] racl_error_o[38]
+ racl_error_o[39] racl_error_o[3] racl_error_o[40] racl_error_o[41] racl_error_o[42]
+ racl_error_o[43] racl_error_o[4] racl_error_o[5] racl_error_o[6] racl_error_o[7]
+ racl_error_o[8] racl_error_o[9] racl_policies_i[0] racl_policies_i[10] racl_policies_i[11]
+ racl_policies_i[12] racl_policies_i[13] racl_policies_i[14] racl_policies_i[15]
+ racl_policies_i[16] racl_policies_i[17] racl_policies_i[18] racl_policies_i[19]
+ racl_policies_i[1] racl_policies_i[20] racl_policies_i[21] racl_policies_i[22] racl_policies_i[23]
+ racl_policies_i[24] racl_policies_i[25] racl_policies_i[26] racl_policies_i[27]
+ racl_policies_i[28] racl_policies_i[29] racl_policies_i[2] racl_policies_i[30] racl_policies_i[31]
+ racl_policies_i[32] racl_policies_i[33] racl_policies_i[34] racl_policies_i[35]
+ racl_policies_i[36] racl_policies_i[37] racl_policies_i[38] racl_policies_i[39]
+ racl_policies_i[3] racl_policies_i[40] racl_policies_i[41] racl_policies_i[42] racl_policies_i[43]
+ racl_policies_i[44] racl_policies_i[45] racl_policies_i[46] racl_policies_i[47]
+ racl_policies_i[48] racl_policies_i[49] racl_policies_i[4] racl_policies_i[50] racl_policies_i[51]
+ racl_policies_i[52] racl_policies_i[53] racl_policies_i[54] racl_policies_i[55]
+ racl_policies_i[56] racl_policies_i[57] racl_policies_i[58] racl_policies_i[59]
+ racl_policies_i[5] racl_policies_i[60] racl_policies_i[61] racl_policies_i[62] racl_policies_i[63]
+ racl_policies_i[64] racl_policies_i[65] racl_policies_i[66] racl_policies_i[67]
+ racl_policies_i[68] racl_policies_i[69] racl_policies_i[6] racl_policies_i[70] racl_policies_i[71]
+ racl_policies_i[72] racl_policies_i[73] racl_policies_i[74] racl_policies_i[75]
+ racl_policies_i[76] racl_policies_i[77] racl_policies_i[78] racl_policies_i[79]
+ racl_policies_i[7] racl_policies_i[80] racl_policies_i[81] racl_policies_i[82] racl_policies_i[83]
+ racl_policies_i[84] racl_policies_i[85] racl_policies_i[86] racl_policies_i[87]
+ racl_policies_i[88] racl_policies_i[89] racl_policies_i[8] racl_policies_i[90] racl_policies_i[91]
+ racl_policies_i[92] racl_policies_i[93] racl_policies_i[94] racl_policies_i[95]
+ racl_policies_i[9] rst_ni tl_i[0] tl_i[100] tl_i[101] tl_i[102] tl_i[103] tl_i[104]
+ tl_i[105] tl_i[106] tl_i[107] tl_i[108] tl_i[109] tl_i[10] tl_i[110] tl_i[111] tl_i[112]
+ tl_i[113] tl_i[11] tl_i[12] tl_i[13] tl_i[14] tl_i[15] tl_i[16] tl_i[17] tl_i[18]
+ tl_i[19] tl_i[1] tl_i[20] tl_i[21] tl_i[22] tl_i[23] tl_i[24] tl_i[25] tl_i[26]
+ tl_i[27] tl_i[28] tl_i[29] tl_i[2] tl_i[30] tl_i[31] tl_i[32] tl_i[33] tl_i[34]
+ tl_i[35] tl_i[36] tl_i[37] tl_i[38] tl_i[39] tl_i[3] tl_i[40] tl_i[41] tl_i[42]
+ tl_i[43] tl_i[44] tl_i[45] tl_i[46] tl_i[47] tl_i[48] tl_i[49] tl_i[4] tl_i[50]
+ tl_i[51] tl_i[52] tl_i[53] tl_i[54] tl_i[55] tl_i[56] tl_i[57] tl_i[58] tl_i[59]
+ tl_i[5] tl_i[60] tl_i[61] tl_i[62] tl_i[63] tl_i[64] tl_i[65] tl_i[66] tl_i[67]
+ tl_i[68] tl_i[69] tl_i[6] tl_i[70] tl_i[71] tl_i[72] tl_i[73] tl_i[74] tl_i[75]
+ tl_i[76] tl_i[77] tl_i[78] tl_i[79] tl_i[7] tl_i[80] tl_i[81] tl_i[82] tl_i[83]
+ tl_i[84] tl_i[85] tl_i[86] tl_i[87] tl_i[88] tl_i[89] tl_i[8] tl_i[90] tl_i[91]
+ tl_i[92] tl_i[93] tl_i[94] tl_i[95] tl_i[96] tl_i[97] tl_i[98] tl_i[99] tl_i[9]
+ tl_o[0] tl_o[10] tl_o[11] tl_o[12] tl_o[13] tl_o[14] tl_o[15] tl_o[16] tl_o[17]
+ tl_o[18] tl_o[19] tl_o[1] tl_o[20] tl_o[21] tl_o[22] tl_o[23] tl_o[24] tl_o[25]
+ tl_o[26] tl_o[27] tl_o[28] tl_o[29] tl_o[2] tl_o[30] tl_o[31] tl_o[32] tl_o[33]
+ tl_o[34] tl_o[35] tl_o[36] tl_o[37] tl_o[38] tl_o[39] tl_o[3] tl_o[40] tl_o[41]
+ tl_o[42] tl_o[43] tl_o[44] tl_o[45] tl_o[46] tl_o[47] tl_o[48] tl_o[49] tl_o[4]
+ tl_o[50] tl_o[51] tl_o[52] tl_o[53] tl_o[54] tl_o[55] tl_o[56] tl_o[57] tl_o[58]
+ tl_o[59] tl_o[5] tl_o[60] tl_o[61] tl_o[62] tl_o[63] tl_o[64] tl_o[65] tl_o[6] tl_o[7]
+ tl_o[8] tl_o[9]
XFILLER_67_564 VDD VDD VSS VSS gf180mcu_fd_sc_mcu7t5v0__fill_1
XFILLER_27_439 VDD VDD VSS VSS gf180mcu_fd_sc_mcu7t5v0__fill_1
X_6914_ _6914_/D _7254_/CLK _6914_/Q VDD VDD VSS VSS gf180mcu_fd_sc_mcu7t5v0__dffq_1
XTAP_TAPCELL_ROW_25_607 VDD VSS gf180mcu_fd_sc_mcu7t5v0__filltie
XFILLER_54_247 VDD VDD VSS VSS gf180mcu_fd_sc_mcu7t5v0__fill_2
X_6845_ _6845_/D _7279_/CLK _6845_/Q VDD VDD VSS VSS gf180mcu_fd_sc_mcu7t5v0__dffq_1
X_3988_ _6749_/Q _4406_/A2 _3989_/B VDD VDD VSS VSS gf180mcu_fd_sc_mcu7t5v0__nand2_1
XFILLER_10_317 VDD VDD VSS VSS gf180mcu_fd_sc_mcu7t5v0__fill_2
XFILLER_51_976 VDD VDD VSS VSS gf180mcu_fd_sc_mcu7t5v0__fillcap_4
X_6776_ _6776_/D _7250_/CLK _6776_/Q VDD VDD VSS VSS gf180mcu_fd_sc_mcu7t5v0__dffq_1
X_5727_ _6324_/A1 _7676_/Q _6333_/A1 _7682_/Q _5728_/C VDD VDD VSS VSS gf180mcu_fd_sc_mcu7t5v0__oai22_1
X_5658_ input31/Z _5661_/S _5659_/B VDD VDD VSS VSS gf180mcu_fd_sc_mcu7t5v0__nand2_1
XFILLER_117_772 VDD VDD VSS VSS gf180mcu_fd_sc_mcu7t5v0__fillcap_64
XFILLER_117_761 VDD VDD VSS VSS gf180mcu_fd_sc_mcu7t5v0__fillcap_8
X_4609_ _7019_/Q _4616_/A2 _4610_/B VDD VDD VSS VSS gf180mcu_fd_sc_mcu7t5v0__nand2_1
X_5589_ _7514_/Q _6733_/A4 _5619_/A1 VDD VDD VSS VSS gf180mcu_fd_sc_mcu7t5v0__nand2_1
X_7328_ _7328_/D _7418_/CLK _7328_/Q VDD VDD VSS VSS gf180mcu_fd_sc_mcu7t5v0__dffq_1
XFILLER_2_527 VDD VDD VSS VSS gf180mcu_fd_sc_mcu7t5v0__fillcap_64
X_7259_ _7259_/D _7259_/CLK _7259_/Q VDD VDD VSS VSS gf180mcu_fd_sc_mcu7t5v0__dffq_1
XTAP_TAPCELL_ROW_5_332 VDD VSS gf180mcu_fd_sc_mcu7t5v0__filltie
XFILLER_18_439 VDD VDD VSS VSS gf180mcu_fd_sc_mcu7t5v0__fill_1
XFILLER_45_214 VDD VDD VSS VSS gf180mcu_fd_sc_mcu7t5v0__fill_1
XFILLER_46_737 VDD VDD VSS VSS gf180mcu_fd_sc_mcu7t5v0__fillcap_4
XFILLER_73_578 VDD VDD VSS VSS gf180mcu_fd_sc_mcu7t5v0__fill_1
XTAP_TAPCELL_ROW_103_1705 VDD VSS gf180mcu_fd_sc_mcu7t5v0__filltie
XFILLER_14_667 VDD VDD VSS VSS gf180mcu_fd_sc_mcu7t5v0__fillcap_64
XTAP_TAPCELL_ROW_52_982 VDD VSS gf180mcu_fd_sc_mcu7t5v0__filltie
XTAP_TAPCELL_ROW_52_993 VDD VSS gf180mcu_fd_sc_mcu7t5v0__filltie
XFILLER_108_772 VDD VDD VSS VSS gf180mcu_fd_sc_mcu7t5v0__fillcap_8
XFILLER_6_877 VDD VDD VSS VSS gf180mcu_fd_sc_mcu7t5v0__fillcap_64
XTAP_TAPCELL_ROW_114_1856 VDD VSS gf180mcu_fd_sc_mcu7t5v0__filltie
XFILLER_68_317 VDD VDD VSS VSS gf180mcu_fd_sc_mcu7t5v0__fill_1
X_4960_ _4988_/A1 _4966_/A2 _4960_/B _7194_/D VDD VDD VSS VSS gf180mcu_fd_sc_mcu7t5v0__oai21_1
XFILLER_64_589 VDD VDD VSS VSS gf180mcu_fd_sc_mcu7t5v0__fill_1
X_3911_ _6257_/A1 _7586_/Q _3911_/Z VDD VDD VSS VSS gf180mcu_fd_sc_mcu7t5v0__xor2_1
X_4891_ _7160_/Q _4896_/A2 _4892_/B VDD VDD VSS VSS gf180mcu_fd_sc_mcu7t5v0__nand2_1
X_3842_ _3819_/Z _3840_/Z _3841_/Z _3842_/Z VDD VDD VSS VSS gf180mcu_fd_sc_mcu7t5v0__xor3_1
XFILLER_33_976 VDD VDD VSS VSS gf180mcu_fd_sc_mcu7t5v0__fillcap_4
X_6630_ _7726_/Q _6633_/A1 _6630_/B _7726_/D VDD VDD VSS VSS gf180mcu_fd_sc_mcu7t5v0__oai21_1
XFILLER_60_784 VDD VDD VSS VSS gf180mcu_fd_sc_mcu7t5v0__fill_2
X_6561_ _6566_/S _6717_/A1 _6561_/B _7696_/D VDD VDD VSS VSS gf180mcu_fd_sc_mcu7t5v0__aoi21_1
XFILLER_60_795 VDD VDD VSS VSS gf180mcu_fd_sc_mcu7t5v0__fill_1
X_5512_ _5508_/C _5512_/A2 _5512_/A3 _5519_/A3 VDD VDD VSS VSS gf180mcu_fd_sc_mcu7t5v0__nor3_1
X_3773_ _7566_/Q _7557_/Q _7810_/D VDD VDD VSS VSS gf180mcu_fd_sc_mcu7t5v0__and2_1
X_6492_ _7672_/Q _7673_/Q _7791_/Q _6492_/Z VDD VDD VSS VSS gf180mcu_fd_sc_mcu7t5v0__and3_1
XTAP_TAPCELL_ROW_30_676 VDD VSS gf180mcu_fd_sc_mcu7t5v0__filltie
XTAP_TAPCELL_ROW_76_1328 VDD VSS gf180mcu_fd_sc_mcu7t5v0__filltie
XTAP_TAPCELL_ROW_76_1317 VDD VSS gf180mcu_fd_sc_mcu7t5v0__filltie
X_5443_ _5443_/A1 _5443_/A2 _5458_/A2 VDD VDD VSS VSS gf180mcu_fd_sc_mcu7t5v0__nor2_1
X_5374_ _7303_/Q _5515_/A2 _5559_/B1 _7310_/Q _7317_/Q _5610_/B1 _5375_/A2 VDD VDD
+ VSS VSS gf180mcu_fd_sc_mcu7t5v0__oai222_1
XFILLER_114_742 VDD VDD VSS VSS gf180mcu_fd_sc_mcu7t5v0__fillcap_4
X_4325_ _6877_/Q _4336_/A2 _4326_/B VDD VDD VSS VSS gf180mcu_fd_sc_mcu7t5v0__nand2_1
X_7113_ _7113_/D _7217_/CLK _7113_/Q VDD VDD VSS VSS gf180mcu_fd_sc_mcu7t5v0__dffq_1
XFILLER_114_797 VDD VDD VSS VSS gf180mcu_fd_sc_mcu7t5v0__fillcap_8
X_7044_ _7044_/D _7055_/CLK _7044_/Q VDD VDD VSS VSS gf180mcu_fd_sc_mcu7t5v0__dffq_1
X_4256_ _5012_/A1 _4266_/A2 _4256_/B _6842_/D VDD VDD VSS VSS gf180mcu_fd_sc_mcu7t5v0__oai21_1
X_4187_ _6651_/A1 _4189_/A2 _5204_/S VDD VDD VSS VSS gf180mcu_fd_sc_mcu7t5v0__nand2_1
XFILLER_110_981 VDD VDD VSS VSS gf180mcu_fd_sc_mcu7t5v0__fill_1
XFILLER_28_737 VDD VDD VSS VSS gf180mcu_fd_sc_mcu7t5v0__fillcap_64
XFILLER_43_707 VDD VDD VSS VSS gf180mcu_fd_sc_mcu7t5v0__fillcap_32
XTAP_TAPCELL_ROW_87_1479 VDD VSS gf180mcu_fd_sc_mcu7t5v0__filltie
XTAP_TAPCELL_ROW_38_787 VDD VSS gf180mcu_fd_sc_mcu7t5v0__filltie
XFILLER_42_228 VDD VDD VSS VSS gf180mcu_fd_sc_mcu7t5v0__fill_1
X_7877_ _7877_/I _7877_/Z VDD VDD VSS VSS gf180mcu_fd_sc_mcu7t5v0__buf_1
X_6828_ _6828_/D _7490_/CLK _6828_/Q VDD VDD VSS VSS gf180mcu_fd_sc_mcu7t5v0__dffq_1
XFILLER_11_626 VDD VDD VSS VSS gf180mcu_fd_sc_mcu7t5v0__fillcap_4
XFILLER_51_795 VDD VDD VSS VSS gf180mcu_fd_sc_mcu7t5v0__fillcap_16
X_6759_ _6759_/D _7002_/CLK _6759_/Q VDD VDD VSS VSS gf180mcu_fd_sc_mcu7t5v0__dffq_1
Xwire517 wire517/I wire517/Z VDD VDD VSS VSS gf180mcu_fd_sc_mcu7t5v0__clkbuf_4
XFILLER_2_313 VDD VDD VSS VSS gf180mcu_fd_sc_mcu7t5v0__fill_2
XFILLER_3_836 VDD VDD VSS VSS gf180mcu_fd_sc_mcu7t5v0__fillcap_4
XFILLER_18_214 VDD VDD VSS VSS gf180mcu_fd_sc_mcu7t5v0__fill_1
XFILLER_18_247 VDD VDD VSS VSS gf180mcu_fd_sc_mcu7t5v0__fill_2
XFILLER_46_545 VDD VDD VSS VSS gf180mcu_fd_sc_mcu7t5v0__fill_1
XFILLER_15_976 VDD VDD VSS VSS gf180mcu_fd_sc_mcu7t5v0__fillcap_4
XFILLER_30_979 VDD VDD VSS VSS gf180mcu_fd_sc_mcu7t5v0__fill_2
XTAP_TAPCELL_ROW_58_1069 VDD VSS gf180mcu_fd_sc_mcu7t5v0__filltie
XFILLER_69_626 VDD VDD VSS VSS gf180mcu_fd_sc_mcu7t5v0__fillcap_4
XFILLER_111_745 VDD VDD VSS VSS gf180mcu_fd_sc_mcu7t5v0__fill_2
X_5090_ wire231/Z _5092_/A2 _5090_/B _7259_/D VDD VDD VSS VSS gf180mcu_fd_sc_mcu7t5v0__oai21_1
X_4110_ _4110_/A1 _4110_/A2 _4952_/A2 VDD VDD VSS VSS gf180mcu_fd_sc_mcu7t5v0__nand2_1
XTAP_TAPCELL_ROW_71_1247 VDD VSS gf180mcu_fd_sc_mcu7t5v0__filltie
XTAP_TAPCELL_ROW_71_1258 VDD VSS gf180mcu_fd_sc_mcu7t5v0__filltie
X_4041_ _4123_/A1 _4053_/A2 _4644_/A2 VDD VDD VSS VSS gf180mcu_fd_sc_mcu7t5v0__nand2_1
XFILLER_65_810 VDD VDD VSS VSS gf180mcu_fd_sc_mcu7t5v0__fill_1
XFILLER_37_545 VDD VDD VSS VSS gf180mcu_fd_sc_mcu7t5v0__fillcap_8
X_7800_ _7800_/D _7800_/RN _7802_/CLK _7800_/Q VDD VDD VSS VSS gf180mcu_fd_sc_mcu7t5v0__dffrnq_1
X_5992_ _7229_/Q _6104_/B1 _6171_/A2 _7236_/Q _7243_/Q _6235_/B1 _5993_/B2 VDD VDD
+ VSS VSS gf180mcu_fd_sc_mcu7t5v0__oai222_1
XFILLER_65_887 VDD VDD VSS VSS gf180mcu_fd_sc_mcu7t5v0__fill_2
XTAP_TAPCELL_ROW_35_746 VDD VSS gf180mcu_fd_sc_mcu7t5v0__filltie
X_7731_ _7731_/D _7791_/RN _7734_/CLK _7731_/Q VDD VDD VSS VSS gf180mcu_fd_sc_mcu7t5v0__dffrnq_1
X_4943_ _7186_/Q _4952_/A2 _4944_/B VDD VDD VSS VSS gf180mcu_fd_sc_mcu7t5v0__nand2_1
X_7662_ _7662_/D _7664_/RN _7670_/CLK _7662_/Q VDD VDD VSS VSS gf180mcu_fd_sc_mcu7t5v0__dffrnq_1
XTAP_TAPCELL_ROW_15_470 VDD VSS gf180mcu_fd_sc_mcu7t5v0__filltie
X_4874_ _5098_/A1 _4882_/A2 _4874_/B _7151_/D VDD VDD VSS VSS gf180mcu_fd_sc_mcu7t5v0__oai21_1
X_6613_ _6616_/A2 _6613_/A2 _7720_/D VDD VDD VSS VSS gf180mcu_fd_sc_mcu7t5v0__nor2_1
X_3825_ _7582_/Q _3819_/Z _3824_/Z _3825_/Z VDD VDD VSS VSS gf180mcu_fd_sc_mcu7t5v0__xor3_1
X_7593_ _7593_/D _7660_/RN _7671_/CLK _7593_/Q VDD VDD VSS VSS gf180mcu_fd_sc_mcu7t5v0__dffrnq_1
X_6544_ _6559_/A1 _6544_/A2 _6543_/Z _7690_/D VDD VDD VSS VSS gf180mcu_fd_sc_mcu7t5v0__nor3_1
X_3756_ _7802_/D _3754_/B _3756_/B1 _7801_/D _3757_/I VDD VDD VSS VSS gf180mcu_fd_sc_mcu7t5v0__oai22_1
X_6475_ _7670_/Q _7536_/Q _6478_/B VDD VDD VSS VSS gf180mcu_fd_sc_mcu7t5v0__nor2_1
X_3687_ _3677_/S input68/Z _3385_/I _3687_/B1 input67/Z _3690_/A2 VDD VDD VSS VSS
+ gf180mcu_fd_sc_mcu7t5v0__oai32_1
X_5426_ _5426_/A1 _5426_/A2 _5430_/B1 VDD VDD VSS VSS gf180mcu_fd_sc_mcu7t5v0__nor2_1
XFILLER_88_902 VDD VDD VSS VSS gf180mcu_fd_sc_mcu7t5v0__fillcap_4
X_5357_ _7644_/Q _7504_/Q _5358_/S _7504_/D VDD VDD VSS VSS gf180mcu_fd_sc_mcu7t5v0__mux2_2
X_4308_ _4336_/A1 _4308_/A2 _4308_/B _6868_/D VDD VDD VSS VSS gf180mcu_fd_sc_mcu7t5v0__oai21_1
X_5288_ _5309_/I0 _7435_/Q _5288_/S _7435_/D VDD VDD VSS VSS gf180mcu_fd_sc_mcu7t5v0__mux2_2
X_7027_ _7027_/D _7062_/CLK _7027_/Q VDD VDD VSS VSS gf180mcu_fd_sc_mcu7t5v0__dffq_1
XFILLER_88_979 VDD VDD VSS VSS gf180mcu_fd_sc_mcu7t5v0__fill_2
XTAP_TAPCELL_ROW_89_1508 VDD VSS gf180mcu_fd_sc_mcu7t5v0__filltie
XFILLER_87_467 VDD VDD VSS VSS gf180mcu_fd_sc_mcu7t5v0__fill_1
X_4239_ _6834_/Q _4252_/A2 _4240_/B VDD VDD VSS VSS gf180mcu_fd_sc_mcu7t5v0__nand2_1
XFILLER_56_832 VDD VDD VSS VSS gf180mcu_fd_sc_mcu7t5v0__fill_2
XFILLER_70_312 VDD VDD VSS VSS gf180mcu_fd_sc_mcu7t5v0__fill_2
XFILLER_43_559 VDD VDD VSS VSS gf180mcu_fd_sc_mcu7t5v0__fill_1
XFILLER_12_979 VDD VDD VSS VSS gf180mcu_fd_sc_mcu7t5v0__fill_2
XFILLER_11_489 VDD VDD VSS VSS gf180mcu_fd_sc_mcu7t5v0__fill_1
XTAP_TAPCELL_ROW_111_1815 VDD VSS gf180mcu_fd_sc_mcu7t5v0__filltie
XFILLER_47_832 VDD VDD VSS VSS gf180mcu_fd_sc_mcu7t5v0__fill_1
XFILLER_65_139 VDD VDD VSS VSS gf180mcu_fd_sc_mcu7t5v0__fill_1
XTAP_TAPCELL_ROW_109_1788 VDD VSS gf180mcu_fd_sc_mcu7t5v0__filltie
XPHY_EDGE_ROW_14_Left_133 VDD VSS gf180mcu_fd_sc_mcu7t5v0__endcap
XTAP_TAPCELL_ROW_32_705 VDD VSS gf180mcu_fd_sc_mcu7t5v0__filltie
XPHY_EDGE_ROW_104_Right_104 VDD VSS gf180mcu_fd_sc_mcu7t5v0__endcap
X_4590_ _5094_/A1 _4602_/A2 _4590_/B _7009_/D VDD VDD VSS VSS gf180mcu_fd_sc_mcu7t5v0__oai21_1
X_3610_ input84/Z input83/Z _3610_/Z VDD VDD VSS VSS gf180mcu_fd_sc_mcu7t5v0__xor2_1
XFILLER_116_804 VDD VDD VSS VSS gf180mcu_fd_sc_mcu7t5v0__fill_1
X_3541_ _7879_/I _7880_/I _3541_/Z VDD VDD VSS VSS gf180mcu_fd_sc_mcu7t5v0__xor2_1
X_6260_ _7626_/Q _6262_/A2 _6268_/B1 _7707_/Q _6261_/B2 VDD VDD VSS VSS gf180mcu_fd_sc_mcu7t5v0__aoi22_1
X_3472_ _7822_/D _3850_/A2 VDD VDD VSS VSS gf180mcu_fd_sc_mcu7t5v0__clkinv_1
XPHY_EDGE_ROW_23_Left_142 VDD VSS gf180mcu_fd_sc_mcu7t5v0__endcap
X_6191_ _6749_/Q _6211_/B1 _6191_/B _6193_/A1 VDD VDD VSS VSS gf180mcu_fd_sc_mcu7t5v0__oai21_1
X_5211_ _5239_/I0 _7358_/Q _5211_/S _7358_/D VDD VDD VSS VSS gf180mcu_fd_sc_mcu7t5v0__mux2_2
XFILLER_97_721 VDD VDD VSS VSS gf180mcu_fd_sc_mcu7t5v0__fill_1
X_5142_ _5345_/I0 _7289_/Q _5148_/S _7289_/D VDD VDD VSS VSS gf180mcu_fd_sc_mcu7t5v0__mux2_2
XFILLER_85_949 VDD VDD VSS VSS gf180mcu_fd_sc_mcu7t5v0__fillcap_16
X_5073_ _7251_/Q _5074_/A2 _5074_/B VDD VDD VSS VSS gf180mcu_fd_sc_mcu7t5v0__nor2_1
X_4024_ _4141_/A2 _4027_/A2 _4574_/A2 VDD VDD VSS VSS gf180mcu_fd_sc_mcu7t5v0__nand2_1
XPHY_EDGE_ROW_32_Left_151 VDD VSS gf180mcu_fd_sc_mcu7t5v0__endcap
XTAP_TAPCELL_ROW_84_1438 VDD VSS gf180mcu_fd_sc_mcu7t5v0__filltie
XFILLER_52_312 VDD VDD VSS VSS gf180mcu_fd_sc_mcu7t5v0__fill_2
X_5975_ _7187_/Q _6132_/A2 _6177_/B1 _7180_/Q _7166_/Q _6177_/C2 _5976_/A2 VDD VDD
+ VSS VSS gf180mcu_fd_sc_mcu7t5v0__oai222_1
X_4926_ _4940_/A1 _4938_/A2 _4926_/B _7177_/D VDD VDD VSS VSS gf180mcu_fd_sc_mcu7t5v0__oai21_1
X_7714_ _7714_/D wire593/Z _7755_/CLK _7714_/Q VDD VDD VSS VSS gf180mcu_fd_sc_mcu7t5v0__dffrnq_1
X_4857_ _7143_/Q _4868_/A2 _4858_/B VDD VDD VSS VSS gf180mcu_fd_sc_mcu7t5v0__nand2_1
X_7645_ _7645_/D _7782_/RN _7804_/CLK _7645_/Q VDD VDD VSS VSS gf180mcu_fd_sc_mcu7t5v0__dffrnq_1
X_7576_ _7576_/D _7589_/RN _7613_/CLK _7576_/Q VDD VDD VSS VSS gf180mcu_fd_sc_mcu7t5v0__dffrnq_1
X_3808_ _7778_/Q _3518_/B _3812_/A1 _3808_/B2 _3809_/I VDD VDD VSS VSS gf180mcu_fd_sc_mcu7t5v0__aoi22_1
X_4788_ wire268/Z _4798_/A2 _4788_/B _7108_/D VDD VDD VSS VSS gf180mcu_fd_sc_mcu7t5v0__oai21_1
X_6527_ _6538_/A1 _6525_/Z _6526_/Z _7684_/D VDD VDD VSS VSS gf180mcu_fd_sc_mcu7t5v0__nor3_1
XPHY_EDGE_ROW_41_Left_160 VDD VSS gf180mcu_fd_sc_mcu7t5v0__endcap
X_3739_ _7551_/Q _3739_/A2 _3760_/A3 VDD VDD VSS VSS gf180mcu_fd_sc_mcu7t5v0__nor2_1
X_6458_ _6462_/B _6458_/A2 _6458_/B _7667_/D VDD VDD VSS VSS gf180mcu_fd_sc_mcu7t5v0__oai21_1
XTAP_TAPCELL_ROW_95_1589 VDD VSS gf180mcu_fd_sc_mcu7t5v0__filltie
X_6389_ _7657_/Q _7523_/Q _6394_/A2 _6391_/A2 VDD VDD VSS VSS gf180mcu_fd_sc_mcu7t5v0__xnor3_1
XFILLER_79_209 VDD VDD VSS VSS gf180mcu_fd_sc_mcu7t5v0__fill_1
X_5409_ _7332_/Q _5607_/B1 _5511_/C2 _7339_/Q _7353_/Q wire428/Z _5410_/A3 VDD VDD
+ VSS VSS gf180mcu_fd_sc_mcu7t5v0__oai222_1
XFILLER_0_614 VDD VDD VSS VSS gf180mcu_fd_sc_mcu7t5v0__fillcap_32
XFILLER_71_698 VDD VDD VSS VSS gf180mcu_fd_sc_mcu7t5v0__fill_2
XFILLER_7_279 VDD VDD VSS VSS gf180mcu_fd_sc_mcu7t5v0__fill_1
XFILLER_112_317 VDD VDD VSS VSS gf180mcu_fd_sc_mcu7t5v0__fill_1
XTAP_TAPCELL_ROW_55_1028 VDD VSS gf180mcu_fd_sc_mcu7t5v0__filltie
XFILLER_105_380 VDD VDD VSS VSS gf180mcu_fd_sc_mcu7t5v0__fill_1
XFILLER_78_242 VDD VDD VSS VSS gf180mcu_fd_sc_mcu7t5v0__fill_2
XFILLER_79_787 VDD VDD VSS VSS gf180mcu_fd_sc_mcu7t5v0__fill_2
XFILLER_62_676 VDD VDD VSS VSS gf180mcu_fd_sc_mcu7t5v0__fill_2
X_5760_ _7037_/Q _6151_/A2 wire313/Z _7044_/Q _7058_/Q _6151_/C2 _5761_/A2 VDD VDD
+ VSS VSS gf180mcu_fd_sc_mcu7t5v0__oai222_1
XTAP_TAPCELL_ROW_45_885 VDD VSS gf180mcu_fd_sc_mcu7t5v0__filltie
XTAP_TAPCELL_ROW_66_1179 VDD VSS gf180mcu_fd_sc_mcu7t5v0__filltie
X_4711_ _7070_/Q _4714_/A2 _4712_/B VDD VDD VSS VSS gf180mcu_fd_sc_mcu7t5v0__nand2_1
X_5691_ _5691_/I _5692_/A2 VDD VDD VSS VSS gf180mcu_fd_sc_mcu7t5v0__clkinv_1
X_4642_ _4964_/A1 _4644_/A2 _4642_/B _7035_/D VDD VDD VSS VSS gf180mcu_fd_sc_mcu7t5v0__oai21_1
X_7430_ _7430_/D _7451_/CLK _7430_/Q VDD VDD VSS VSS gf180mcu_fd_sc_mcu7t5v0__dffq_1
X_4573_ _7001_/Q _4574_/A2 _4574_/B VDD VDD VSS VSS gf180mcu_fd_sc_mcu7t5v0__nand2_1
X_7361_ _7361_/D _7483_/CLK _7361_/Q VDD VDD VSS VSS gf180mcu_fd_sc_mcu7t5v0__dffq_1
X_6312_ _6312_/A1 _6303_/S _6312_/B _7612_/D VDD VDD VSS VSS gf180mcu_fd_sc_mcu7t5v0__oai21_1
X_3524_ _7773_/Q _7778_/Q _3525_/A2 VDD VDD VSS VSS gf180mcu_fd_sc_mcu7t5v0__nor2_1
X_7292_ _7292_/D _7492_/CLK _7292_/Q VDD VDD VSS VSS gf180mcu_fd_sc_mcu7t5v0__dffq_1
X_3455_ _7602_/Q _6300_/A1 VDD VDD VSS VSS gf180mcu_fd_sc_mcu7t5v0__clkinv_1
XFILLER_104_807 VDD VDD VSS VSS gf180mcu_fd_sc_mcu7t5v0__fillcap_16
X_6243_ _6243_/A1 _6243_/A2 _6243_/B _6244_/B1 VDD VDD VSS VSS gf180mcu_fd_sc_mcu7t5v0__oai21_1
X_3386_ _3386_/I _3688_/A2 VDD VDD VSS VSS gf180mcu_fd_sc_mcu7t5v0__clkinv_1
X_6174_ _7211_/Q _6174_/A2 _6174_/B _6176_/A1 VDD VDD VSS VSS gf180mcu_fd_sc_mcu7t5v0__oai21_1
X_5125_ _7277_/Q _5134_/A2 _5126_/B VDD VDD VSS VSS gf180mcu_fd_sc_mcu7t5v0__nand2_1
XFILLER_58_938 VDD VDD VSS VSS gf180mcu_fd_sc_mcu7t5v0__fillcap_4
XFILLER_85_757 VDD VDD VSS VSS gf180mcu_fd_sc_mcu7t5v0__fillcap_4
XFILLER_73_908 VDD VDD VSS VSS gf180mcu_fd_sc_mcu7t5v0__fill_2
X_5056_ _5056_/A1 _5064_/A2 _5056_/B _7242_/D VDD VDD VSS VSS gf180mcu_fd_sc_mcu7t5v0__oai21_1
X_4007_ _6755_/Q _4490_/A2 _4008_/B VDD VDD VSS VSS gf180mcu_fd_sc_mcu7t5v0__nand2_1
XFILLER_81_941 VDD VDD VSS VSS gf180mcu_fd_sc_mcu7t5v0__fillcap_32
XFILLER_65_492 VDD VDD VSS VSS gf180mcu_fd_sc_mcu7t5v0__fill_2
X_5958_ _5958_/A1 _5958_/A2 _5958_/B1 _5958_/B2 _7716_/Q _5998_/B VDD VDD VSS VSS
+ gf180mcu_fd_sc_mcu7t5v0__oai221_1
XFILLER_52_164 VDD VDD VSS VSS gf180mcu_fd_sc_mcu7t5v0__fill_2
XFILLER_53_698 VDD VDD VSS VSS gf180mcu_fd_sc_mcu7t5v0__fill_2
X_4909_ _7169_/Q _4910_/A2 _4910_/B VDD VDD VSS VSS gf180mcu_fd_sc_mcu7t5v0__nand2_1
X_5889_ _5889_/A1 _5889_/A2 _5934_/A1 VDD VDD VSS VSS gf180mcu_fd_sc_mcu7t5v0__nor2_1
XFILLER_21_562 VDD VDD VSS VSS gf180mcu_fd_sc_mcu7t5v0__fillcap_64
XTAP_TAPCELL_ROW_23_579 VDD VSS gf180mcu_fd_sc_mcu7t5v0__filltie
XTAP_TAPCELL_ROW_97_1618 VDD VSS gf180mcu_fd_sc_mcu7t5v0__filltie
X_7628_ _7628_/D _7709_/RN _7711_/CLK _7628_/Q VDD VDD VSS VSS gf180mcu_fd_sc_mcu7t5v0__dffrnq_1
X_7559_ _7559_/D _7652_/RN _7794_/CLK _7559_/Q VDD VDD VSS VSS gf180mcu_fd_sc_mcu7t5v0__dffrnq_1
XFILLER_1_912 VDD VDD VSS VSS gf180mcu_fd_sc_mcu7t5v0__fillcap_64
XFILLER_0_444 VDD VDD VSS VSS gf180mcu_fd_sc_mcu7t5v0__fill_2
XFILLER_49_905 VDD VDD VSS VSS gf180mcu_fd_sc_mcu7t5v0__fillcap_4
XFILLER_88_573 VDD VDD VSS VSS gf180mcu_fd_sc_mcu7t5v0__fill_2
XFILLER_0_499 VDD VDD VSS VSS gf180mcu_fd_sc_mcu7t5v0__fillcap_8
XFILLER_75_278 VDD VDD VSS VSS gf180mcu_fd_sc_mcu7t5v0__fill_2
XTAP_TAPCELL_ROW_106_1736 VDD VSS gf180mcu_fd_sc_mcu7t5v0__filltie
XFILLER_72_941 VDD VDD VSS VSS gf180mcu_fd_sc_mcu7t5v0__fillcap_4
XTAP_TAPCELL_ROW_106_1747 VDD VSS gf180mcu_fd_sc_mcu7t5v0__filltie
XTAP_TAPCELL_ROW_42_844 VDD VSS gf180mcu_fd_sc_mcu7t5v0__filltie
XFILLER_40_871 VDD VDD VSS VSS gf180mcu_fd_sc_mcu7t5v0__fillcap_4
XANTENNA_5 _7581_/D VDD VDD VSS VSS gf180mcu_fd_sc_mcu7t5v0__antenna
XTAP_TAPCELL_ROW_117_1898 VDD VSS gf180mcu_fd_sc_mcu7t5v0__filltie
XFILLER_3_282 VDD VDD VSS VSS gf180mcu_fd_sc_mcu7t5v0__fill_1
XTAP_TAPCELL_ROW_68_1208 VDD VSS gf180mcu_fd_sc_mcu7t5v0__filltie
X_6930_ _6930_/D _6944_/CLK _6930_/Q VDD VDD VSS VSS gf180mcu_fd_sc_mcu7t5v0__dffq_1
XFILLER_35_632 VDD VDD VSS VSS gf180mcu_fd_sc_mcu7t5v0__fillcap_64
XFILLER_63_941 VDD VDD VSS VSS gf180mcu_fd_sc_mcu7t5v0__fillcap_32
XFILLER_81_248 VDD VDD VSS VSS gf180mcu_fd_sc_mcu7t5v0__fill_1
X_6861_ _6861_/D _6882_/CLK _6861_/Q VDD VDD VSS VSS gf180mcu_fd_sc_mcu7t5v0__dffq_1
X_6792_ _6792_/D _7253_/CLK _6792_/Q VDD VDD VSS VSS gf180mcu_fd_sc_mcu7t5v0__dffq_1
X_5812_ _5813_/A1 _5813_/A2 _6283_/B1 VDD VDD VSS VSS gf180mcu_fd_sc_mcu7t5v0__nor2_1
X_5743_ _7884_/I _3702_/Z _6303_/S _7570_/D VDD VDD VSS VSS gf180mcu_fd_sc_mcu7t5v0__mux2_2
XTAP_TAPCELL_ROW_20_538 VDD VSS gf180mcu_fd_sc_mcu7t5v0__filltie
X_5674_ _7551_/Q input37/Z _5675_/S _7551_/D VDD VDD VSS VSS gf180mcu_fd_sc_mcu7t5v0__mux2_2
X_4625_ _7027_/Q _4630_/A2 _4626_/B VDD VDD VSS VSS gf180mcu_fd_sc_mcu7t5v0__nand2_1
XTAP_TAPCELL_ROW_79_1359 VDD VSS gf180mcu_fd_sc_mcu7t5v0__filltie
X_7413_ _7413_/D _7456_/CLK _7413_/Q VDD VDD VSS VSS gf180mcu_fd_sc_mcu7t5v0__dffq_1
X_4556_ _4822_/A1 _4560_/A2 _4556_/B _6992_/D VDD VDD VSS VSS gf180mcu_fd_sc_mcu7t5v0__oai21_1
X_7344_ _7344_/D _7804_/CLK _7344_/Q VDD VDD VSS VSS gf180mcu_fd_sc_mcu7t5v0__dffq_1
XFILLER_117_976 VDD VDD VSS VSS gf180mcu_fd_sc_mcu7t5v0__fillcap_4
X_3507_ _7801_/D _6488_/A2 VDD VDD VSS VSS gf180mcu_fd_sc_mcu7t5v0__clkinv_1
X_4487_ _6958_/Q _4490_/A2 _4488_/B VDD VDD VSS VSS gf180mcu_fd_sc_mcu7t5v0__nand2_1
XFILLER_116_486 VDD VDD VSS VSS gf180mcu_fd_sc_mcu7t5v0__fill_1
XTAP_TAPCELL_ROW_92_1548 VDD VSS gf180mcu_fd_sc_mcu7t5v0__filltie
X_7275_ _7275_/D _7279_/CLK _7275_/Q VDD VDD VSS VSS gf180mcu_fd_sc_mcu7t5v0__dffq_1
X_6226_ _6226_/I _6227_/B VDD VDD VSS VSS gf180mcu_fd_sc_mcu7t5v0__clkinv_1
X_3438_ _7583_/Q _6261_/A1 VDD VDD VSS VSS gf180mcu_fd_sc_mcu7t5v0__clkinv_1
XFILLER_98_871 VDD VDD VSS VSS gf180mcu_fd_sc_mcu7t5v0__fillcap_4
X_3369_ _7722_/Q _6617_/A1 VDD VDD VSS VSS gf180mcu_fd_sc_mcu7t5v0__clkinv_1
X_6157_ _6217_/B _6157_/A2 _6157_/B _6185_/A2 VDD VDD VSS VSS gf180mcu_fd_sc_mcu7t5v0__oai21_1
XFILLER_100_832 VDD VDD VSS VSS gf180mcu_fd_sc_mcu7t5v0__fill_1
X_5108_ _5122_/A1 _5120_/A2 _5108_/B _7268_/D VDD VDD VSS VSS gf180mcu_fd_sc_mcu7t5v0__oai21_1
X_6088_ _6088_/A1 _6088_/A2 _6088_/B _6095_/A2 VDD VDD VSS VSS gf180mcu_fd_sc_mcu7t5v0__oai21_1
X_5039_ _7234_/Q _5050_/A2 _5040_/B VDD VDD VSS VSS gf180mcu_fd_sc_mcu7t5v0__nand2_1
XFILLER_54_941 VDD VDD VSS VSS gf180mcu_fd_sc_mcu7t5v0__fillcap_4
XTAP_TAPCELL_ROW_0_241 VDD VSS gf180mcu_fd_sc_mcu7t5v0__filltie
XTAP_TAPCELL_ROW_0_252 VDD VSS gf180mcu_fd_sc_mcu7t5v0__filltie
XTAP_TAPCELL_ROW_0_263 VDD VSS gf180mcu_fd_sc_mcu7t5v0__filltie
XTAP_TAPCELL_ROW_28_649 VDD VSS gf180mcu_fd_sc_mcu7t5v0__filltie
XTAP_TAPCELL_ROW_101_1666 VDD VSS gf180mcu_fd_sc_mcu7t5v0__filltie
XFILLER_22_871 VDD VDD VSS VSS gf180mcu_fd_sc_mcu7t5v0__fillcap_4
XTAP_TAPCELL_ROW_101_1677 VDD VSS gf180mcu_fd_sc_mcu7t5v0__filltie
XFILLER_5_503 VDD VDD VSS VSS gf180mcu_fd_sc_mcu7t5v0__fill_2
XFILLER_31_86 VDD VDD VSS VSS gf180mcu_fd_sc_mcu7t5v0__fill_2
XFILLER_107_475 VDD VDD VSS VSS gf180mcu_fd_sc_mcu7t5v0__fill_2
XTAP_TAPCELL_ROW_8_374 VDD VSS gf180mcu_fd_sc_mcu7t5v0__filltie
XFILLER_49_702 VDD VDD VSS VSS gf180mcu_fd_sc_mcu7t5v0__fill_2
XTAP_TAPCELL_ROW_47_914 VDD VSS gf180mcu_fd_sc_mcu7t5v0__filltie
XFILLER_17_632 VDD VDD VSS VSS gf180mcu_fd_sc_mcu7t5v0__fillcap_64
XFILLER_29_492 VDD VDD VSS VSS gf180mcu_fd_sc_mcu7t5v0__fillcap_4
XTAP_TAPCELL_ROW_63_1138 VDD VSS gf180mcu_fd_sc_mcu7t5v0__filltie
XFILLER_9_842 VDD VDD VSS VSS gf180mcu_fd_sc_mcu7t5v0__fillcap_64
X_4410_ _4550_/A1 _4420_/A2 _4410_/B _6919_/D VDD VDD VSS VSS gf180mcu_fd_sc_mcu7t5v0__oai21_1
X_5390_ _7352_/Q _6632_/A1 _5594_/B1 _7338_/Q _5391_/A3 VDD VDD VSS VSS gf180mcu_fd_sc_mcu7t5v0__oai22_1
X_4341_ _6885_/Q _4350_/A2 _4342_/B VDD VDD VSS VSS gf180mcu_fd_sc_mcu7t5v0__nand2_1
XFILLER_114_979 VDD VDD VSS VSS gf180mcu_fd_sc_mcu7t5v0__fill_2
X_7060_ _7060_/D _7060_/CLK _7060_/Q VDD VDD VSS VSS gf180mcu_fd_sc_mcu7t5v0__dffq_1
XFILLER_87_808 VDD VDD VSS VSS gf180mcu_fd_sc_mcu7t5v0__fill_1
X_4272_ _5126_/A1 _4280_/A2 _4272_/B _6850_/D VDD VDD VSS VSS gf180mcu_fd_sc_mcu7t5v0__oai21_1
XTAP_TAPCELL_ROW_74_1289 VDD VSS gf180mcu_fd_sc_mcu7t5v0__filltie
XFILLER_4_591 VDD VDD VSS VSS gf180mcu_fd_sc_mcu7t5v0__fillcap_4
XFILLER_113_478 VDD VDD VSS VSS gf180mcu_fd_sc_mcu7t5v0__fill_2
X_6011_ _7223_/Q _6140_/B1 _6221_/B _6013_/A1 VDD VDD VSS VSS gf180mcu_fd_sc_mcu7t5v0__oai21_1
XFILLER_82_524 VDD VDD VSS VSS gf180mcu_fd_sc_mcu7t5v0__fill_1
XPHY_EDGE_ROW_6_Left_125 VDD VSS gf180mcu_fd_sc_mcu7t5v0__endcap
XFILLER_82_568 VDD VDD VSS VSS gf180mcu_fd_sc_mcu7t5v0__fillcap_8
X_6913_ _6913_/D _7254_/CLK _6913_/Q VDD VDD VSS VSS gf180mcu_fd_sc_mcu7t5v0__dffq_1
XFILLER_36_941 VDD VDD VSS VSS gf180mcu_fd_sc_mcu7t5v0__fillcap_4
XTAP_TAPCELL_ROW_25_608 VDD VSS gf180mcu_fd_sc_mcu7t5v0__filltie
XFILLER_63_760 VDD VDD VSS VSS gf180mcu_fd_sc_mcu7t5v0__fill_1
X_6844_ _6844_/D _7279_/CLK _6844_/Q VDD VDD VSS VSS gf180mcu_fd_sc_mcu7t5v0__dffq_1
X_6775_ _6775_/D _7118_/CLK _6775_/Q VDD VDD VSS VSS gf180mcu_fd_sc_mcu7t5v0__dffq_1
X_3987_ _4144_/A1 _4150_/A2 _4406_/A2 VDD VDD VSS VSS gf180mcu_fd_sc_mcu7t5v0__nand2_1
X_5726_ _6351_/A1 _7694_/Q _5726_/B _5731_/B VDD VDD VSS VSS gf180mcu_fd_sc_mcu7t5v0__oai21_1
XFILLER_109_707 VDD VDD VSS VSS gf180mcu_fd_sc_mcu7t5v0__fill_2
X_5657_ _7539_/Q input37/Z _5663_/S _7539_/D VDD VDD VSS VSS gf180mcu_fd_sc_mcu7t5v0__mux2_2
X_4608_ _4748_/A1 _4616_/A2 _4608_/B _7018_/D VDD VDD VSS VSS gf180mcu_fd_sc_mcu7t5v0__oai21_1
X_5588_ _5588_/A1 _5588_/A2 _7513_/D VDD VDD VSS VSS gf180mcu_fd_sc_mcu7t5v0__nand2_1
X_4539_ _6984_/Q _4546_/A2 _4540_/B VDD VDD VSS VSS gf180mcu_fd_sc_mcu7t5v0__nand2_1
X_7327_ _7327_/D _7492_/CLK _7327_/Q VDD VDD VSS VSS gf180mcu_fd_sc_mcu7t5v0__dffq_1
X_7258_ _7258_/D _7267_/CLK _7258_/Q VDD VDD VSS VSS gf180mcu_fd_sc_mcu7t5v0__dffq_1
X_6209_ _6209_/A1 _6209_/A2 _6210_/A3 VDD VDD VSS VSS gf180mcu_fd_sc_mcu7t5v0__nor2_1
XTAP_TAPCELL_ROW_5_322 VDD VSS gf180mcu_fd_sc_mcu7t5v0__filltie
XTAP_TAPCELL_ROW_5_333 VDD VSS gf180mcu_fd_sc_mcu7t5v0__filltie
X_7189_ _7189_/D _7189_/CLK _7189_/Q VDD VDD VSS VSS gf180mcu_fd_sc_mcu7t5v0__dffq_1
XFILLER_73_524 VDD VDD VSS VSS gf180mcu_fd_sc_mcu7t5v0__fill_1
XTAP_TAPCELL_ROW_103_1706 VDD VSS gf180mcu_fd_sc_mcu7t5v0__filltie
XFILLER_13_112 VDD VDD VSS VSS gf180mcu_fd_sc_mcu7t5v0__fill_2
XFILLER_41_487 VDD VDD VSS VSS gf180mcu_fd_sc_mcu7t5v0__fill_2
XTAP_TAPCELL_ROW_52_983 VDD VSS gf180mcu_fd_sc_mcu7t5v0__filltie
XFILLER_6_801 VDD VDD VSS VSS gf180mcu_fd_sc_mcu7t5v0__fillcap_4
XTAP_TAPCELL_ROW_114_1857 VDD VSS gf180mcu_fd_sc_mcu7t5v0__filltie
XPHY_EDGE_ROW_79_Left_198 VDD VSS gf180mcu_fd_sc_mcu7t5v0__endcap
XFILLER_77_863 VDD VDD VSS VSS gf180mcu_fd_sc_mcu7t5v0__fill_2
XFILLER_49_576 VDD VDD VSS VSS gf180mcu_fd_sc_mcu7t5v0__fill_1
XFILLER_18_941 VDD VDD VSS VSS gf180mcu_fd_sc_mcu7t5v0__fillcap_4
X_3910_ _7599_/Q _3905_/Z _3909_/Z _3910_/Z VDD VDD VSS VSS gf180mcu_fd_sc_mcu7t5v0__xor3_1
X_4890_ _4918_/A1 _4896_/A2 _4890_/B _7159_/D VDD VDD VSS VSS gf180mcu_fd_sc_mcu7t5v0__oai21_1
X_3841_ _7588_/Q _3822_/Z _3839_/Z _3841_/Z VDD VDD VSS VSS gf180mcu_fd_sc_mcu7t5v0__xor3_1
X_3772_ _7562_/Q _7553_/Q _7809_/D VDD VDD VSS VSS gf180mcu_fd_sc_mcu7t5v0__and2_1
X_6560_ _6566_/S _7696_/Q _6561_/B VDD VDD VSS VSS gf180mcu_fd_sc_mcu7t5v0__nor2_1
X_5511_ _7461_/Q wire428/Z _5511_/B1 _7440_/Q _7363_/Q _5511_/C2 _5512_/A3 VDD VDD
+ VSS VSS gf180mcu_fd_sc_mcu7t5v0__oai222_1
X_6491_ _6538_/A1 _6490_/Z _7672_/D VDD VDD VSS VSS gf180mcu_fd_sc_mcu7t5v0__nor2_1
XTAP_TAPCELL_ROW_30_677 VDD VSS gf180mcu_fd_sc_mcu7t5v0__filltie
XTAP_TAPCELL_ROW_76_1329 VDD VSS gf180mcu_fd_sc_mcu7t5v0__filltie
XTAP_TAPCELL_ROW_76_1318 VDD VSS gf180mcu_fd_sc_mcu7t5v0__filltie
X_5442_ _7368_/Q _5442_/A2 _5559_/B1 _7375_/Q _7382_/Q _5600_/C2 _5443_/A2 VDD VDD
+ VSS VSS gf180mcu_fd_sc_mcu7t5v0__oai222_1
X_5373_ _5373_/A1 _7727_/Q _5373_/Z VDD VDD VSS VSS gf180mcu_fd_sc_mcu7t5v0__or2_1
X_4324_ _4324_/A1 _4336_/A2 _4324_/B _6876_/D VDD VDD VSS VSS gf180mcu_fd_sc_mcu7t5v0__oai21_1
X_7112_ _7112_/D _7196_/CLK _7112_/Q VDD VDD VSS VSS gf180mcu_fd_sc_mcu7t5v0__dffq_1
XFILLER_114_765 VDD VDD VSS VSS gf180mcu_fd_sc_mcu7t5v0__fillcap_32
X_7043_ _7043_/D _7064_/CLK _7043_/Q VDD VDD VSS VSS gf180mcu_fd_sc_mcu7t5v0__dffq_1
X_4255_ _6842_/Q _4266_/A2 _4256_/B VDD VDD VSS VSS gf180mcu_fd_sc_mcu7t5v0__nand2_1
X_4186_ wire507/Z _6810_/Q _5197_/S _6810_/D VDD VDD VSS VSS gf180mcu_fd_sc_mcu7t5v0__mux2_2
XPHY_EDGE_ROW_118_Right_118 VDD VSS gf180mcu_fd_sc_mcu7t5v0__endcap
XFILLER_82_387 VDD VDD VSS VSS gf180mcu_fd_sc_mcu7t5v0__fill_1
XTAP_TAPCELL_ROW_38_788 VDD VSS gf180mcu_fd_sc_mcu7t5v0__filltie
X_6827_ _6827_/D _7823_/CLK _6827_/Q VDD VDD VSS VSS gf180mcu_fd_sc_mcu7t5v0__dffq_1
X_6758_ _6758_/D _7002_/CLK _6758_/Q VDD VDD VSS VSS gf180mcu_fd_sc_mcu7t5v0__dffq_1
Xwire507 wire507/I wire507/Z VDD VDD VSS VSS gf180mcu_fd_sc_mcu7t5v0__clkbuf_4
X_5709_ _6327_/A1 _7678_/Q _7624_/Q _5724_/A2 _5710_/C VDD VDD VSS VSS gf180mcu_fd_sc_mcu7t5v0__oai22_1
X_6689_ _7743_/Q _7742_/Q _7744_/Q _6690_/A2 VDD VDD VSS VSS gf180mcu_fd_sc_mcu7t5v0__nor3_1
XFILLER_93_608 VDD VDD VSS VSS gf180mcu_fd_sc_mcu7t5v0__fill_1
XFILLER_59_863 VDD VDD VSS VSS gf180mcu_fd_sc_mcu7t5v0__fill_1
Xclkbuf_leaf_42_clk_i clkload5/I _7148_/CLK VDD VDD VSS VSS gf180mcu_fd_sc_mcu7t5v0__clkbuf_8
XFILLER_74_833 VDD VDD VSS VSS gf180mcu_fd_sc_mcu7t5v0__fill_1
XFILLER_46_524 VDD VDD VSS VSS gf180mcu_fd_sc_mcu7t5v0__fill_1
XFILLER_74_877 VDD VDD VSS VSS gf180mcu_fd_sc_mcu7t5v0__fillcap_32
Xclkbuf_leaf_57_clk_i clkload4/I _7250_/CLK VDD VDD VSS VSS gf180mcu_fd_sc_mcu7t5v0__clkbuf_8
XFILLER_14_454 VDD VDD VSS VSS gf180mcu_fd_sc_mcu7t5v0__fill_1
XFILLER_30_947 VDD VDD VSS VSS gf180mcu_fd_sc_mcu7t5v0__fillcap_32
XFILLER_108_592 VDD VDD VSS VSS gf180mcu_fd_sc_mcu7t5v0__fill_2
XPHY_EDGE_ROW_87_Left_206 VDD VSS gf180mcu_fd_sc_mcu7t5v0__endcap
XTAP_TAPCELL_ROW_71_1248 VDD VSS gf180mcu_fd_sc_mcu7t5v0__filltie
XTAP_TAPCELL_ROW_71_1259 VDD VSS gf180mcu_fd_sc_mcu7t5v0__filltie
XFILLER_111_768 VDD VDD VSS VSS gf180mcu_fd_sc_mcu7t5v0__fill_2
X_4040_ _4143_/A1 _4630_/A2 _4040_/B _6765_/D VDD VDD VSS VSS gf180mcu_fd_sc_mcu7t5v0__oai21_1
XFILLER_37_557 VDD VDD VSS VSS gf180mcu_fd_sc_mcu7t5v0__fill_2
XFILLER_80_803 VDD VDD VSS VSS gf180mcu_fd_sc_mcu7t5v0__fill_2
X_5991_ _7250_/Q _6233_/A2 _6214_/B _5993_/B1 VDD VDD VSS VSS gf180mcu_fd_sc_mcu7t5v0__oai21_1
XFILLER_65_877 VDD VDD VSS VSS gf180mcu_fd_sc_mcu7t5v0__fillcap_4
XTAP_TAPCELL_ROW_35_747 VDD VSS gf180mcu_fd_sc_mcu7t5v0__filltie
X_7730_ _7730_/D _7736_/RN _7734_/CLK _7730_/Q VDD VDD VSS VSS gf180mcu_fd_sc_mcu7t5v0__dffrnq_1
X_4942_ _4942_/A1 _4952_/A2 _4942_/B _7185_/D VDD VDD VSS VSS gf180mcu_fd_sc_mcu7t5v0__oai21_1
X_7661_ _7661_/D _7661_/RN _7670_/CLK _7661_/Q VDD VDD VSS VSS gf180mcu_fd_sc_mcu7t5v0__dffrnq_1
XPHY_EDGE_ROW_96_Left_215 VDD VSS gf180mcu_fd_sc_mcu7t5v0__endcap
XTAP_TAPCELL_ROW_15_471 VDD VSS gf180mcu_fd_sc_mcu7t5v0__filltie
X_6612_ _7720_/Q _6612_/A2 _6622_/B _6613_/A2 VDD VDD VSS VSS gf180mcu_fd_sc_mcu7t5v0__oai21_1
X_4873_ _7151_/Q _4882_/A2 _4874_/B VDD VDD VSS VSS gf180mcu_fd_sc_mcu7t5v0__nand2_1
X_3824_ _7583_/Q _7580_/Q _7587_/Q _3824_/Z VDD VDD VSS VSS gf180mcu_fd_sc_mcu7t5v0__xor3_1
X_7592_ _7592_/D _7657_/RN _7695_/CLK _7592_/Q VDD VDD VSS VSS gf180mcu_fd_sc_mcu7t5v0__dffrnq_1
X_6543_ _7689_/Q _7690_/Q _6537_/Z _6543_/Z VDD VDD VSS VSS gf180mcu_fd_sc_mcu7t5v0__and3_1
X_3755_ _3502_/I _3755_/A2 _3755_/B1 _3755_/B2 _3758_/B1 VDD VDD VSS VSS gf180mcu_fd_sc_mcu7t5v0__oai22_1
X_6474_ _7670_/Q _7536_/Q _6478_/A2 VDD VDD VSS VSS gf180mcu_fd_sc_mcu7t5v0__nand2_1
X_3686_ input18/Z _3686_/A2 _3686_/A3 _3699_/B VDD VDD VSS VSS gf180mcu_fd_sc_mcu7t5v0__nor3_1
XPHY_EDGE_ROW_12_Right_12 VDD VSS gf180mcu_fd_sc_mcu7t5v0__endcap
X_5425_ _7451_/Q _5597_/A2 _5544_/A2 _7444_/Q _7423_/Q _5578_/A2 _5426_/A2 VDD VDD
+ VSS VSS gf180mcu_fd_sc_mcu7t5v0__oai222_1
XFILLER_88_936 VDD VDD VSS VSS gf180mcu_fd_sc_mcu7t5v0__fillcap_8
X_5356_ _7643_/Q _7503_/Q _5358_/S _7503_/D VDD VDD VSS VSS gf180mcu_fd_sc_mcu7t5v0__mux2_2
XFILLER_0_818 VDD VDD VSS VSS gf180mcu_fd_sc_mcu7t5v0__fillcap_32
XFILLER_102_724 VDD VDD VSS VSS gf180mcu_fd_sc_mcu7t5v0__fill_2
XFILLER_88_947 VDD VDD VSS VSS gf180mcu_fd_sc_mcu7t5v0__fillcap_32
X_4307_ _6868_/Q _4308_/A2 _4308_/B VDD VDD VSS VSS gf180mcu_fd_sc_mcu7t5v0__nand2_1
X_5287_ wire517/I _7434_/Q _5288_/S _7434_/D VDD VDD VSS VSS gf180mcu_fd_sc_mcu7t5v0__mux2_2
X_7026_ _7026_/D _7097_/CLK _7026_/Q VDD VDD VSS VSS gf180mcu_fd_sc_mcu7t5v0__dffq_1
XTAP_TAPCELL_ROW_89_1509 VDD VSS gf180mcu_fd_sc_mcu7t5v0__filltie
X_4238_ _4238_/I0 _6833_/Q _5358_/S _6833_/D VDD VDD VSS VSS gf180mcu_fd_sc_mcu7t5v0__mux2_2
X_4169_ _7734_/Q _4155_/Z _4226_/A3 VDD VDD VSS VSS gf180mcu_fd_sc_mcu7t5v0__nand2_1
XPHY_EDGE_ROW_21_Right_21 VDD VSS gf180mcu_fd_sc_mcu7t5v0__endcap
XFILLER_56_877 VDD VDD VSS VSS gf180mcu_fd_sc_mcu7t5v0__fillcap_64
XFILLER_36_590 VDD VDD VSS VSS gf180mcu_fd_sc_mcu7t5v0__fillcap_4
XFILLER_12_947 VDD VDD VSS VSS gf180mcu_fd_sc_mcu7t5v0__fillcap_32
XPHY_EDGE_ROW_30_Right_30 VDD VSS gf180mcu_fd_sc_mcu7t5v0__endcap
XFILLER_99_69 VDD VDD VSS VSS gf180mcu_fd_sc_mcu7t5v0__fill_1
XTAP_TAPCELL_ROW_111_1816 VDD VSS gf180mcu_fd_sc_mcu7t5v0__filltie
Xload_slew309 _6112_/A2 _6232_/A2 VDD VDD VSS VSS gf180mcu_fd_sc_mcu7t5v0__buf_4
XFILLER_78_424 VDD VDD VSS VSS gf180mcu_fd_sc_mcu7t5v0__fill_2
Xfanout470 _5577_/B _5599_/B VDD VDD VSS VSS gf180mcu_fd_sc_mcu7t5v0__dlyd_1
Xfanout492 _6147_/B _6236_/C VDD VDD VSS VSS gf180mcu_fd_sc_mcu7t5v0__dlyd_1
XTAP_TAPCELL_ROW_109_1789 VDD VSS gf180mcu_fd_sc_mcu7t5v0__filltie
XTAP_TAPCELL_ROW_109_1778 VDD VSS gf180mcu_fd_sc_mcu7t5v0__filltie
XFILLER_0_36 VDD VDD VSS VSS gf180mcu_fd_sc_mcu7t5v0__fill_2
XFILLER_62_836 VDD VDD VSS VSS gf180mcu_fd_sc_mcu7t5v0__fillcap_8
XTAP_TAPCELL_ROW_32_706 VDD VSS gf180mcu_fd_sc_mcu7t5v0__filltie
XTAP_TAPCELL_ROW_12_430 VDD VSS gf180mcu_fd_sc_mcu7t5v0__filltie
X_3540_ _3668_/A1 _7880_/I _5748_/A2 VDD VDD VSS VSS gf180mcu_fd_sc_mcu7t5v0__nand2_1
XFILLER_115_348 VDD VDD VSS VSS gf180mcu_fd_sc_mcu7t5v0__fill_2
X_5210_ _5245_/I0 _7357_/Q _5211_/S _7357_/D VDD VDD VSS VSS gf180mcu_fd_sc_mcu7t5v0__mux2_2
X_3471_ _3471_/A1 _3469_/Z _3471_/B _7822_/D VDD VDD VSS VSS gf180mcu_fd_sc_mcu7t5v0__aoi21_1
XFILLER_50_4 VDD VDD VSS VSS gf180mcu_fd_sc_mcu7t5v0__fill_1
X_6190_ _6190_/A1 _6284_/A2 _6284_/B1 _6189_/Z _7578_/D VDD VDD VSS VSS gf180mcu_fd_sc_mcu7t5v0__aoi22_1
X_5141_ _5344_/I0 _7288_/Q _5141_/S _7288_/D VDD VDD VSS VSS gf180mcu_fd_sc_mcu7t5v0__mux2_2
XFILLER_36_2 VDD VDD VSS VSS gf180mcu_fd_sc_mcu7t5v0__fill_1
XFILLER_85_917 VDD VDD VSS VSS gf180mcu_fd_sc_mcu7t5v0__fillcap_32
X_5072_ _5072_/A1 _5074_/A2 _5072_/B _7250_/D VDD VDD VSS VSS gf180mcu_fd_sc_mcu7t5v0__aoi21_1
X_4023_ _4088_/A1 _4560_/A2 _4023_/B _6760_/D VDD VDD VSS VSS gf180mcu_fd_sc_mcu7t5v0__oai21_1
XFILLER_38_877 VDD VDD VSS VSS gf180mcu_fd_sc_mcu7t5v0__fillcap_64
XTAP_TAPCELL_ROW_84_1439 VDD VSS gf180mcu_fd_sc_mcu7t5v0__filltie
XTAP_TAPCELL_ROW_84_1428 VDD VSS gf180mcu_fd_sc_mcu7t5v0__filltie
XFILLER_18_590 VDD VDD VSS VSS gf180mcu_fd_sc_mcu7t5v0__fillcap_4
X_7713_ _7713_/D wire593/I _7796_/CLK _7713_/Q VDD VDD VSS VSS gf180mcu_fd_sc_mcu7t5v0__dffrnq_1
X_5974_ _7173_/Q _6131_/A2 _6242_/C _5976_/A1 VDD VDD VSS VSS gf180mcu_fd_sc_mcu7t5v0__oai21_1
X_4925_ _7177_/Q _4938_/A2 _4926_/B VDD VDD VSS VSS gf180mcu_fd_sc_mcu7t5v0__nand2_1
X_4856_ _5094_/A1 _4868_/A2 _4856_/B _7142_/D VDD VDD VSS VSS gf180mcu_fd_sc_mcu7t5v0__oai21_1
X_7644_ _7644_/D _7782_/RN _7782_/CLK _7644_/Q VDD VDD VSS VSS gf180mcu_fd_sc_mcu7t5v0__dffrnq_1
X_7575_ _7575_/D _7710_/RN _7710_/CLK _7575_/Q VDD VDD VSS VSS gf180mcu_fd_sc_mcu7t5v0__dffrnq_1
XFILLER_21_766 VDD VDD VSS VSS gf180mcu_fd_sc_mcu7t5v0__fillcap_4
X_3807_ _3850_/C _3811_/A2 _3808_/B2 VDD VDD VSS VSS gf180mcu_fd_sc_mcu7t5v0__nor2_1
X_6526_ _7682_/Q _7683_/Q _7684_/Q _6516_/Z _6526_/Z VDD VDD VSS VSS gf180mcu_fd_sc_mcu7t5v0__and4_1
X_4787_ _7108_/Q _4798_/A2 _4788_/B VDD VDD VSS VSS gf180mcu_fd_sc_mcu7t5v0__nand2_1
X_3738_ _5673_/A1 _3738_/A2 _3738_/B _3738_/C _3739_/A2 VDD VDD VSS VSS gf180mcu_fd_sc_mcu7t5v0__aoi211_1
X_6457_ _6479_/S _6457_/A2 _6458_/A2 VDD VDD VSS VSS gf180mcu_fd_sc_mcu7t5v0__nand2_1
Xclkload80 _7099_/CLK clkload80/Z VDD VDD VSS VSS gf180mcu_fd_sc_mcu7t5v0__clkbuf_4
X_3669_ _7880_/I _3696_/A2 input67/Z _3670_/B1 VDD VDD VSS VSS gf180mcu_fd_sc_mcu7t5v0__nor3_1
X_6388_ _6388_/A1 _6388_/A2 _6388_/B _6394_/A2 VDD VDD VSS VSS gf180mcu_fd_sc_mcu7t5v0__oai21_1
X_5408_ _7346_/Q _5572_/C2 _5410_/A2 VDD VDD VSS VSS gf180mcu_fd_sc_mcu7t5v0__nor2_1
X_5339_ _5339_/I0 _7486_/Q _5344_/S _7486_/D VDD VDD VSS VSS gf180mcu_fd_sc_mcu7t5v0__mux2_2
XFILLER_0_648 VDD VDD VSS VSS gf180mcu_fd_sc_mcu7t5v0__fillcap_32
X_7009_ _7009_/D _7097_/CLK _7009_/Q VDD VDD VSS VSS gf180mcu_fd_sc_mcu7t5v0__dffq_1
XFILLER_28_332 VDD VDD VSS VSS gf180mcu_fd_sc_mcu7t5v0__fill_2
XFILLER_16_516 VDD VDD VSS VSS gf180mcu_fd_sc_mcu7t5v0__fillcap_8
XFILLER_43_357 VDD VDD VSS VSS gf180mcu_fd_sc_mcu7t5v0__fill_2
XFILLER_8_737 VDD VDD VSS VSS gf180mcu_fd_sc_mcu7t5v0__fillcap_64
XTAP_TAPCELL_ROW_55_1029 VDD VSS gf180mcu_fd_sc_mcu7t5v0__filltie
XFILLER_79_777 VDD VDD VSS VSS gf180mcu_fd_sc_mcu7t5v0__fill_2
XFILLER_94_725 VDD VDD VSS VSS gf180mcu_fd_sc_mcu7t5v0__fill_2
XFILLER_93_279 VDD VDD VSS VSS gf180mcu_fd_sc_mcu7t5v0__fill_1
XFILLER_81_419 VDD VDD VSS VSS gf180mcu_fd_sc_mcu7t5v0__fill_1
XTAP_TAPCELL_ROW_17_500 VDD VSS gf180mcu_fd_sc_mcu7t5v0__filltie
XFILLER_35_836 VDD VDD VSS VSS gf180mcu_fd_sc_mcu7t5v0__fillcap_4
XFILLER_46_173 VDD VDD VSS VSS gf180mcu_fd_sc_mcu7t5v0__fill_2
XTAP_TAPCELL_ROW_45_886 VDD VSS gf180mcu_fd_sc_mcu7t5v0__filltie
X_4710_ _4822_/A1 _4714_/A2 _4710_/B _7069_/D VDD VDD VSS VSS gf180mcu_fd_sc_mcu7t5v0__oai21_1
X_5690_ _5690_/A1 _5690_/A2 _5691_/I VDD VDD VSS VSS gf180mcu_fd_sc_mcu7t5v0__and2_1
X_4641_ _7035_/Q _4644_/A2 _4642_/B VDD VDD VSS VSS gf180mcu_fd_sc_mcu7t5v0__nand2_1
XFILLER_116_613 VDD VDD VSS VSS gf180mcu_fd_sc_mcu7t5v0__fill_2
X_4572_ _5118_/A1 _4574_/A2 _4572_/B _7000_/D VDD VDD VSS VSS gf180mcu_fd_sc_mcu7t5v0__oai21_1
X_7360_ _7360_/D clkload9/I _7360_/Q VDD VDD VSS VSS gf180mcu_fd_sc_mcu7t5v0__dffq_1
X_6311_ _3681_/C _6303_/S _6312_/B VDD VDD VSS VSS gf180mcu_fd_sc_mcu7t5v0__nand2_1
X_3523_ _3525_/A1 _3523_/A2 _7774_/D VDD VDD VSS VSS gf180mcu_fd_sc_mcu7t5v0__nor2_1
X_7291_ _7291_/D _7504_/CLK _7291_/Q VDD VDD VSS VSS gf180mcu_fd_sc_mcu7t5v0__dffq_1
X_3454_ _7592_/Q _6280_/A1 VDD VDD VSS VSS gf180mcu_fd_sc_mcu7t5v0__clkinv_1
X_6242_ _6788_/Q _6242_/A2 _6242_/B1 _6787_/Q _6242_/C _6243_/A2 VDD VDD VSS VSS gf180mcu_fd_sc_mcu7t5v0__oai221_1
X_3385_ _3385_/I _3681_/A2 VDD VDD VSS VSS gf180mcu_fd_sc_mcu7t5v0__clkinv_1
X_6173_ _6173_/A1 _6173_/A2 _6183_/A1 VDD VDD VSS VSS gf180mcu_fd_sc_mcu7t5v0__nor2_1
X_5124_ _5124_/A1 _5134_/A2 _5124_/B _7276_/D VDD VDD VSS VSS gf180mcu_fd_sc_mcu7t5v0__oai21_1
X_5055_ _7242_/Q _5064_/A2 _5056_/B VDD VDD VSS VSS gf180mcu_fd_sc_mcu7t5v0__nand2_1
X_4006_ _4150_/A2 _4027_/A2 _4490_/A2 VDD VDD VSS VSS gf180mcu_fd_sc_mcu7t5v0__nand2_1
XFILLER_52_121 VDD VDD VSS VSS gf180mcu_fd_sc_mcu7t5v0__fill_1
X_5957_ _6921_/Q _6167_/B1 _6085_/B1 _6928_/Q _6942_/Q _6087_/A2 _5958_/B2 VDD VDD
+ VSS VSS gf180mcu_fd_sc_mcu7t5v0__oai222_1
X_4908_ _4950_/A1 _4910_/A2 _4908_/B _7168_/D VDD VDD VSS VSS gf180mcu_fd_sc_mcu7t5v0__oai21_1
X_5888_ _7074_/Q _6153_/B1 wire313/I _7081_/Q _7095_/Q _6153_/A2 _5889_/A2 VDD VDD
+ VSS VSS gf180mcu_fd_sc_mcu7t5v0__oai222_1
X_7627_ _7627_/D _7706_/RN _7781_/CLK _7627_/Q VDD VDD VSS VSS gf180mcu_fd_sc_mcu7t5v0__dffrnq_1
XTAP_TAPCELL_ROW_97_1619 VDD VSS gf180mcu_fd_sc_mcu7t5v0__filltie
X_4839_ _7134_/Q _4840_/A2 _4840_/B VDD VDD VSS VSS gf180mcu_fd_sc_mcu7t5v0__nand2_1
X_7558_ _7558_/D _7558_/RN _7794_/CLK _7558_/Q VDD VDD VSS VSS gf180mcu_fd_sc_mcu7t5v0__dffrnq_1
X_7489_ _7489_/D _7489_/CLK _7489_/Q VDD VDD VSS VSS gf180mcu_fd_sc_mcu7t5v0__dffq_1
X_6509_ _6538_/A1 _6516_/A4 _6508_/Z _7678_/D VDD VDD VSS VSS gf180mcu_fd_sc_mcu7t5v0__nor3_1
XFILLER_0_412 VDD VDD VSS VSS gf180mcu_fd_sc_mcu7t5v0__fill_1
XTAP_TAPCELL_ROW_106_1737 VDD VSS gf180mcu_fd_sc_mcu7t5v0__filltie
XFILLER_17_836 VDD VDD VSS VSS gf180mcu_fd_sc_mcu7t5v0__fillcap_4
XFILLER_16_302 VDD VDD VSS VSS gf180mcu_fd_sc_mcu7t5v0__fill_1
XTAP_TAPCELL_ROW_3_294 VDD VSS gf180mcu_fd_sc_mcu7t5v0__filltie
XFILLER_29_696 VDD VDD VSS VSS gf180mcu_fd_sc_mcu7t5v0__fillcap_4
XTAP_TAPCELL_ROW_106_1748 VDD VSS gf180mcu_fd_sc_mcu7t5v0__filltie
XTAP_TAPCELL_ROW_42_845 VDD VSS gf180mcu_fd_sc_mcu7t5v0__filltie
XFILLER_12_574 VDD VDD VSS VSS gf180mcu_fd_sc_mcu7t5v0__fillcap_16
XANTENNA_6 _7613_/D VDD VDD VSS VSS gf180mcu_fd_sc_mcu7t5v0__antenna
XTAP_TAPCELL_ROW_117_1899 VDD VSS gf180mcu_fd_sc_mcu7t5v0__filltie
XPHY_EDGE_ROW_60_Left_179 VDD VSS gf180mcu_fd_sc_mcu7t5v0__endcap
XFILLER_79_585 VDD VDD VSS VSS gf180mcu_fd_sc_mcu7t5v0__fillcap_8
XFILLER_55_909 VDD VDD VSS VSS gf180mcu_fd_sc_mcu7t5v0__fill_1
XTAP_TAPCELL_ROW_68_1209 VDD VSS gf180mcu_fd_sc_mcu7t5v0__filltie
X_6860_ _6860_/D _7279_/CLK _6860_/Q VDD VDD VSS VSS gf180mcu_fd_sc_mcu7t5v0__dffq_1
XFILLER_90_772 VDD VDD VSS VSS gf180mcu_fd_sc_mcu7t5v0__fillcap_4
X_5811_ _6315_/A1 _6315_/A2 _6271_/B1 VDD VDD VSS VSS gf180mcu_fd_sc_mcu7t5v0__nor2_2
XFILLER_34_154 VDD VDD VSS VSS gf180mcu_fd_sc_mcu7t5v0__fill_1
X_6791_ _6791_/D _7253_/CLK _6791_/Q VDD VDD VSS VSS gf180mcu_fd_sc_mcu7t5v0__dffq_1
X_5742_ input31/Z _7569_/Q _5742_/S _7569_/D VDD VDD VSS VSS gf180mcu_fd_sc_mcu7t5v0__mux2_2
XTAP_TAPCELL_ROW_20_539 VDD VSS gf180mcu_fd_sc_mcu7t5v0__filltie
X_5673_ _5673_/A1 _5675_/S _5673_/B _7550_/D VDD VDD VSS VSS gf180mcu_fd_sc_mcu7t5v0__oai21_1
X_4624_ _4708_/A1 _4630_/A2 _4624_/B _7026_/D VDD VDD VSS VSS gf180mcu_fd_sc_mcu7t5v0__oai21_1
XPHY_EDGE_ROW_6_Right_6 VDD VSS gf180mcu_fd_sc_mcu7t5v0__endcap
X_7412_ _7412_/D _7418_/CLK _7412_/Q VDD VDD VSS VSS gf180mcu_fd_sc_mcu7t5v0__dffq_1
X_4555_ _6992_/Q _4560_/A2 _4556_/B VDD VDD VSS VSS gf180mcu_fd_sc_mcu7t5v0__nand2_1
X_7343_ _7343_/D _7378_/CLK _7343_/Q VDD VDD VSS VSS gf180mcu_fd_sc_mcu7t5v0__dffq_1
X_3506_ _3504_/Z _3508_/A2 _7801_/D VDD VDD VSS VSS gf180mcu_fd_sc_mcu7t5v0__xor2_1
X_4486_ _4584_/A1 _4490_/A2 _4486_/B _6957_/D VDD VDD VSS VSS gf180mcu_fd_sc_mcu7t5v0__oai21_1
XTAP_TAPCELL_ROW_92_1549 VDD VSS gf180mcu_fd_sc_mcu7t5v0__filltie
X_7274_ _7274_/D _7724_/CLK _7274_/Q VDD VDD VSS VSS gf180mcu_fd_sc_mcu7t5v0__dffq_1
X_6225_ _6753_/Q _6225_/A2 _6225_/B1 _6752_/Q _6751_/Q wire313/Z _6226_/I VDD VDD
+ VSS VSS gf180mcu_fd_sc_mcu7t5v0__oai222_1
X_3437_ _7582_/Q _6259_/A1 VDD VDD VSS VSS gf180mcu_fd_sc_mcu7t5v0__clkinv_1
X_6156_ _6156_/A1 _6156_/A2 _6156_/B1 _6156_/B2 _6217_/B _6157_/B VDD VDD VSS VSS
+ gf180mcu_fd_sc_mcu7t5v0__oai221_1
X_3368_ _6216_/B _6196_/B VDD VDD VSS VSS gf180mcu_fd_sc_mcu7t5v0__inv_2
XFILLER_111_181 VDD VDD VSS VSS gf180mcu_fd_sc_mcu7t5v0__fill_1
X_5107_ _7268_/Q _5120_/A2 _5108_/B VDD VDD VSS VSS gf180mcu_fd_sc_mcu7t5v0__nand2_1
X_6087_ _7266_/Q _6087_/A2 _6087_/B _6195_/C _6088_/B VDD VDD VSS VSS gf180mcu_fd_sc_mcu7t5v0__oai211_1
XFILLER_100_899 VDD VDD VSS VSS gf180mcu_fd_sc_mcu7t5v0__fillcap_32
XFILLER_45_419 VDD VDD VSS VSS gf180mcu_fd_sc_mcu7t5v0__fill_1
X_5038_ _5066_/A1 _5050_/A2 _5038_/B _7233_/D VDD VDD VSS VSS gf180mcu_fd_sc_mcu7t5v0__oai21_1
XTAP_TAPCELL_ROW_0_242 VDD VSS gf180mcu_fd_sc_mcu7t5v0__filltie
XTAP_TAPCELL_ROW_0_253 VDD VSS gf180mcu_fd_sc_mcu7t5v0__filltie
XFILLER_81_772 VDD VDD VSS VSS gf180mcu_fd_sc_mcu7t5v0__fillcap_8
XTAP_TAPCELL_ROW_0_264 VDD VSS gf180mcu_fd_sc_mcu7t5v0__filltie
X_6989_ _6989_/D _7254_/CLK _6989_/Q VDD VDD VSS VSS gf180mcu_fd_sc_mcu7t5v0__dffq_1
XTAP_TAPCELL_ROW_101_1667 VDD VSS gf180mcu_fd_sc_mcu7t5v0__filltie
XTAP_TAPCELL_ROW_101_1678 VDD VSS gf180mcu_fd_sc_mcu7t5v0__filltie
XFILLER_108_944 VDD VDD VSS VSS gf180mcu_fd_sc_mcu7t5v0__fill_1
XFILLER_108_922 VDD VDD VSS VSS gf180mcu_fd_sc_mcu7t5v0__fillcap_16
XFILLER_5_559 VDD VDD VSS VSS gf180mcu_fd_sc_mcu7t5v0__fill_1
XFILLER_89_861 VDD VDD VSS VSS gf180mcu_fd_sc_mcu7t5v0__fill_1
XTAP_TAPCELL_ROW_8_375 VDD VSS gf180mcu_fd_sc_mcu7t5v0__filltie
XTAP_TAPCELL_ROW_8_364 VDD VSS gf180mcu_fd_sc_mcu7t5v0__filltie
XFILLER_76_577 VDD VDD VSS VSS gf180mcu_fd_sc_mcu7t5v0__fillcap_4
XFILLER_49_769 VDD VDD VSS VSS gf180mcu_fd_sc_mcu7t5v0__fill_1
XTAP_TAPCELL_ROW_47_915 VDD VSS gf180mcu_fd_sc_mcu7t5v0__filltie
XFILLER_64_739 VDD VDD VSS VSS gf180mcu_fd_sc_mcu7t5v0__fill_1
XFILLER_91_547 VDD VDD VSS VSS gf180mcu_fd_sc_mcu7t5v0__fill_1
XTAP_TAPCELL_ROW_63_1139 VDD VSS gf180mcu_fd_sc_mcu7t5v0__filltie
XPHY_EDGE_ROW_59_Right_59 VDD VSS gf180mcu_fd_sc_mcu7t5v0__endcap
XFILLER_8_397 VDD VDD VSS VSS gf180mcu_fd_sc_mcu7t5v0__fill_1
XFILLER_114_947 VDD VDD VSS VSS gf180mcu_fd_sc_mcu7t5v0__fillcap_32
X_4340_ _5012_/A1 _4350_/A2 _4340_/B _6884_/D VDD VDD VSS VSS gf180mcu_fd_sc_mcu7t5v0__oai21_1
X_4271_ _6850_/Q _4280_/A2 _4272_/B VDD VDD VSS VSS gf180mcu_fd_sc_mcu7t5v0__nand2_1
X_6010_ _6010_/A1 _6010_/A2 _6020_/A1 VDD VDD VSS VSS gf180mcu_fd_sc_mcu7t5v0__nor2_1
XPHY_EDGE_ROW_68_Right_68 VDD VSS gf180mcu_fd_sc_mcu7t5v0__endcap
XFILLER_27_419 VDD VDD VSS VSS gf180mcu_fd_sc_mcu7t5v0__fill_1
X_6912_ _6912_/D _6915_/CLK _6912_/Q VDD VDD VSS VSS gf180mcu_fd_sc_mcu7t5v0__dffq_1
X_6843_ _6843_/D _7683_/CLK _6843_/Q VDD VDD VSS VSS gf180mcu_fd_sc_mcu7t5v0__dffq_1
XTAP_TAPCELL_ROW_25_609 VDD VSS gf180mcu_fd_sc_mcu7t5v0__filltie
XFILLER_51_912 VDD VDD VSS VSS gf180mcu_fd_sc_mcu7t5v0__fillcap_64
X_3986_ wire248/Z _4392_/A2 _3986_/B _6748_/D VDD VDD VSS VSS gf180mcu_fd_sc_mcu7t5v0__oai21_1
X_6774_ _6774_/D _7118_/CLK _6774_/Q VDD VDD VSS VSS gf180mcu_fd_sc_mcu7t5v0__dffq_1
XPHY_EDGE_ROW_77_Right_77 VDD VSS gf180mcu_fd_sc_mcu7t5v0__endcap
X_5725_ _6322_/A1 _7675_/Q _6330_/A1 _7680_/Q _5726_/B VDD VDD VSS VSS gf180mcu_fd_sc_mcu7t5v0__aoi22_1
XFILLER_10_319 VDD VDD VSS VSS gf180mcu_fd_sc_mcu7t5v0__fill_1
X_5656_ _7538_/Q input36/Z _5663_/S _7538_/D VDD VDD VSS VSS gf180mcu_fd_sc_mcu7t5v0__mux2_2
X_4607_ _7018_/Q _4616_/A2 _4608_/B VDD VDD VSS VSS gf180mcu_fd_sc_mcu7t5v0__nand2_1
XPHY_EDGE_ROW_107_Left_226 VDD VSS gf180mcu_fd_sc_mcu7t5v0__endcap
X_5587_ _7514_/Q _6732_/A1 _6728_/B _5587_/C _5588_/A2 VDD VDD VSS VSS gf180mcu_fd_sc_mcu7t5v0__oai211_1
X_4538_ _5014_/A1 _4546_/A2 _4538_/B _6983_/D VDD VDD VSS VSS gf180mcu_fd_sc_mcu7t5v0__oai21_1
X_7326_ _7326_/D _7491_/CLK _7326_/Q VDD VDD VSS VSS gf180mcu_fd_sc_mcu7t5v0__dffq_1
X_7257_ _7257_/D _7266_/CLK _7257_/Q VDD VDD VSS VSS gf180mcu_fd_sc_mcu7t5v0__dffq_1
X_4469_ _6949_/Q _4476_/A2 _4470_/B VDD VDD VSS VSS gf180mcu_fd_sc_mcu7t5v0__nand2_1
X_6208_ _6765_/Q wire355/I _6212_/B1 _6763_/Q _6208_/C _6209_/A2 VDD VDD VSS VSS gf180mcu_fd_sc_mcu7t5v0__oai221_1
XPHY_EDGE_ROW_86_Right_86 VDD VSS gf180mcu_fd_sc_mcu7t5v0__endcap
XTAP_TAPCELL_ROW_5_334 VDD VSS gf180mcu_fd_sc_mcu7t5v0__filltie
XTAP_TAPCELL_ROW_5_323 VDD VSS gf180mcu_fd_sc_mcu7t5v0__filltie
X_7188_ _7188_/D _7189_/CLK _7188_/Q VDD VDD VSS VSS gf180mcu_fd_sc_mcu7t5v0__dffq_1
XFILLER_86_886 VDD VDD VSS VSS gf180mcu_fd_sc_mcu7t5v0__fill_2
X_6139_ _6139_/A1 _6139_/A2 _6143_/B1 VDD VDD VSS VSS gf180mcu_fd_sc_mcu7t5v0__nor2_1
XPHY_EDGE_ROW_116_Left_235 VDD VSS gf180mcu_fd_sc_mcu7t5v0__endcap
XFILLER_58_588 VDD VDD VSS VSS gf180mcu_fd_sc_mcu7t5v0__fill_2
XTAP_TAPCELL_ROW_103_1707 VDD VSS gf180mcu_fd_sc_mcu7t5v0__filltie
XPHY_EDGE_ROW_95_Right_95 VDD VSS gf180mcu_fd_sc_mcu7t5v0__endcap
XTAP_TAPCELL_ROW_52_984 VDD VSS gf180mcu_fd_sc_mcu7t5v0__filltie
XFILLER_108_741 VDD VDD VSS VSS gf180mcu_fd_sc_mcu7t5v0__fill_2
XTAP_TAPCELL_ROW_114_1858 VDD VSS gf180mcu_fd_sc_mcu7t5v0__filltie
XFILLER_111_906 VDD VDD VSS VSS gf180mcu_fd_sc_mcu7t5v0__fillcap_4
XFILLER_1_562 VDD VDD VSS VSS gf180mcu_fd_sc_mcu7t5v0__fillcap_64
XFILLER_77_820 VDD VDD VSS VSS gf180mcu_fd_sc_mcu7t5v0__fillcap_8
XFILLER_33_912 VDD VDD VSS VSS gf180mcu_fd_sc_mcu7t5v0__fillcap_64
XFILLER_45_772 VDD VDD VSS VSS gf180mcu_fd_sc_mcu7t5v0__fillcap_64
XFILLER_51_219 VDD VDD VSS VSS gf180mcu_fd_sc_mcu7t5v0__fill_2
XFILLER_60_731 VDD VDD VSS VSS gf180mcu_fd_sc_mcu7t5v0__fillcap_4
X_3840_ _3836_/Z _3837_/Z _3838_/Z _3840_/Z VDD VDD VSS VSS gf180mcu_fd_sc_mcu7t5v0__xor3_1
X_3771_ _7563_/Q _7554_/Q _7808_/D VDD VDD VSS VSS gf180mcu_fd_sc_mcu7t5v0__and2_1
XFILLER_60_786 VDD VDD VSS VSS gf180mcu_fd_sc_mcu7t5v0__fill_1
X_5510_ _7286_/Q _5607_/B1 _5512_/A2 VDD VDD VSS VSS gf180mcu_fd_sc_mcu7t5v0__nor2_1
X_6490_ _6490_/A1 _7791_/Q _6490_/Z VDD VDD VSS VSS gf180mcu_fd_sc_mcu7t5v0__xor2_1
XFILLER_8_172 VDD VDD VSS VSS gf180mcu_fd_sc_mcu7t5v0__fill_2
XTAP_TAPCELL_ROW_30_678 VDD VSS gf180mcu_fd_sc_mcu7t5v0__filltie
XTAP_TAPCELL_ROW_76_1319 VDD VSS gf180mcu_fd_sc_mcu7t5v0__filltie
X_5441_ _7389_/Q _5453_/C2 _5590_/B _5443_/A1 VDD VDD VSS VSS gf180mcu_fd_sc_mcu7t5v0__oai21_1
XFILLER_66_2 VDD VDD VSS VSS gf180mcu_fd_sc_mcu7t5v0__fill_1
X_5372_ _7726_/Q _7727_/Q _5372_/Z VDD VDD VSS VSS gf180mcu_fd_sc_mcu7t5v0__or2_1
X_4323_ _6876_/Q _4336_/A2 _4324_/B VDD VDD VSS VSS gf180mcu_fd_sc_mcu7t5v0__nand2_1
X_7111_ _7111_/D _7217_/CLK _7111_/Q VDD VDD VSS VSS gf180mcu_fd_sc_mcu7t5v0__dffq_1
X_7042_ _7042_/D _7064_/CLK _7042_/Q VDD VDD VSS VSS gf180mcu_fd_sc_mcu7t5v0__dffq_1
XFILLER_99_455 VDD VDD VSS VSS gf180mcu_fd_sc_mcu7t5v0__fill_2
X_4254_ _5122_/A1 _4266_/A2 _4254_/B _6841_/D VDD VDD VSS VSS gf180mcu_fd_sc_mcu7t5v0__oai21_1
X_4185_ _6651_/A2 _4189_/A2 _5197_/S VDD VDD VSS VSS gf180mcu_fd_sc_mcu7t5v0__nand2_1
XTAP_TAPCELL_ROW_38_789 VDD VSS gf180mcu_fd_sc_mcu7t5v0__filltie
XFILLER_35_282 VDD VDD VSS VSS gf180mcu_fd_sc_mcu7t5v0__fill_1
XFILLER_63_580 VDD VDD VSS VSS gf180mcu_fd_sc_mcu7t5v0__fill_1
X_6826_ _6826_/D _7736_/CLK _6826_/Q VDD VDD VSS VSS gf180mcu_fd_sc_mcu7t5v0__dffq_1
X_6757_ _6757_/D _7002_/CLK _6757_/Q VDD VDD VSS VSS gf180mcu_fd_sc_mcu7t5v0__dffq_1
X_3969_ _4150_/A1 _3967_/I _4336_/A2 VDD VDD VSS VSS gf180mcu_fd_sc_mcu7t5v0__nand2_1
X_5708_ _5703_/Z _5705_/Z _5708_/A3 _5707_/Z _5732_/A1 VDD VDD VSS VSS gf180mcu_fd_sc_mcu7t5v0__nor4_1
X_6688_ _6697_/A1 _6687_/Z _7744_/D VDD VDD VSS VSS gf180mcu_fd_sc_mcu7t5v0__nor2_1
X_5639_ _7522_/Q input48/Z _5642_/S _7522_/D VDD VDD VSS VSS gf180mcu_fd_sc_mcu7t5v0__mux2_2
X_7309_ _7309_/D _7491_/CLK _7309_/Q VDD VDD VSS VSS gf180mcu_fd_sc_mcu7t5v0__dffq_1
XFILLER_105_777 VDD VDD VSS VSS gf180mcu_fd_sc_mcu7t5v0__fill_2
XFILLER_18_249 VDD VDD VSS VSS gf180mcu_fd_sc_mcu7t5v0__fill_1
XFILLER_15_912 VDD VDD VSS VSS gf180mcu_fd_sc_mcu7t5v0__fillcap_64
XFILLER_27_772 VDD VDD VSS VSS gf180mcu_fd_sc_mcu7t5v0__fillcap_64
XFILLER_42_731 VDD VDD VSS VSS gf180mcu_fd_sc_mcu7t5v0__fillcap_4
XFILLER_10_661 VDD VDD VSS VSS gf180mcu_fd_sc_mcu7t5v0__fillcap_4
XFILLER_108_582 VDD VDD VSS VSS gf180mcu_fd_sc_mcu7t5v0__fill_2
XFILLER_2_871 VDD VDD VSS VSS gf180mcu_fd_sc_mcu7t5v0__fillcap_4
XTAP_TAPCELL_ROW_71_1249 VDD VSS gf180mcu_fd_sc_mcu7t5v0__filltie
X_5990_ _7194_/Q _6098_/A2 _6171_/A2 _7201_/Q _7208_/Q _6233_/B1 _5993_/A2 VDD VDD
+ VSS VSS gf180mcu_fd_sc_mcu7t5v0__oai222_1
XTAP_TAPCELL_ROW_35_748 VDD VSS gf180mcu_fd_sc_mcu7t5v0__filltie
XFILLER_45_580 VDD VDD VSS VSS gf180mcu_fd_sc_mcu7t5v0__fill_2
X_4941_ _7185_/Q _4952_/A2 _4942_/B VDD VDD VSS VSS gf180mcu_fd_sc_mcu7t5v0__nand2_1
X_7660_ _7660_/D _7660_/RN _7670_/CLK _7660_/Q VDD VDD VSS VSS gf180mcu_fd_sc_mcu7t5v0__dffrnq_1
X_4872_ _4942_/A1 _4882_/A2 _4872_/B _7150_/D VDD VDD VSS VSS gf180mcu_fd_sc_mcu7t5v0__oai21_1
X_3823_ _7598_/Q _7597_/Q _3823_/Z VDD VDD VSS VSS gf180mcu_fd_sc_mcu7t5v0__xor2_1
X_6611_ _3937_/I _6611_/A2 _6616_/A2 VDD VDD VSS VSS gf180mcu_fd_sc_mcu7t5v0__nor2_1
X_7591_ _7591_/D _7695_/RN _7695_/CLK _7591_/Q VDD VDD VSS VSS gf180mcu_fd_sc_mcu7t5v0__dffrnq_1
XTAP_TAPCELL_ROW_15_472 VDD VSS gf180mcu_fd_sc_mcu7t5v0__filltie
X_6542_ _7690_/Q _6540_/Z _6544_/A2 VDD VDD VSS VSS gf180mcu_fd_sc_mcu7t5v0__nor2_1
X_3754_ _7798_/D _3754_/A2 _3754_/B _3755_/B2 VDD VDD VSS VSS gf180mcu_fd_sc_mcu7t5v0__aoi21_1
X_6473_ _6466_/Z _6473_/A2 _6473_/B _6478_/A1 VDD VDD VSS VSS gf180mcu_fd_sc_mcu7t5v0__aoi21_1
X_3685_ _3681_/C _3685_/A2 _3685_/A3 _3685_/B _3686_/A3 VDD VDD VSS VSS gf180mcu_fd_sc_mcu7t5v0__oai31_1
XFILLER_9_492 VDD VDD VSS VSS gf180mcu_fd_sc_mcu7t5v0__fill_2
X_5424_ _7430_/Q _5501_/B1 _5599_/B _5426_/A1 VDD VDD VSS VSS gf180mcu_fd_sc_mcu7t5v0__oai21_1
X_5355_ _7642_/Q _7502_/Q _5358_/S _7502_/D VDD VDD VSS VSS gf180mcu_fd_sc_mcu7t5v0__mux2_2
X_4306_ _5132_/A1 _4308_/A2 _4306_/B _6867_/D VDD VDD VSS VSS gf180mcu_fd_sc_mcu7t5v0__oai21_1
X_5286_ wire521/I _7433_/Q _5288_/S _7433_/D VDD VDD VSS VSS gf180mcu_fd_sc_mcu7t5v0__mux2_2
X_7025_ _7025_/D _7060_/CLK _7025_/Q VDD VDD VSS VSS gf180mcu_fd_sc_mcu7t5v0__dffq_1
X_4237_ _4237_/A1 _6651_/A2 _5358_/S VDD VDD VSS VSS gf180mcu_fd_sc_mcu7t5v0__nand2_1
XFILLER_96_981 VDD VDD VSS VSS gf180mcu_fd_sc_mcu7t5v0__fill_1
X_4168_ _4238_/I0 _6804_/Q _5155_/S _6804_/D VDD VDD VSS VSS gf180mcu_fd_sc_mcu7t5v0__mux2_2
XFILLER_56_834 VDD VDD VSS VSS gf180mcu_fd_sc_mcu7t5v0__fill_1
XFILLER_15_208 VDD VDD VSS VSS gf180mcu_fd_sc_mcu7t5v0__fill_2
X_4099_ _6784_/Q _4896_/A2 _4100_/B VDD VDD VSS VSS gf180mcu_fd_sc_mcu7t5v0__nand2_1
XFILLER_24_731 VDD VDD VSS VSS gf180mcu_fd_sc_mcu7t5v0__fillcap_4
XFILLER_43_539 VDD VDD VSS VSS gf180mcu_fd_sc_mcu7t5v0__fillcap_16
XFILLER_70_314 VDD VDD VSS VSS gf180mcu_fd_sc_mcu7t5v0__fill_1
XFILLER_71_837 VDD VDD VSS VSS gf180mcu_fd_sc_mcu7t5v0__fill_2
X_6809_ _6809_/D _7378_/CLK _6809_/Q VDD VDD VSS VSS gf180mcu_fd_sc_mcu7t5v0__dffq_1
X_7789_ _7789_/D _7785_/RN _7790_/CLK _7790_/D VDD VDD VSS VSS gf180mcu_fd_sc_mcu7t5v0__dffsnq_1
XFILLER_20_981 VDD VDD VSS VSS gf180mcu_fd_sc_mcu7t5v0__fill_1
XTAP_TAPCELL_ROW_111_1817 VDD VSS gf180mcu_fd_sc_mcu7t5v0__filltie
XTAP_TAPCELL_ROW_111_1806 VDD VSS gf180mcu_fd_sc_mcu7t5v0__filltie
XTAP_TAPCELL_ROW_57_1060 VDD VSS gf180mcu_fd_sc_mcu7t5v0__filltie
Xfanout482 wire487/I _6202_/B VDD VDD VSS VSS gf180mcu_fd_sc_mcu7t5v0__dlyd_1
XFILLER_101_780 VDD VDD VSS VSS gf180mcu_fd_sc_mcu7t5v0__fillcap_32
XTAP_TAPCELL_ROW_109_1779 VDD VSS gf180mcu_fd_sc_mcu7t5v0__filltie
XFILLER_62_859 VDD VDD VSS VSS gf180mcu_fd_sc_mcu7t5v0__fillcap_8
XTAP_TAPCELL_ROW_32_707 VDD VSS gf180mcu_fd_sc_mcu7t5v0__filltie
XTAP_TAPCELL_ROW_12_420 VDD VSS gf180mcu_fd_sc_mcu7t5v0__filltie
XTAP_TAPCELL_ROW_12_431 VDD VSS gf180mcu_fd_sc_mcu7t5v0__filltie
XFILLER_6_462 VDD VDD VSS VSS gf180mcu_fd_sc_mcu7t5v0__fill_1
X_3470_ _7769_/D _3469_/Z _7822_/Q _3471_/B VDD VDD VSS VSS gf180mcu_fd_sc_mcu7t5v0__aoi21_1
X_5140_ _5343_/I0 _7287_/Q _5141_/S _7287_/D VDD VDD VSS VSS gf180mcu_fd_sc_mcu7t5v0__mux2_2
XFILLER_97_767 VDD VDD VSS VSS gf180mcu_fd_sc_mcu7t5v0__fill_2
XFILLER_29_2 VDD VDD VSS VSS gf180mcu_fd_sc_mcu7t5v0__fill_1
X_5071_ _7250_/Q _5074_/A2 _5072_/B VDD VDD VSS VSS gf180mcu_fd_sc_mcu7t5v0__nor2_1
XFILLER_78_981 VDD VDD VSS VSS gf180mcu_fd_sc_mcu7t5v0__fill_1
X_4022_ _6760_/Q _4560_/A2 _4023_/B VDD VDD VSS VSS gf180mcu_fd_sc_mcu7t5v0__nand2_1
XFILLER_38_801 VDD VDD VSS VSS gf180mcu_fd_sc_mcu7t5v0__fillcap_4
XFILLER_93_973 VDD VDD VSS VSS gf180mcu_fd_sc_mcu7t5v0__fillcap_4
XTAP_TAPCELL_ROW_84_1429 VDD VSS gf180mcu_fd_sc_mcu7t5v0__filltie
XFILLER_52_314 VDD VDD VSS VSS gf180mcu_fd_sc_mcu7t5v0__fill_1
X_5973_ _5973_/A1 _5973_/A2 _5997_/A1 VDD VDD VSS VSS gf180mcu_fd_sc_mcu7t5v0__nor2_1
X_4924_ _4952_/A1 _4924_/A2 _4924_/B _7176_/D VDD VDD VSS VSS gf180mcu_fd_sc_mcu7t5v0__oai21_1
X_7712_ _7712_/D _7799_/RN _7796_/CLK _7712_/Q VDD VDD VSS VSS gf180mcu_fd_sc_mcu7t5v0__dffrnq_1
X_4855_ _7142_/Q _4868_/A2 _4856_/B VDD VDD VSS VSS gf180mcu_fd_sc_mcu7t5v0__nand2_1
X_7643_ _7643_/D _7780_/RN _7790_/CLK _7643_/Q VDD VDD VSS VSS gf180mcu_fd_sc_mcu7t5v0__dffrnq_1
X_7574_ _7574_/D _7589_/RN _7710_/CLK _7574_/Q VDD VDD VSS VSS gf180mcu_fd_sc_mcu7t5v0__dffrnq_1
XFILLER_20_255 VDD VDD VSS VSS gf180mcu_fd_sc_mcu7t5v0__fill_1
X_3806_ _7772_/Q _3903_/A1 _3811_/A2 VDD VDD VSS VSS gf180mcu_fd_sc_mcu7t5v0__nand2_1
X_4786_ _4786_/A1 _4798_/A2 _4786_/B _7107_/D VDD VDD VSS VSS gf180mcu_fd_sc_mcu7t5v0__oai21_1
XTAP_TAPCELL_ROW_99_1650 VDD VSS gf180mcu_fd_sc_mcu7t5v0__filltie
X_6525_ _6525_/A1 _6525_/A2 _6525_/Z VDD VDD VSS VSS gf180mcu_fd_sc_mcu7t5v0__and2_1
Xclkbuf_leaf_41_clk_i clkload5/I _7267_/CLK VDD VDD VSS VSS gf180mcu_fd_sc_mcu7t5v0__clkbuf_8
X_3737_ _3730_/Z _3737_/A2 _7549_/Q _3738_/C VDD VDD VSS VSS gf180mcu_fd_sc_mcu7t5v0__aoi21_1
X_6456_ _6456_/A1 _6469_/A1 _6457_/A2 VDD VDD VSS VSS gf180mcu_fd_sc_mcu7t5v0__nand2_1
Xclkload70 _6915_/CLK clkload70/ZN VDD VDD VSS VSS gf180mcu_fd_sc_mcu7t5v0__inv_2
X_3668_ _3668_/A1 _3668_/A2 _6315_/A1 VDD VDD VSS VSS gf180mcu_fd_sc_mcu7t5v0__nand2_1
X_6387_ _7657_/Q _7523_/Q _6387_/Z VDD VDD VSS VSS gf180mcu_fd_sc_mcu7t5v0__or2_1
Xclkload81 _7101_/CLK clkload81/ZN VDD VDD VSS VSS gf180mcu_fd_sc_mcu7t5v0__inv_2
X_5407_ _5407_/A1 _5407_/A2 _5417_/B1 VDD VDD VSS VSS gf180mcu_fd_sc_mcu7t5v0__nor2_1
X_3599_ input55/Z input62/Z _3599_/Z VDD VDD VSS VSS gf180mcu_fd_sc_mcu7t5v0__xor2_1
XFILLER_102_500 VDD VDD VSS VSS gf180mcu_fd_sc_mcu7t5v0__fill_1
X_5338_ _5345_/I0 _7485_/Q _5344_/S _7485_/D VDD VDD VSS VSS gf180mcu_fd_sc_mcu7t5v0__mux2_2
Xclkbuf_leaf_56_clk_i clkload4/I _7217_/CLK VDD VDD VSS VSS gf180mcu_fd_sc_mcu7t5v0__clkbuf_8
X_7008_ _7008_/D _7008_/CLK _7008_/Q VDD VDD VSS VSS gf180mcu_fd_sc_mcu7t5v0__dffq_1
X_5269_ _5304_/I0 _7416_/Q _5274_/S _7416_/D VDD VDD VSS VSS gf180mcu_fd_sc_mcu7t5v0__mux2_2
XFILLER_44_815 VDD VDD VSS VSS gf180mcu_fd_sc_mcu7t5v0__fillcap_4
XFILLER_44_848 VDD VDD VSS VSS gf180mcu_fd_sc_mcu7t5v0__fillcap_16
XFILLER_43_347 VDD VDD VSS VSS gf180mcu_fd_sc_mcu7t5v0__fill_2
XFILLER_24_594 VDD VDD VSS VSS gf180mcu_fd_sc_mcu7t5v0__fill_1
XFILLER_78_211 VDD VDD VSS VSS gf180mcu_fd_sc_mcu7t5v0__fill_1
XFILLER_78_244 VDD VDD VSS VSS gf180mcu_fd_sc_mcu7t5v0__fill_1
XFILLER_94_737 VDD VDD VSS VSS gf180mcu_fd_sc_mcu7t5v0__fill_2
XFILLER_79_789 VDD VDD VSS VSS gf180mcu_fd_sc_mcu7t5v0__fill_1
Xfanout290 _5120_/A1 wire292/I VDD VDD VSS VSS gf180mcu_fd_sc_mcu7t5v0__dlyd_1
XFILLER_75_973 VDD VDD VSS VSS gf180mcu_fd_sc_mcu7t5v0__fillcap_4
XFILLER_47_675 VDD VDD VSS VSS gf180mcu_fd_sc_mcu7t5v0__fill_2
XFILLER_90_943 VDD VDD VSS VSS gf180mcu_fd_sc_mcu7t5v0__fill_2
XFILLER_90_910 VDD VDD VSS VSS gf180mcu_fd_sc_mcu7t5v0__fill_1
XTAP_TAPCELL_ROW_17_501 VDD VSS gf180mcu_fd_sc_mcu7t5v0__filltie
XFILLER_62_601 VDD VDD VSS VSS gf180mcu_fd_sc_mcu7t5v0__fill_2
XFILLER_62_667 VDD VDD VSS VSS gf180mcu_fd_sc_mcu7t5v0__fill_1
XTAP_TAPCELL_ROW_45_887 VDD VSS gf180mcu_fd_sc_mcu7t5v0__filltie
XFILLER_62_678 VDD VDD VSS VSS gf180mcu_fd_sc_mcu7t5v0__fill_1
X_4640_ wire240/Z _4644_/A2 _4640_/B _7034_/D VDD VDD VSS VSS gf180mcu_fd_sc_mcu7t5v0__oai21_1
XFILLER_30_597 VDD VDD VSS VSS gf180mcu_fd_sc_mcu7t5v0__fillcap_64
X_4571_ _7000_/Q _4574_/A2 _4572_/B VDD VDD VSS VSS gf180mcu_fd_sc_mcu7t5v0__nand2_1
X_6310_ _7611_/Q input12/Z _6310_/S _7611_/D VDD VDD VSS VSS gf180mcu_fd_sc_mcu7t5v0__mux2_2
X_7290_ _7290_/D _7500_/CLK _7290_/Q VDD VDD VSS VSS gf180mcu_fd_sc_mcu7t5v0__dffq_1
X_3522_ _7774_/Q _7776_/Q _3523_/A2 VDD VDD VSS VSS gf180mcu_fd_sc_mcu7t5v0__nor2_1
X_3453_ _7593_/Q _6282_/A1 VDD VDD VSS VSS gf180mcu_fd_sc_mcu7t5v0__clkinv_1
X_6241_ _6785_/Q _6241_/A2 _6241_/B1 _6786_/Q _6243_/A1 VDD VDD VSS VSS gf180mcu_fd_sc_mcu7t5v0__oai22_1
XTAP_TAPCELL_ROW_94_1580 VDD VSS gf180mcu_fd_sc_mcu7t5v0__filltie
X_6172_ _7253_/Q _6235_/A2 _6235_/B1 _7246_/Q _7232_/Q _6236_/A2 _6173_/A2 VDD VDD
+ VSS VSS gf180mcu_fd_sc_mcu7t5v0__oai222_1
X_5123_ _7276_/Q _5134_/A2 _5124_/B VDD VDD VSS VSS gf180mcu_fd_sc_mcu7t5v0__nand2_1
X_3384_ _3683_/C _6314_/A1 VDD VDD VSS VSS gf180mcu_fd_sc_mcu7t5v0__clkinv_1
X_5054_ _5068_/A1 _5064_/A2 _5054_/B _7241_/D VDD VDD VSS VSS gf180mcu_fd_sc_mcu7t5v0__oai21_1
X_4005_ wire248/Z _4476_/A2 _4005_/B _6754_/D VDD VDD VSS VSS gf180mcu_fd_sc_mcu7t5v0__oai21_1
XFILLER_84_269 VDD VDD VSS VSS gf180mcu_fd_sc_mcu7t5v0__fill_1
XFILLER_84_247 VDD VDD VSS VSS gf180mcu_fd_sc_mcu7t5v0__fill_2
XFILLER_25_358 VDD VDD VSS VSS gf180mcu_fd_sc_mcu7t5v0__fill_1
X_5956_ _6935_/Q wire355/Z _6195_/C _5958_/B1 VDD VDD VSS VSS gf180mcu_fd_sc_mcu7t5v0__oai21_1
XFILLER_80_453 VDD VDD VSS VSS gf180mcu_fd_sc_mcu7t5v0__fill_2
XFILLER_52_177 VDD VDD VSS VSS gf180mcu_fd_sc_mcu7t5v0__fill_2
X_5887_ _7088_/Q _6144_/A2 _6208_/C _5889_/A1 VDD VDD VSS VSS gf180mcu_fd_sc_mcu7t5v0__oai21_1
X_4907_ _7168_/Q _4910_/A2 _4908_/B VDD VDD VSS VSS gf180mcu_fd_sc_mcu7t5v0__nand2_1
X_7626_ _7626_/D _7706_/RN _7781_/CLK _7626_/Q VDD VDD VSS VSS gf180mcu_fd_sc_mcu7t5v0__dffrnq_1
X_4838_ _4880_/A1 _4840_/A2 _4838_/B _7133_/D VDD VDD VSS VSS gf180mcu_fd_sc_mcu7t5v0__oai21_1
X_4769_ _7099_/Q _4770_/A2 _4770_/B VDD VDD VSS VSS gf180mcu_fd_sc_mcu7t5v0__nand2_1
X_7557_ _7557_/D _7558_/RN _7780_/CLK _7557_/Q VDD VDD VSS VSS gf180mcu_fd_sc_mcu7t5v0__dffrnq_1
X_7488_ _7488_/D _7490_/CLK _7488_/Q VDD VDD VSS VSS gf180mcu_fd_sc_mcu7t5v0__dffq_1
X_6508_ _6508_/A1 _6508_/A2 _6508_/Z VDD VDD VSS VSS gf180mcu_fd_sc_mcu7t5v0__and2_1
X_6439_ _6432_/Z _6440_/A3 _6439_/B _6442_/A2 VDD VDD VSS VSS gf180mcu_fd_sc_mcu7t5v0__aoi21_1
XFILLER_103_842 VDD VDD VSS VSS gf180mcu_fd_sc_mcu7t5v0__fillcap_4
XFILLER_0_446 VDD VDD VSS VSS gf180mcu_fd_sc_mcu7t5v0__fill_1
XFILLER_88_575 VDD VDD VSS VSS gf180mcu_fd_sc_mcu7t5v0__fill_1
XFILLER_76_726 VDD VDD VSS VSS gf180mcu_fd_sc_mcu7t5v0__fill_1
XTAP_TAPCELL_ROW_3_295 VDD VSS gf180mcu_fd_sc_mcu7t5v0__filltie
XTAP_TAPCELL_ROW_106_1749 VDD VSS gf180mcu_fd_sc_mcu7t5v0__filltie
XTAP_TAPCELL_ROW_106_1738 VDD VSS gf180mcu_fd_sc_mcu7t5v0__filltie
XFILLER_32_807 VDD VDD VSS VSS gf180mcu_fd_sc_mcu7t5v0__fillcap_64
XFILLER_44_667 VDD VDD VSS VSS gf180mcu_fd_sc_mcu7t5v0__fillcap_8
XTAP_TAPCELL_ROW_42_846 VDD VSS gf180mcu_fd_sc_mcu7t5v0__filltie
XTAP_TAPCELL_ROW_65_1170 VDD VSS gf180mcu_fd_sc_mcu7t5v0__filltie
XFILLER_12_542 VDD VDD VSS VSS gf180mcu_fd_sc_mcu7t5v0__fillcap_32
XFILLER_12_597 VDD VDD VSS VSS gf180mcu_fd_sc_mcu7t5v0__fillcap_64
XTAP_TAPCELL_ROW_22_570 VDD VSS gf180mcu_fd_sc_mcu7t5v0__filltie
XANTENNA_7 _5808_/A1 VDD VDD VSS VSS gf180mcu_fd_sc_mcu7t5v0__antenna
XFILLER_113_628 VDD VDD VSS VSS gf180mcu_fd_sc_mcu7t5v0__fill_2
XFILLER_75_792 VDD VDD VSS VSS gf180mcu_fd_sc_mcu7t5v0__fillcap_4
X_5810_ _5810_/A1 _5813_/A2 _6254_/B1 VDD VDD VSS VSS gf180mcu_fd_sc_mcu7t5v0__nor2_2
X_6790_ _6790_/D _7253_/CLK _6790_/Q VDD VDD VSS VSS gf180mcu_fd_sc_mcu7t5v0__dffq_1
X_5741_ input29/Z _7568_/Q _5742_/S _7568_/D VDD VDD VSS VSS gf180mcu_fd_sc_mcu7t5v0__mux2_2
X_7411_ _7411_/D _7418_/CLK _7411_/Q VDD VDD VSS VSS gf180mcu_fd_sc_mcu7t5v0__dffq_1
X_5672_ input36/Z _5675_/S _5673_/B VDD VDD VSS VSS gf180mcu_fd_sc_mcu7t5v0__nand2_1
XFILLER_117_912 VDD VDD VSS VSS gf180mcu_fd_sc_mcu7t5v0__fillcap_64
X_4623_ _7026_/Q _4630_/A2 _4624_/B VDD VDD VSS VSS gf180mcu_fd_sc_mcu7t5v0__nand2_1
X_4554_ _5100_/A1 _4560_/A2 _4554_/B _6991_/D VDD VDD VSS VSS gf180mcu_fd_sc_mcu7t5v0__oai21_1
X_7342_ _7342_/D clkload9/I _7342_/Q VDD VDD VSS VSS gf180mcu_fd_sc_mcu7t5v0__dffq_1
X_7273_ _7273_/D _7687_/CLK _7273_/Q VDD VDD VSS VSS gf180mcu_fd_sc_mcu7t5v0__dffq_1
X_3505_ _3499_/I _3505_/A2 _3505_/B _3508_/A2 VDD VDD VSS VSS gf180mcu_fd_sc_mcu7t5v0__oai21_1
X_4485_ _6957_/Q _4490_/A2 _4486_/B VDD VDD VSS VSS gf180mcu_fd_sc_mcu7t5v0__nand2_1
X_6224_ _6224_/A1 _6224_/A2 _6224_/B _6231_/A2 VDD VDD VSS VSS gf180mcu_fd_sc_mcu7t5v0__oai21_1
X_3436_ _7577_/Q _6130_/A1 VDD VDD VSS VSS gf180mcu_fd_sc_mcu7t5v0__clkinv_1
X_6155_ _6155_/A1 _6155_/A2 _6196_/B _6156_/B2 VDD VDD VSS VSS gf180mcu_fd_sc_mcu7t5v0__oai21_1
X_3367_ _7721_/Q _3966_/A1 VDD VDD VSS VSS gf180mcu_fd_sc_mcu7t5v0__clkinv_1
X_6086_ _6086_/I _6087_/B VDD VDD VSS VSS gf180mcu_fd_sc_mcu7t5v0__clkinv_1
X_5106_ _5134_/A1 _5106_/A2 _5106_/B _7267_/D VDD VDD VSS VSS gf180mcu_fd_sc_mcu7t5v0__oai21_1
Xload_slew471 _5599_/B _5590_/B VDD VDD VSS VSS gf180mcu_fd_sc_mcu7t5v0__clkbuf_4
Xload_slew460 _6637_/A1 _5397_/B VDD VDD VSS VSS gf180mcu_fd_sc_mcu7t5v0__buf_4
XFILLER_58_737 VDD VDD VSS VSS gf180mcu_fd_sc_mcu7t5v0__fill_1
X_5037_ _7233_/Q _5050_/A2 _5038_/B VDD VDD VSS VSS gf180mcu_fd_sc_mcu7t5v0__nand2_1
Xload_slew493 _6171_/B _6214_/B VDD VDD VSS VSS gf180mcu_fd_sc_mcu7t5v0__buf_4
XTAP_TAPCELL_ROW_0_243 VDD VSS gf180mcu_fd_sc_mcu7t5v0__filltie
XTAP_TAPCELL_ROW_0_254 VDD VSS gf180mcu_fd_sc_mcu7t5v0__filltie
XFILLER_14_807 VDD VDD VSS VSS gf180mcu_fd_sc_mcu7t5v0__fillcap_64
XTAP_TAPCELL_ROW_0_265 VDD VSS gf180mcu_fd_sc_mcu7t5v0__filltie
XFILLER_26_667 VDD VDD VSS VSS gf180mcu_fd_sc_mcu7t5v0__fillcap_64
X_6988_ _6988_/D _7070_/CLK _6988_/Q VDD VDD VSS VSS gf180mcu_fd_sc_mcu7t5v0__dffq_1
XFILLER_41_626 VDD VDD VSS VSS gf180mcu_fd_sc_mcu7t5v0__fillcap_4
X_5939_ _6246_/C _5939_/A2 _5939_/A3 _5945_/B VDD VDD VSS VSS gf180mcu_fd_sc_mcu7t5v0__nand3_1
XTAP_TAPCELL_ROW_101_1679 VDD VSS gf180mcu_fd_sc_mcu7t5v0__filltie
XTAP_TAPCELL_ROW_101_1668 VDD VSS gf180mcu_fd_sc_mcu7t5v0__filltie
X_7609_ _7609_/D _7611_/RN _7668_/CLK _7609_/Q VDD VDD VSS VSS gf180mcu_fd_sc_mcu7t5v0__dffrnq_1
XFILLER_5_505 VDD VDD VSS VSS gf180mcu_fd_sc_mcu7t5v0__fill_1
XFILLER_0_221 VDD VDD VSS VSS gf180mcu_fd_sc_mcu7t5v0__fill_2
Xinput100 tl_i[93] _3636_/A1 VDD VDD VSS VSS gf180mcu_fd_sc_mcu7t5v0__dlyd_1
XTAP_TAPCELL_ROW_8_376 VDD VSS gf180mcu_fd_sc_mcu7t5v0__filltie
XTAP_TAPCELL_ROW_8_365 VDD VSS gf180mcu_fd_sc_mcu7t5v0__filltie
XFILLER_1_766 VDD VDD VSS VSS gf180mcu_fd_sc_mcu7t5v0__fillcap_4
XFILLER_88_383 VDD VDD VSS VSS gf180mcu_fd_sc_mcu7t5v0__fill_2
XFILLER_76_523 VDD VDD VSS VSS gf180mcu_fd_sc_mcu7t5v0__fill_2
XFILLER_76_512 VDD VDD VSS VSS gf180mcu_fd_sc_mcu7t5v0__fill_2
XFILLER_76_556 VDD VDD VSS VSS gf180mcu_fd_sc_mcu7t5v0__fillcap_4
XFILLER_91_515 VDD VDD VSS VSS gf180mcu_fd_sc_mcu7t5v0__fill_1
XTAP_TAPCELL_ROW_47_916 VDD VSS gf180mcu_fd_sc_mcu7t5v0__filltie
XTAP_TAPCELL_ROW_27_640 VDD VSS gf180mcu_fd_sc_mcu7t5v0__filltie
XFILLER_45_976 VDD VDD VSS VSS gf180mcu_fd_sc_mcu7t5v0__fillcap_4
XFILLER_60_979 VDD VDD VSS VSS gf180mcu_fd_sc_mcu7t5v0__fill_2
XTAP_TAPCELL_ROW_78_1350 VDD VSS gf180mcu_fd_sc_mcu7t5v0__filltie
X_4270_ _5012_/A1 _4280_/A2 _4270_/B _6849_/D VDD VDD VSS VSS gf180mcu_fd_sc_mcu7t5v0__oai21_1
XFILLER_113_469 VDD VDD VSS VSS gf180mcu_fd_sc_mcu7t5v0__fill_1
XFILLER_95_865 VDD VDD VSS VSS gf180mcu_fd_sc_mcu7t5v0__fill_2
X_6911_ _6911_/D _7070_/CLK _6911_/Q VDD VDD VSS VSS gf180mcu_fd_sc_mcu7t5v0__dffq_1
X_6842_ _6842_/D _7276_/CLK _6842_/Q VDD VDD VSS VSS gf180mcu_fd_sc_mcu7t5v0__dffq_1
XFILLER_90_592 VDD VDD VSS VSS gf180mcu_fd_sc_mcu7t5v0__fill_2
XFILLER_23_626 VDD VDD VSS VSS gf180mcu_fd_sc_mcu7t5v0__fillcap_4
X_3985_ _6748_/Q _4392_/A2 _3986_/B VDD VDD VSS VSS gf180mcu_fd_sc_mcu7t5v0__nand2_1
X_6773_ _6773_/D _7118_/CLK _6773_/Q VDD VDD VSS VSS gf180mcu_fd_sc_mcu7t5v0__dffq_1
X_5724_ _7624_/Q _5724_/A2 _5724_/B _5724_/C _5732_/A3 VDD VDD VSS VSS gf180mcu_fd_sc_mcu7t5v0__aoi211_1
X_5655_ _5655_/A1 _5663_/S _5655_/B _7537_/D VDD VDD VSS VSS gf180mcu_fd_sc_mcu7t5v0__oai21_1
X_4606_ _4998_/A1 _4616_/A2 _4606_/B _7017_/D VDD VDD VSS VSS gf180mcu_fd_sc_mcu7t5v0__oai21_1
XFILLER_105_904 VDD VDD VSS VSS gf180mcu_fd_sc_mcu7t5v0__fill_1
X_7325_ _7325_/D _7418_/CLK _7325_/Q VDD VDD VSS VSS gf180mcu_fd_sc_mcu7t5v0__dffq_1
X_5586_ _7513_/Q _6733_/A4 _5588_/A1 VDD VDD VSS VSS gf180mcu_fd_sc_mcu7t5v0__nand2_1
X_4537_ _6983_/Q _4546_/A2 _4538_/B VDD VDD VSS VSS gf180mcu_fd_sc_mcu7t5v0__nand2_1
X_4468_ _5126_/A1 _4476_/A2 _4468_/B _6948_/D VDD VDD VSS VSS gf180mcu_fd_sc_mcu7t5v0__oai21_1
X_7256_ _7256_/D _7267_/CLK _7256_/Q VDD VDD VSS VSS gf180mcu_fd_sc_mcu7t5v0__dffq_1
X_6207_ _6766_/Q _6207_/A2 _6207_/B1 _6764_/Q _6209_/A1 VDD VDD VSS VSS gf180mcu_fd_sc_mcu7t5v0__oai22_1
X_3419_ _7742_/Q _6679_/I1 VDD VDD VSS VSS gf180mcu_fd_sc_mcu7t5v0__clkinv_1
X_7187_ _7187_/D _7719_/CLK _7187_/Q VDD VDD VSS VSS gf180mcu_fd_sc_mcu7t5v0__dffq_1
X_4399_ _6914_/Q _4406_/A2 _4400_/B VDD VDD VSS VSS gf180mcu_fd_sc_mcu7t5v0__nand2_1
X_6138_ _6840_/Q _6215_/A2 _6138_/B1 _6917_/Q _7071_/Q _6192_/A2 _6139_/A2 VDD VDD
+ VSS VSS gf180mcu_fd_sc_mcu7t5v0__oai222_1
XTAP_TAPCELL_ROW_5_335 VDD VSS gf180mcu_fd_sc_mcu7t5v0__filltie
XTAP_TAPCELL_ROW_5_324 VDD VSS gf180mcu_fd_sc_mcu7t5v0__filltie
XFILLER_58_523 VDD VDD VSS VSS gf180mcu_fd_sc_mcu7t5v0__fill_2
X_6069_ _6069_/I _7576_/D VDD VDD VSS VSS gf180mcu_fd_sc_mcu7t5v0__clkinv_1
XFILLER_73_559 VDD VDD VSS VSS gf180mcu_fd_sc_mcu7t5v0__fill_1
XFILLER_27_976 VDD VDD VSS VSS gf180mcu_fd_sc_mcu7t5v0__fillcap_4
XFILLER_13_114 VDD VDD VSS VSS gf180mcu_fd_sc_mcu7t5v0__fill_1
XFILLER_26_88 VDD VDD VSS VSS gf180mcu_fd_sc_mcu7t5v0__fill_2
XFILLER_42_979 VDD VDD VSS VSS gf180mcu_fd_sc_mcu7t5v0__fill_2
Xclkbuf_3_3__f_clk_i clkbuf_0_clk_i/Z clkload2/I VDD VDD VSS VSS gf180mcu_fd_sc_mcu7t5v0__clkbuf_16
XFILLER_41_489 VDD VDD VSS VSS gf180mcu_fd_sc_mcu7t5v0__fill_1
XTAP_TAPCELL_ROW_52_985 VDD VSS gf180mcu_fd_sc_mcu7t5v0__filltie
XFILLER_108_797 VDD VDD VSS VSS gf180mcu_fd_sc_mcu7t5v0__fillcap_8
XTAP_TAPCELL_ROW_114_1859 VDD VSS gf180mcu_fd_sc_mcu7t5v0__filltie
XTAP_TAPCELL_ROW_114_1848 VDD VSS gf180mcu_fd_sc_mcu7t5v0__filltie
XFILLER_104_981 VDD VDD VSS VSS gf180mcu_fd_sc_mcu7t5v0__fill_1
XTAP_TAPCELL_ROW_73_1280 VDD VSS gf180mcu_fd_sc_mcu7t5v0__filltie
XFILLER_49_501 VDD VDD VSS VSS gf180mcu_fd_sc_mcu7t5v0__fill_2
XFILLER_67_95 VDD VDD VSS VSS gf180mcu_fd_sc_mcu7t5v0__fill_2
X_3770_ _7564_/Q _7555_/Q _7807_/D VDD VDD VSS VSS gf180mcu_fd_sc_mcu7t5v0__and2_1
XFILLER_9_696 VDD VDD VSS VSS gf180mcu_fd_sc_mcu7t5v0__fillcap_4
X_5440_ _5440_/A1 _5440_/A2 _5460_/A3 VDD VDD VSS VSS gf180mcu_fd_sc_mcu7t5v0__nor2_1
XTAP_TAPCELL_ROW_30_679 VDD VSS gf180mcu_fd_sc_mcu7t5v0__filltie
XTAP_TAPCELL_ROW_10_392 VDD VSS gf180mcu_fd_sc_mcu7t5v0__filltie
X_5371_ _5373_/A1 _7727_/Q _5371_/ZN VDD VDD VSS VSS gf180mcu_fd_sc_mcu7t5v0__nand2_1
XFILLER_114_734 VDD VDD VSS VSS gf180mcu_fd_sc_mcu7t5v0__fill_1
X_4322_ _4336_/A1 _4322_/A2 _4322_/B _6875_/D VDD VDD VSS VSS gf180mcu_fd_sc_mcu7t5v0__oai21_1
X_7110_ _7110_/D _7250_/CLK _7110_/Q VDD VDD VSS VSS gf180mcu_fd_sc_mcu7t5v0__dffq_1
X_4253_ _6841_/Q _4266_/A2 _4254_/B VDD VDD VSS VSS gf180mcu_fd_sc_mcu7t5v0__nand2_1
X_7041_ _7041_/D _7062_/CLK _7041_/Q VDD VDD VSS VSS gf180mcu_fd_sc_mcu7t5v0__dffq_1
X_4184_ wire507/Z _6809_/Q _5190_/S _6809_/D VDD VDD VSS VSS gf180mcu_fd_sc_mcu7t5v0__mux2_2
XFILLER_55_548 VDD VDD VSS VSS gf180mcu_fd_sc_mcu7t5v0__fillcap_4
XFILLER_91_890 VDD VDD VSS VSS gf180mcu_fd_sc_mcu7t5v0__fill_1
XFILLER_23_434 VDD VDD VSS VSS gf180mcu_fd_sc_mcu7t5v0__fill_1
XFILLER_24_979 VDD VDD VSS VSS gf180mcu_fd_sc_mcu7t5v0__fill_2
X_6825_ _6825_/D _7736_/CLK _6825_/Q VDD VDD VSS VSS gf180mcu_fd_sc_mcu7t5v0__dffq_1
X_6756_ _6756_/D _7002_/CLK _6756_/Q VDD VDD VSS VSS gf180mcu_fd_sc_mcu7t5v0__dffq_1
X_3968_ _4138_/A1 _4138_/A2 _6617_/C VDD VDD VSS VSS gf180mcu_fd_sc_mcu7t5v0__nor2_1
X_5707_ _7622_/Q _7679_/Q _5707_/Z VDD VDD VSS VSS gf180mcu_fd_sc_mcu7t5v0__xor2_1
X_3899_ _7822_/D _3902_/A1 _3899_/S _3900_/I VDD VDD VSS VSS gf180mcu_fd_sc_mcu7t5v0__mux2_2
X_6687_ _7744_/Q _6687_/A2 _6687_/Z VDD VDD VSS VSS gf180mcu_fd_sc_mcu7t5v0__xor2_1
X_5638_ _7521_/Q input47/Z _5642_/S _7521_/D VDD VDD VSS VSS gf180mcu_fd_sc_mcu7t5v0__mux2_2
X_5569_ _5508_/C _5569_/A2 _5569_/A3 _5570_/A3 VDD VDD VSS VSS gf180mcu_fd_sc_mcu7t5v0__nor3_1
X_7308_ _7308_/D _7505_/CLK _7308_/Q VDD VDD VSS VSS gf180mcu_fd_sc_mcu7t5v0__dffq_1
X_7239_ _7239_/D _7247_/CLK _7239_/Q VDD VDD VSS VSS gf180mcu_fd_sc_mcu7t5v0__dffq_1
XFILLER_101_973 VDD VDD VSS VSS gf180mcu_fd_sc_mcu7t5v0__fillcap_4
XFILLER_108_594 VDD VDD VSS VSS gf180mcu_fd_sc_mcu7t5v0__fill_1
XFILLER_1_360 VDD VDD VSS VSS gf180mcu_fd_sc_mcu7t5v0__fill_2
XFILLER_49_364 VDD VDD VSS VSS gf180mcu_fd_sc_mcu7t5v0__fill_2
XFILLER_64_312 VDD VDD VSS VSS gf180mcu_fd_sc_mcu7t5v0__fill_2
XFILLER_92_654 VDD VDD VSS VSS gf180mcu_fd_sc_mcu7t5v0__fill_2
XFILLER_37_559 VDD VDD VSS VSS gf180mcu_fd_sc_mcu7t5v0__fill_1
XTAP_TAPCELL_ROW_86_1460 VDD VSS gf180mcu_fd_sc_mcu7t5v0__filltie
XFILLER_17_250 VDD VDD VSS VSS gf180mcu_fd_sc_mcu7t5v0__fill_1
X_4940_ _4940_/A1 _4952_/A2 _4940_/B _7184_/D VDD VDD VSS VSS gf180mcu_fd_sc_mcu7t5v0__oai21_1
XTAP_TAPCELL_ROW_35_749 VDD VSS gf180mcu_fd_sc_mcu7t5v0__filltie
X_4871_ _7150_/Q _4882_/A2 _4872_/B VDD VDD VSS VSS gf180mcu_fd_sc_mcu7t5v0__nand2_1
X_7590_ _7590_/D _7657_/RN _7695_/CLK _7590_/Q VDD VDD VSS VSS gf180mcu_fd_sc_mcu7t5v0__dffrnq_1
X_3822_ _7572_/Q _7577_/Q _3822_/Z VDD VDD VSS VSS gf180mcu_fd_sc_mcu7t5v0__xor2_1
XTAP_TAPCELL_ROW_15_462 VDD VSS gf180mcu_fd_sc_mcu7t5v0__filltie
X_6610_ _6621_/B _6610_/A2 _6612_/A2 _7719_/D VDD VDD VSS VSS gf180mcu_fd_sc_mcu7t5v0__nor3_1
XTAP_TAPCELL_ROW_15_473 VDD VSS gf180mcu_fd_sc_mcu7t5v0__filltie
X_6541_ _6559_/A1 _6541_/A2 _6540_/Z _7689_/D VDD VDD VSS VSS gf180mcu_fd_sc_mcu7t5v0__nor3_1
XFILLER_9_460 VDD VDD VSS VSS gf180mcu_fd_sc_mcu7t5v0__fill_1
X_3753_ _3476_/I _3484_/I _3754_/A2 VDD VDD VSS VSS gf180mcu_fd_sc_mcu7t5v0__nor2_1
X_6472_ _7670_/Q _6479_/S _6477_/B VDD VDD VSS VSS gf180mcu_fd_sc_mcu7t5v0__nor2_1
X_3684_ _3695_/C input16/Z _3685_/B VDD VDD VSS VSS gf180mcu_fd_sc_mcu7t5v0__nor2_1
X_5423_ _5423_/A1 _5423_/A2 _5430_/A3 VDD VDD VSS VSS gf180mcu_fd_sc_mcu7t5v0__nor2_1
X_5354_ _5354_/I0 _7501_/Q _5358_/S _7501_/D VDD VDD VSS VSS gf180mcu_fd_sc_mcu7t5v0__mux2_2
X_4305_ _6867_/Q _4308_/A2 _4306_/B VDD VDD VSS VSS gf180mcu_fd_sc_mcu7t5v0__nand2_1
XFILLER_102_726 VDD VDD VSS VSS gf180mcu_fd_sc_mcu7t5v0__fill_1
X_5285_ wire525/I _7432_/Q _5288_/S _7432_/D VDD VDD VSS VSS gf180mcu_fd_sc_mcu7t5v0__mux2_2
X_7024_ _7024_/D _7101_/CLK _7024_/Q VDD VDD VSS VSS gf180mcu_fd_sc_mcu7t5v0__dffq_1
X_4236_ _4238_/I0 _6832_/Q _5351_/S _6832_/D VDD VDD VSS VSS gf180mcu_fd_sc_mcu7t5v0__mux2_2
X_4167_ _4237_/A1 _6653_/A2 _5155_/S VDD VDD VSS VSS gf180mcu_fd_sc_mcu7t5v0__nand2_1
X_4098_ _4123_/A1 _4110_/A2 _4896_/A2 VDD VDD VSS VSS gf180mcu_fd_sc_mcu7t5v0__nand2_1
X_6808_ _6808_/D _7491_/CLK _6808_/Q VDD VDD VSS VSS gf180mcu_fd_sc_mcu7t5v0__dffq_1
XFILLER_11_448 VDD VDD VSS VSS gf180mcu_fd_sc_mcu7t5v0__fill_2
X_7788_ _7788_/D _7785_/RN _7790_/CLK _7789_/D VDD VDD VSS VSS gf180mcu_fd_sc_mcu7t5v0__dffsnq_1
X_6739_ _6739_/D _7279_/CLK _6739_/Q VDD VDD VSS VSS gf180mcu_fd_sc_mcu7t5v0__dffq_1
XTAP_TAPCELL_ROW_111_1818 VDD VSS gf180mcu_fd_sc_mcu7t5v0__filltie
XTAP_TAPCELL_ROW_111_1807 VDD VSS gf180mcu_fd_sc_mcu7t5v0__filltie
XTAP_TAPCELL_ROW_57_1050 VDD VSS gf180mcu_fd_sc_mcu7t5v0__filltie
XTAP_TAPCELL_ROW_57_1061 VDD VSS gf180mcu_fd_sc_mcu7t5v0__filltie
Xfanout461 _7729_/Q _5582_/C VDD VDD VSS VSS gf180mcu_fd_sc_mcu7t5v0__dlyd_1
Xfanout472 _7728_/Q _5577_/B VDD VDD VSS VSS gf180mcu_fd_sc_mcu7t5v0__dlyd_1
XFILLER_19_559 VDD VDD VSS VSS gf180mcu_fd_sc_mcu7t5v0__fill_1
XFILLER_0_38 VDD VDD VSS VSS gf180mcu_fd_sc_mcu7t5v0__fill_1
XTAP_TAPCELL_ROW_32_708 VDD VSS gf180mcu_fd_sc_mcu7t5v0__filltie
XFILLER_70_893 VDD VDD VSS VSS gf180mcu_fd_sc_mcu7t5v0__fillcap_8
XTAP_TAPCELL_ROW_81_1390 VDD VSS gf180mcu_fd_sc_mcu7t5v0__filltie
XTAP_TAPCELL_ROW_12_432 VDD VSS gf180mcu_fd_sc_mcu7t5v0__filltie
XTAP_TAPCELL_ROW_12_421 VDD VSS gf180mcu_fd_sc_mcu7t5v0__filltie
XFILLER_116_807 VDD VDD VSS VSS gf180mcu_fd_sc_mcu7t5v0__fillcap_64
X_5070_ _5070_/A1 _5074_/A2 _5070_/B _7249_/D VDD VDD VSS VSS gf180mcu_fd_sc_mcu7t5v0__aoi21_1
X_4021_ _4144_/A1 _4120_/A1 _4560_/A2 VDD VDD VSS VSS gf180mcu_fd_sc_mcu7t5v0__nand2_1
XFILLER_93_941 VDD VDD VSS VSS gf180mcu_fd_sc_mcu7t5v0__fillcap_32
XFILLER_77_481 VDD VDD VSS VSS gf180mcu_fd_sc_mcu7t5v0__fill_1
XFILLER_77_470 VDD VDD VSS VSS gf180mcu_fd_sc_mcu7t5v0__fill_1
X_5972_ _7159_/Q _6192_/A2 _6138_/B1 _7138_/Q _6174_/B _5973_/A2 VDD VDD VSS VSS gf180mcu_fd_sc_mcu7t5v0__oai221_1
X_7711_ _7711_/D _7711_/RN _7711_/CLK _7711_/Q VDD VDD VSS VSS gf180mcu_fd_sc_mcu7t5v0__dffrnq_1
XFILLER_33_540 VDD VDD VSS VSS gf180mcu_fd_sc_mcu7t5v0__fillcap_16
X_4923_ _7176_/Q _4924_/A2 _4924_/B VDD VDD VSS VSS gf180mcu_fd_sc_mcu7t5v0__nand2_1
XFILLER_21_702 VDD VDD VSS VSS gf180mcu_fd_sc_mcu7t5v0__fillcap_64
XFILLER_33_562 VDD VDD VSS VSS gf180mcu_fd_sc_mcu7t5v0__fillcap_64
X_7642_ _7642_/D _7782_/RN _7804_/CLK _7642_/Q VDD VDD VSS VSS gf180mcu_fd_sc_mcu7t5v0__dffrnq_1
X_4854_ _4952_/A1 _4854_/A2 _4854_/B _7141_/D VDD VDD VSS VSS gf180mcu_fd_sc_mcu7t5v0__oai21_1
X_7573_ _7573_/D _7614_/RN _7695_/CLK _7573_/Q VDD VDD VSS VSS gf180mcu_fd_sc_mcu7t5v0__dffrnq_1
X_3805_ _7766_/D _3804_/Z _7827_/Q _3850_/C VDD VDD VSS VSS gf180mcu_fd_sc_mcu7t5v0__aoi21_1
X_4785_ _7107_/Q _4798_/A2 _4786_/B VDD VDD VSS VSS gf180mcu_fd_sc_mcu7t5v0__nand2_1
XTAP_TAPCELL_ROW_99_1651 VDD VSS gf180mcu_fd_sc_mcu7t5v0__filltie
XTAP_TAPCELL_ROW_99_1640 VDD VSS gf180mcu_fd_sc_mcu7t5v0__filltie
X_6524_ _6538_/A1 _6523_/Z _7683_/D VDD VDD VSS VSS gf180mcu_fd_sc_mcu7t5v0__nor2_1
X_3736_ _5673_/A1 _5815_/C2 _3737_/A2 VDD VDD VSS VSS gf180mcu_fd_sc_mcu7t5v0__nand2_1
X_6455_ _6456_/A1 _6469_/A1 _6462_/B VDD VDD VSS VSS gf180mcu_fd_sc_mcu7t5v0__nor2_1
Xclkload71 _7266_/CLK clkload71/Z VDD VDD VSS VSS gf180mcu_fd_sc_mcu7t5v0__clkbuf_4
Xclkload60 _7118_/CLK clkload60/Z VDD VDD VSS VSS gf180mcu_fd_sc_mcu7t5v0__clkbuf_2
X_3667_ _7879_/I _7880_/I _5690_/A1 VDD VDD VSS VSS gf180mcu_fd_sc_mcu7t5v0__nor2_1
X_6386_ _7657_/Q _7523_/Q _6394_/B VDD VDD VSS VSS gf180mcu_fd_sc_mcu7t5v0__and2_1
X_5406_ _7367_/Q _5507_/B1 _5511_/C2 _7374_/Q _5531_/B _5407_/A2 VDD VDD VSS VSS gf180mcu_fd_sc_mcu7t5v0__oai221_1
X_3598_ _3592_/Z _3596_/Z _3597_/Z _3660_/C VDD VDD VSS VSS gf180mcu_fd_sc_mcu7t5v0__xor3_1
X_5337_ _5344_/I0 _7484_/Q _5337_/S _7484_/D VDD VDD VSS VSS gf180mcu_fd_sc_mcu7t5v0__mux2_2
XFILLER_76_908 VDD VDD VSS VSS gf180mcu_fd_sc_mcu7t5v0__fillcap_4
X_5268_ _5303_/I0 _7415_/Q _5274_/S _7415_/D VDD VDD VSS VSS gf180mcu_fd_sc_mcu7t5v0__mux2_2
X_7007_ _7007_/D _7276_/CLK _7007_/Q VDD VDD VSS VSS gf180mcu_fd_sc_mcu7t5v0__dffq_1
XFILLER_87_278 VDD VDD VSS VSS gf180mcu_fd_sc_mcu7t5v0__fill_2
X_4219_ _6651_/A1 _4219_/A2 _5302_/S VDD VDD VSS VSS gf180mcu_fd_sc_mcu7t5v0__nand2_1
XFILLER_84_941 VDD VDD VSS VSS gf180mcu_fd_sc_mcu7t5v0__fillcap_4
X_5199_ _6354_/I0 _7346_/Q _5204_/S _7346_/D VDD VDD VSS VSS gf180mcu_fd_sc_mcu7t5v0__mux2_2
XFILLER_28_334 VDD VDD VSS VSS gf180mcu_fd_sc_mcu7t5v0__fill_1
XFILLER_34_33 VDD VDD VSS VSS gf180mcu_fd_sc_mcu7t5v0__fill_2
XFILLER_3_422 VDD VDD VSS VSS gf180mcu_fd_sc_mcu7t5v0__fill_2
XFILLER_3_488 VDD VDD VSS VSS gf180mcu_fd_sc_mcu7t5v0__fill_2
XFILLER_75_941 VDD VDD VSS VSS gf180mcu_fd_sc_mcu7t5v0__fillcap_32
XTAP_TAPCELL_ROW_17_502 VDD VSS gf180mcu_fd_sc_mcu7t5v0__filltie
XFILLER_15_562 VDD VDD VSS VSS gf180mcu_fd_sc_mcu7t5v0__fillcap_64
XTAP_TAPCELL_ROW_45_888 VDD VSS gf180mcu_fd_sc_mcu7t5v0__filltie
X_4570_ _4584_/A1 _4574_/A2 _4570_/B _6999_/D VDD VDD VSS VSS gf180mcu_fd_sc_mcu7t5v0__oai21_1
X_3521_ _7822_/D _3903_/A1 _3525_/A1 VDD VDD VSS VSS gf180mcu_fd_sc_mcu7t5v0__nand2_1
XFILLER_7_772 VDD VDD VSS VSS gf180mcu_fd_sc_mcu7t5v0__fillcap_64
X_3452_ _7588_/Q _6272_/A1 VDD VDD VSS VSS gf180mcu_fd_sc_mcu7t5v0__clkinv_1
X_6240_ _6240_/A1 _6240_/A2 _6243_/B VDD VDD VSS VSS gf180mcu_fd_sc_mcu7t5v0__or2_1
XFILLER_97_510 VDD VDD VSS VSS gf180mcu_fd_sc_mcu7t5v0__fill_2
XTAP_TAPCELL_ROW_94_1581 VDD VSS gf180mcu_fd_sc_mcu7t5v0__filltie
XTAP_TAPCELL_ROW_94_1570 VDD VSS gf180mcu_fd_sc_mcu7t5v0__filltie
X_3383_ _3383_/I _3693_/A2 VDD VDD VSS VSS gf180mcu_fd_sc_mcu7t5v0__clkinv_1
X_6171_ _7239_/Q _6171_/A2 _6171_/B _6173_/A1 VDD VDD VSS VSS gf180mcu_fd_sc_mcu7t5v0__oai21_1
X_5122_ _5122_/A1 _5134_/A2 _5122_/B _7275_/D VDD VDD VSS VSS gf180mcu_fd_sc_mcu7t5v0__oai21_1
XFILLER_85_749 VDD VDD VSS VSS gf180mcu_fd_sc_mcu7t5v0__fillcap_8
X_5053_ _7241_/Q _5064_/A2 _5054_/B VDD VDD VSS VSS gf180mcu_fd_sc_mcu7t5v0__nand2_1
X_4004_ _6754_/Q _4476_/A2 _4005_/B VDD VDD VSS VSS gf180mcu_fd_sc_mcu7t5v0__nand2_1
X_5955_ _6886_/Q wire322/I _6140_/B1 _6893_/Q _6900_/Q _6141_/A2 _5958_/A2 VDD VDD
+ VSS VSS gf180mcu_fd_sc_mcu7t5v0__oai222_1
XFILLER_81_977 VDD VDD VSS VSS gf180mcu_fd_sc_mcu7t5v0__fill_2
XFILLER_34_871 VDD VDD VSS VSS gf180mcu_fd_sc_mcu7t5v0__fillcap_4
X_4906_ _4948_/A1 _4910_/A2 _4906_/B _7167_/D VDD VDD VSS VSS gf180mcu_fd_sc_mcu7t5v0__oai21_1
X_5886_ _7123_/Q _6097_/A2 _6215_/A2 _7102_/Q _6214_/B _5890_/A2 VDD VDD VSS VSS gf180mcu_fd_sc_mcu7t5v0__oai221_1
X_7625_ _7625_/D _7708_/RN _7711_/CLK _7625_/Q VDD VDD VSS VSS gf180mcu_fd_sc_mcu7t5v0__dffrnq_1
XFILLER_21_543 VDD VDD VSS VSS gf180mcu_fd_sc_mcu7t5v0__fillcap_16
X_4837_ _7133_/Q _4840_/A2 _4838_/B VDD VDD VSS VSS gf180mcu_fd_sc_mcu7t5v0__nand2_1
X_4768_ _4824_/A1 _4770_/A2 _4768_/B _7098_/D VDD VDD VSS VSS gf180mcu_fd_sc_mcu7t5v0__oai21_1
X_7556_ _7556_/D _7558_/RN _7780_/CLK _7556_/Q VDD VDD VSS VSS gf180mcu_fd_sc_mcu7t5v0__dffrnq_1
X_4699_ _7064_/Q _4700_/A2 _4700_/B VDD VDD VSS VSS gf180mcu_fd_sc_mcu7t5v0__nand2_1
X_6507_ _6508_/A1 _6508_/A2 _6516_/A4 VDD VDD VSS VSS gf180mcu_fd_sc_mcu7t5v0__nor2_1
X_7487_ _7487_/D _7491_/CLK _7487_/Q VDD VDD VSS VSS gf180mcu_fd_sc_mcu7t5v0__dffq_1
X_3719_ _3719_/I _3720_/A2 VDD VDD VSS VSS gf180mcu_fd_sc_mcu7t5v0__clkinv_1
X_6438_ _6438_/A1 _6438_/A2 _6438_/B _6438_/C _6440_/A3 VDD VDD VSS VSS gf180mcu_fd_sc_mcu7t5v0__oai211_1
XTAP_TAPCELL_ROW_54_1020 VDD VSS gf180mcu_fd_sc_mcu7t5v0__filltie
XFILLER_103_854 VDD VDD VSS VSS gf180mcu_fd_sc_mcu7t5v0__fill_2
X_6369_ _7651_/Q _6677_/A1 _6370_/B VDD VDD VSS VSS gf180mcu_fd_sc_mcu7t5v0__nand2_1
XFILLER_29_632 VDD VDD VSS VSS gf180mcu_fd_sc_mcu7t5v0__fillcap_64
XTAP_TAPCELL_ROW_3_296 VDD VSS gf180mcu_fd_sc_mcu7t5v0__filltie
XFILLER_72_933 VDD VDD VSS VSS gf180mcu_fd_sc_mcu7t5v0__fillcap_8
XTAP_TAPCELL_ROW_106_1739 VDD VSS gf180mcu_fd_sc_mcu7t5v0__filltie
XFILLER_44_679 VDD VDD VSS VSS gf180mcu_fd_sc_mcu7t5v0__fill_2
XTAP_TAPCELL_ROW_42_847 VDD VSS gf180mcu_fd_sc_mcu7t5v0__filltie
XTAP_TAPCELL_ROW_65_1171 VDD VSS gf180mcu_fd_sc_mcu7t5v0__filltie
XTAP_TAPCELL_ROW_22_560 VDD VSS gf180mcu_fd_sc_mcu7t5v0__filltie
XTAP_TAPCELL_ROW_22_571 VDD VSS gf180mcu_fd_sc_mcu7t5v0__filltie
XANTENNA_8 _5840_/B VDD VDD VSS VSS gf180mcu_fd_sc_mcu7t5v0__antenna
XFILLER_4_731 VDD VDD VSS VSS gf180mcu_fd_sc_mcu7t5v0__fillcap_4
XFILLER_94_535 VDD VDD VSS VSS gf180mcu_fd_sc_mcu7t5v0__fill_1
XFILLER_0_970 VDD VDD VSS VSS gf180mcu_fd_sc_mcu7t5v0__fillcap_8
Xclkbuf_leaf_40_clk_i clkload5/I _7266_/CLK VDD VDD VSS VSS gf180mcu_fd_sc_mcu7t5v0__clkbuf_8
XFILLER_16_871 VDD VDD VSS VSS gf180mcu_fd_sc_mcu7t5v0__fillcap_4
XFILLER_62_465 VDD VDD VSS VSS gf180mcu_fd_sc_mcu7t5v0__fill_1
XFILLER_63_977 VDD VDD VSS VSS gf180mcu_fd_sc_mcu7t5v0__fill_2
X_5740_ _5748_/A2 _5813_/A2 _3703_/Z _5742_/S VDD VDD VSS VSS gf180mcu_fd_sc_mcu7t5v0__or3_1
Xclkbuf_leaf_55_clk_i clkload4/I _7196_/CLK VDD VDD VSS VSS gf180mcu_fd_sc_mcu7t5v0__clkbuf_8
X_7410_ _7410_/D _7499_/CLK _7410_/Q VDD VDD VSS VSS gf180mcu_fd_sc_mcu7t5v0__dffq_1
XFILLER_30_373 VDD VDD VSS VSS gf180mcu_fd_sc_mcu7t5v0__fill_2
X_5671_ _7549_/Q input35/Z _5675_/S _7549_/D VDD VDD VSS VSS gf180mcu_fd_sc_mcu7t5v0__mux2_2
X_4622_ _4748_/A1 _4630_/A2 _4622_/B _7025_/D VDD VDD VSS VSS gf180mcu_fd_sc_mcu7t5v0__oai21_1
X_4553_ _6991_/Q _4560_/A2 _4554_/B VDD VDD VSS VSS gf180mcu_fd_sc_mcu7t5v0__nand2_1
X_7341_ _7341_/D clkload9/I _7341_/Q VDD VDD VSS VSS gf180mcu_fd_sc_mcu7t5v0__dffq_1
X_4484_ _4540_/A1 _4490_/A2 _4484_/B _6956_/D VDD VDD VSS VSS gf180mcu_fd_sc_mcu7t5v0__oai21_1
X_7272_ _7272_/D _7279_/CLK _7272_/Q VDD VDD VSS VSS gf180mcu_fd_sc_mcu7t5v0__dffq_1
X_3504_ _6231_/C _7724_/Q _3504_/Z VDD VDD VSS VSS gf180mcu_fd_sc_mcu7t5v0__xor2_1
X_6223_ _6223_/A1 _6223_/A2 _6231_/A1 VDD VDD VSS VSS gf180mcu_fd_sc_mcu7t5v0__nor2_1
X_3435_ _7516_/Q _5630_/A1 VDD VDD VSS VSS gf180mcu_fd_sc_mcu7t5v0__clkinv_1
XFILLER_98_852 VDD VDD VSS VSS gf180mcu_fd_sc_mcu7t5v0__fillcap_4
X_6154_ _7029_/Q _6154_/A2 wire313/I _7022_/Q _6208_/C _6155_/A2 VDD VDD VSS VSS gf180mcu_fd_sc_mcu7t5v0__oai221_1
X_3366_ _6171_/B wire454/I VDD VDD VSS VSS gf180mcu_fd_sc_mcu7t5v0__clkinv_1
XFILLER_100_824 VDD VDD VSS VSS gf180mcu_fd_sc_mcu7t5v0__fillcap_8
X_6085_ _7147_/Q _6167_/B1 _6085_/B1 _7224_/Q _7259_/Q wire355/Z _6086_/I VDD VDD
+ VSS VSS gf180mcu_fd_sc_mcu7t5v0__oai222_1
X_5105_ _7267_/Q _5106_/A2 _5106_/B VDD VDD VSS VSS gf180mcu_fd_sc_mcu7t5v0__nand2_1
Xload_slew483 _6202_/B _6224_/B VDD VDD VSS VSS gf180mcu_fd_sc_mcu7t5v0__buf_4
Xload_slew450 wire449/I _6174_/B VDD VDD VSS VSS gf180mcu_fd_sc_mcu7t5v0__clkbuf_4
X_5036_ _5078_/A1 _5036_/A2 _5036_/B _7232_/D VDD VDD VSS VSS gf180mcu_fd_sc_mcu7t5v0__oai21_1
Xload_slew494 _6236_/C _6171_/B VDD VDD VSS VSS gf180mcu_fd_sc_mcu7t5v0__buf_4
XFILLER_81_730 VDD VDD VSS VSS gf180mcu_fd_sc_mcu7t5v0__fill_1
XTAP_TAPCELL_ROW_0_244 VDD VSS gf180mcu_fd_sc_mcu7t5v0__filltie
X_6987_ _6987_/D _7002_/CLK _6987_/Q VDD VDD VSS VSS gf180mcu_fd_sc_mcu7t5v0__dffq_1
XTAP_TAPCELL_ROW_0_255 VDD VSS gf180mcu_fd_sc_mcu7t5v0__filltie
X_5938_ _6184_/C _5938_/A2 _5938_/A3 _5939_/A3 VDD VDD VSS VSS gf180mcu_fd_sc_mcu7t5v0__nand3_1
XTAP_TAPCELL_ROW_101_1669 VDD VSS gf180mcu_fd_sc_mcu7t5v0__filltie
X_5869_ _7248_/Q _6235_/A2 _6236_/C _5873_/A2 VDD VDD VSS VSS gf180mcu_fd_sc_mcu7t5v0__oai21_1
X_7608_ _7608_/D _7611_/RN _7670_/CLK _7608_/Q VDD VDD VSS VSS gf180mcu_fd_sc_mcu7t5v0__dffrnq_1
X_7539_ _7539_/D _7652_/RN _7790_/CLK _7539_/Q VDD VDD VSS VSS gf180mcu_fd_sc_mcu7t5v0__dffrnq_1
XFILLER_108_979 VDD VDD VSS VSS gf180mcu_fd_sc_mcu7t5v0__fill_2
XFILLER_107_445 VDD VDD VSS VSS gf180mcu_fd_sc_mcu7t5v0__fill_1
XFILLER_107_434 VDD VDD VSS VSS gf180mcu_fd_sc_mcu7t5v0__fill_1
Xinput101 tl_i[94] _3563_/A1 VDD VDD VSS VSS gf180mcu_fd_sc_mcu7t5v0__dlyd_1
XTAP_TAPCELL_ROW_8_377 VDD VSS gf180mcu_fd_sc_mcu7t5v0__filltie
XTAP_TAPCELL_ROW_8_366 VDD VSS gf180mcu_fd_sc_mcu7t5v0__filltie
XFILLER_91_505 VDD VDD VSS VSS gf180mcu_fd_sc_mcu7t5v0__fill_2
XTAP_TAPCELL_ROW_47_917 VDD VSS gf180mcu_fd_sc_mcu7t5v0__filltie
XTAP_TAPCELL_ROW_67_1200 VDD VSS gf180mcu_fd_sc_mcu7t5v0__filltie
XPHY_EDGE_ROW_113_Right_113 VDD VSS gf180mcu_fd_sc_mcu7t5v0__endcap
XTAP_TAPCELL_ROW_27_630 VDD VSS gf180mcu_fd_sc_mcu7t5v0__filltie
XTAP_TAPCELL_ROW_27_641 VDD VSS gf180mcu_fd_sc_mcu7t5v0__filltie
XFILLER_71_251 VDD VDD VSS VSS gf180mcu_fd_sc_mcu7t5v0__fill_1
XFILLER_60_947 VDD VDD VSS VSS gf180mcu_fd_sc_mcu7t5v0__fillcap_32
XTAP_TAPCELL_ROW_78_1351 VDD VSS gf180mcu_fd_sc_mcu7t5v0__filltie
XFILLER_95_855 VDD VDD VSS VSS gf180mcu_fd_sc_mcu7t5v0__fill_2
X_6910_ _6910_/D _6939_/CLK _6910_/Q VDD VDD VSS VSS gf180mcu_fd_sc_mcu7t5v0__dffq_1
X_6841_ _6841_/D _7683_/CLK _6841_/Q VDD VDD VSS VSS gf180mcu_fd_sc_mcu7t5v0__dffq_1
XFILLER_51_903 VDD VDD VSS VSS gf180mcu_fd_sc_mcu7t5v0__fillcap_4
XFILLER_35_487 VDD VDD VSS VSS gf180mcu_fd_sc_mcu7t5v0__fill_2
X_3984_ _4012_/A1 _3999_/A2 _4392_/A2 VDD VDD VSS VSS gf180mcu_fd_sc_mcu7t5v0__nand2_1
X_6772_ _6772_/D _7118_/CLK _6772_/Q VDD VDD VSS VSS gf180mcu_fd_sc_mcu7t5v0__dffq_1
X_5723_ _6337_/A1 _7685_/Q _6347_/A1 _7692_/Q _5723_/C _5724_/C VDD VDD VSS VSS gf180mcu_fd_sc_mcu7t5v0__oai221_1
XFILLER_22_159 VDD VDD VSS VSS gf180mcu_fd_sc_mcu7t5v0__fill_1
X_5654_ input32/Z _5663_/S _5655_/B VDD VDD VSS VSS gf180mcu_fd_sc_mcu7t5v0__nand2_1
X_4605_ _7017_/Q _4616_/A2 _4606_/B VDD VDD VSS VSS gf180mcu_fd_sc_mcu7t5v0__nand2_1
X_7324_ _7324_/D _7489_/CLK _7324_/Q VDD VDD VSS VSS gf180mcu_fd_sc_mcu7t5v0__dffq_1
X_5585_ _5366_/Z _5584_/Z _5587_/C VDD VDD VSS VSS gf180mcu_fd_sc_mcu7t5v0__nand2_1
X_4536_ _5124_/A1 _4546_/A2 _4536_/B _6982_/D VDD VDD VSS VSS gf180mcu_fd_sc_mcu7t5v0__oai21_1
XFILLER_105_916 VDD VDD VSS VSS gf180mcu_fd_sc_mcu7t5v0__fillcap_64
X_4467_ _6948_/Q _4476_/A2 _4468_/B VDD VDD VSS VSS gf180mcu_fd_sc_mcu7t5v0__nand2_1
X_7255_ _7255_/D _7266_/CLK _7255_/Q VDD VDD VSS VSS gf180mcu_fd_sc_mcu7t5v0__dffq_1
X_6206_ _6206_/A1 _6206_/A2 _6210_/A2 VDD VDD VSS VSS gf180mcu_fd_sc_mcu7t5v0__nor2_1
X_4398_ _4832_/A1 _4406_/A2 _4398_/B _6913_/D VDD VDD VSS VSS gf180mcu_fd_sc_mcu7t5v0__oai21_1
X_3418_ _7565_/Q _5699_/A1 VDD VDD VSS VSS gf180mcu_fd_sc_mcu7t5v0__clkinv_1
X_7186_ _7186_/D _7719_/CLK _7186_/Q VDD VDD VSS VSS gf180mcu_fd_sc_mcu7t5v0__dffq_1
X_6137_ _6994_/Q wire353/I _6191_/B _6139_/A1 VDD VDD VSS VSS gf180mcu_fd_sc_mcu7t5v0__oai21_1
XTAP_TAPCELL_ROW_5_325 VDD VSS gf180mcu_fd_sc_mcu7t5v0__filltie
Xload_slew280 _5122_/A1 _4506_/A1 VDD VDD VSS VSS gf180mcu_fd_sc_mcu7t5v0__clkbuf_4
XFILLER_86_866 VDD VDD VSS VSS gf180mcu_fd_sc_mcu7t5v0__fill_1
X_6068_ _7576_/Q _6303_/S _6068_/B _6069_/I VDD VDD VSS VSS gf180mcu_fd_sc_mcu7t5v0__oai21_1
X_5019_ _7224_/Q _5022_/A2 _5020_/B VDD VDD VSS VSS gf180mcu_fd_sc_mcu7t5v0__nand2_1
XFILLER_81_571 VDD VDD VSS VSS gf180mcu_fd_sc_mcu7t5v0__fill_2
XTAP_TAPCELL_ROW_24_600 VDD VSS gf180mcu_fd_sc_mcu7t5v0__filltie
XFILLER_41_413 VDD VDD VSS VSS gf180mcu_fd_sc_mcu7t5v0__fill_2
XFILLER_42_947 VDD VDD VSS VSS gf180mcu_fd_sc_mcu7t5v0__fillcap_32
XTAP_TAPCELL_ROW_62_1130 VDD VSS gf180mcu_fd_sc_mcu7t5v0__filltie
XTAP_TAPCELL_ROW_52_986 VDD VSS gf180mcu_fd_sc_mcu7t5v0__filltie
XTAP_TAPCELL_ROW_118_1930 VDD VSS gf180mcu_fd_sc_mcu7t5v0__filltie
XFILLER_10_877 VDD VDD VSS VSS gf180mcu_fd_sc_mcu7t5v0__fillcap_64
XFILLER_5_325 VDD VDD VSS VSS gf180mcu_fd_sc_mcu7t5v0__fill_2
XPHY_EDGE_ROW_2_Left_121 VDD VSS gf180mcu_fd_sc_mcu7t5v0__endcap
XPHY_EDGE_ROW_39_Left_158 VDD VSS gf180mcu_fd_sc_mcu7t5v0__endcap
XTAP_TAPCELL_ROW_114_1849 VDD VSS gf180mcu_fd_sc_mcu7t5v0__filltie
XFILLER_77_811 VDD VDD VSS VSS gf180mcu_fd_sc_mcu7t5v0__fill_1
XTAP_TAPCELL_ROW_73_1281 VDD VSS gf180mcu_fd_sc_mcu7t5v0__filltie
XFILLER_103_492 VDD VDD VSS VSS gf180mcu_fd_sc_mcu7t5v0__fill_1
XFILLER_92_847 VDD VDD VSS VSS gf180mcu_fd_sc_mcu7t5v0__fillcap_16
XFILLER_64_527 VDD VDD VSS VSS gf180mcu_fd_sc_mcu7t5v0__fill_1
XFILLER_45_763 VDD VDD VSS VSS gf180mcu_fd_sc_mcu7t5v0__fillcap_4
XPHY_EDGE_ROW_48_Left_167 VDD VSS gf180mcu_fd_sc_mcu7t5v0__endcap
XFILLER_8_174 VDD VDD VSS VSS gf180mcu_fd_sc_mcu7t5v0__fill_1
XPHY_EDGE_ROW_57_Left_176 VDD VSS gf180mcu_fd_sc_mcu7t5v0__endcap
X_5370_ _7324_/Q _5453_/C2 _5558_/B _5375_/A1 VDD VDD VSS VSS gf180mcu_fd_sc_mcu7t5v0__oai21_1
XTAP_TAPCELL_ROW_10_393 VDD VSS gf180mcu_fd_sc_mcu7t5v0__filltie
X_4321_ _6875_/Q _4322_/A2 _4322_/B VDD VDD VSS VSS gf180mcu_fd_sc_mcu7t5v0__nand2_1
X_7040_ _7040_/D _7261_/CLK _7040_/Q VDD VDD VSS VSS gf180mcu_fd_sc_mcu7t5v0__dffq_1
X_4252_ _5078_/A1 _4252_/A2 _4252_/B _6840_/D VDD VDD VSS VSS gf180mcu_fd_sc_mcu7t5v0__oai21_1
XFILLER_110_941 VDD VDD VSS VSS gf180mcu_fd_sc_mcu7t5v0__fillcap_4
X_4183_ _4235_/A1 _4189_/A2 _5190_/S VDD VDD VSS VSS gf180mcu_fd_sc_mcu7t5v0__nand2_1
XPHY_EDGE_ROW_66_Left_185 VDD VSS gf180mcu_fd_sc_mcu7t5v0__endcap
XFILLER_68_877 VDD VDD VSS VSS gf180mcu_fd_sc_mcu7t5v0__fill_1
XFILLER_82_313 VDD VDD VSS VSS gf180mcu_fd_sc_mcu7t5v0__fill_2
XFILLER_24_947 VDD VDD VSS VSS gf180mcu_fd_sc_mcu7t5v0__fillcap_32
XFILLER_35_273 VDD VDD VSS VSS gf180mcu_fd_sc_mcu7t5v0__fill_1
X_6824_ _6824_/D _7823_/CLK _6824_/Q VDD VDD VSS VSS gf180mcu_fd_sc_mcu7t5v0__dffq_1
X_6755_ _6755_/D _7002_/CLK _6755_/Q VDD VDD VSS VSS gf180mcu_fd_sc_mcu7t5v0__dffq_1
XFILLER_51_777 VDD VDD VSS VSS gf180mcu_fd_sc_mcu7t5v0__fillcap_4
X_3967_ _3967_/I _4138_/A2 VDD VDD VSS VSS gf180mcu_fd_sc_mcu7t5v0__clkinv_1
X_5706_ _6330_/A1 _7680_/Q _6343_/A1 _7689_/Q _5708_/A3 VDD VDD VSS VSS gf180mcu_fd_sc_mcu7t5v0__oai22_1
XPHY_EDGE_ROW_75_Left_194 VDD VSS gf180mcu_fd_sc_mcu7t5v0__endcap
X_3898_ _7776_/Q _7778_/Q _3899_/S VDD VDD VSS VSS gf180mcu_fd_sc_mcu7t5v0__nor2_1
X_6686_ _6672_/Z _6686_/A2 _6687_/A2 VDD VDD VSS VSS gf180mcu_fd_sc_mcu7t5v0__nand2_1
X_5637_ _7520_/Q input35/Z _5663_/S _7520_/D VDD VDD VSS VSS gf180mcu_fd_sc_mcu7t5v0__mux2_2
XFILLER_117_562 VDD VDD VSS VSS gf180mcu_fd_sc_mcu7t5v0__fill_1
XFILLER_105_702 VDD VDD VSS VSS gf180mcu_fd_sc_mcu7t5v0__fill_2
X_5568_ _7463_/Q wire428/Z _5606_/B1 _7365_/Q _5569_/A3 VDD VDD VSS VSS gf180mcu_fd_sc_mcu7t5v0__oai22_1
X_4519_ _6974_/Q _4532_/A2 _4520_/B VDD VDD VSS VSS gf180mcu_fd_sc_mcu7t5v0__nand2_1
XFILLER_105_713 VDD VDD VSS VSS gf180mcu_fd_sc_mcu7t5v0__fill_2
X_7307_ _7307_/D _7500_/CLK _7307_/Q VDD VDD VSS VSS gf180mcu_fd_sc_mcu7t5v0__dffq_1
XFILLER_2_317 VDD VDD VSS VSS gf180mcu_fd_sc_mcu7t5v0__fill_2
XFILLER_78_619 VDD VDD VSS VSS gf180mcu_fd_sc_mcu7t5v0__fill_2
X_5499_ _5499_/A1 _5499_/A2 _5522_/A1 VDD VDD VSS VSS gf180mcu_fd_sc_mcu7t5v0__nor2_1
X_7238_ _7238_/D _7252_/CLK _7238_/Q VDD VDD VSS VSS gf180mcu_fd_sc_mcu7t5v0__dffq_1
X_7169_ _7169_/D _7748_/CLK _7169_/Q VDD VDD VSS VSS gf180mcu_fd_sc_mcu7t5v0__dffq_1
XFILLER_59_855 VDD VDD VSS VSS gf180mcu_fd_sc_mcu7t5v0__fillcap_8
XFILLER_46_527 VDD VDD VSS VSS gf180mcu_fd_sc_mcu7t5v0__fill_1
XTAP_TAPCELL_ROW_37_780 VDD VSS gf180mcu_fd_sc_mcu7t5v0__filltie
XFILLER_54_593 VDD VDD VSS VSS gf180mcu_fd_sc_mcu7t5v0__fill_2
XFILLER_41_265 VDD VDD VSS VSS gf180mcu_fd_sc_mcu7t5v0__fill_1
XTAP_TAPCELL_ROW_75_1310 VDD VSS gf180mcu_fd_sc_mcu7t5v0__filltie
XFILLER_6_667 VDD VDD VSS VSS gf180mcu_fd_sc_mcu7t5v0__fillcap_64
XFILLER_77_696 VDD VDD VSS VSS gf180mcu_fd_sc_mcu7t5v0__fillcap_4
XFILLER_80_817 VDD VDD VSS VSS gf180mcu_fd_sc_mcu7t5v0__fillcap_4
XTAP_TAPCELL_ROW_86_1461 VDD VSS gf180mcu_fd_sc_mcu7t5v0__filltie
X_4870_ _5066_/A1 _4882_/A2 _4870_/B _7149_/D VDD VDD VSS VSS gf180mcu_fd_sc_mcu7t5v0__oai21_1
X_3821_ _7590_/Q _7589_/Q _3821_/Z VDD VDD VSS VSS gf180mcu_fd_sc_mcu7t5v0__xor2_1
XFILLER_21_906 VDD VDD VSS VSS gf180mcu_fd_sc_mcu7t5v0__fillcap_4
XFILLER_32_243 VDD VDD VSS VSS gf180mcu_fd_sc_mcu7t5v0__fill_2
XFILLER_33_766 VDD VDD VSS VSS gf180mcu_fd_sc_mcu7t5v0__fillcap_4
XFILLER_60_552 VDD VDD VSS VSS gf180mcu_fd_sc_mcu7t5v0__fill_2
XFILLER_20_416 VDD VDD VSS VSS gf180mcu_fd_sc_mcu7t5v0__fill_1
XTAP_TAPCELL_ROW_15_474 VDD VSS gf180mcu_fd_sc_mcu7t5v0__filltie
XTAP_TAPCELL_ROW_15_463 VDD VSS gf180mcu_fd_sc_mcu7t5v0__filltie
X_6540_ _7689_/Q _6537_/Z _6540_/Z VDD VDD VSS VSS gf180mcu_fd_sc_mcu7t5v0__and2_1
X_3752_ _7801_/D _3756_/B1 _3752_/B _3755_/B1 VDD VDD VSS VSS gf180mcu_fd_sc_mcu7t5v0__aoi21_1
XFILLER_118_337 VDD VDD VSS VSS gf180mcu_fd_sc_mcu7t5v0__fill_2
X_6471_ _7669_/Q _6470_/Z _6479_/S _7669_/D VDD VDD VSS VSS gf180mcu_fd_sc_mcu7t5v0__mux2_2
X_3683_ _3682_/C _3683_/A2 _3683_/B _3683_/C _3686_/A2 VDD VDD VSS VSS gf180mcu_fd_sc_mcu7t5v0__aoi211_1
X_5422_ _7325_/Q _5535_/C2 _5562_/A2 _7318_/Q _7311_/Q _5516_/C2 _5423_/A2 VDD VDD
+ VSS VSS gf180mcu_fd_sc_mcu7t5v0__oai222_1
X_5353_ _7640_/Q _7500_/Q _5358_/S _7500_/D VDD VDD VSS VSS gf180mcu_fd_sc_mcu7t5v0__mux2_2
XFILLER_88_906 VDD VDD VSS VSS gf180mcu_fd_sc_mcu7t5v0__fill_1
X_4304_ _5130_/A1 _4308_/A2 _4304_/B _6866_/D VDD VDD VSS VSS gf180mcu_fd_sc_mcu7t5v0__oai21_1
X_5284_ _5354_/I0 _7431_/Q _5288_/S _7431_/D VDD VDD VSS VSS gf180mcu_fd_sc_mcu7t5v0__mux2_2
X_7023_ _7023_/D _7062_/CLK _7023_/Q VDD VDD VSS VSS gf180mcu_fd_sc_mcu7t5v0__dffq_1
X_4235_ _4235_/A1 _4237_/A1 _5351_/S VDD VDD VSS VSS gf180mcu_fd_sc_mcu7t5v0__nand2_1
XFILLER_68_630 VDD VDD VSS VSS gf180mcu_fd_sc_mcu7t5v0__fill_1
X_4166_ _7732_/Q _7733_/Q _4221_/A2 VDD VDD VSS VSS gf180mcu_fd_sc_mcu7t5v0__nand2_1
X_4097_ _4112_/A1 _4882_/A2 _4097_/B _6783_/D VDD VDD VSS VSS gf180mcu_fd_sc_mcu7t5v0__oai21_1
XFILLER_71_839 VDD VDD VSS VSS gf180mcu_fd_sc_mcu7t5v0__fill_1
XFILLER_71_828 VDD VDD VSS VSS gf180mcu_fd_sc_mcu7t5v0__fill_1
X_6807_ _6807_/D _7492_/CLK _6807_/Q VDD VDD VSS VSS gf180mcu_fd_sc_mcu7t5v0__dffq_1
XPHY_EDGE_ROW_83_Left_202 VDD VSS gf180mcu_fd_sc_mcu7t5v0__endcap
X_7787_ input5/Z _7760_/RN _7790_/CLK _7788_/D VDD VDD VSS VSS gf180mcu_fd_sc_mcu7t5v0__dffsnq_1
X_4999_ _7214_/Q _5008_/A2 _5000_/B VDD VDD VSS VSS gf180mcu_fd_sc_mcu7t5v0__nand2_1
X_6738_ _6738_/D _7070_/CLK _6738_/Q VDD VDD VSS VSS gf180mcu_fd_sc_mcu7t5v0__dffq_1
X_6669_ _7741_/Q _3787_/Z _6671_/A1 VDD VDD VSS VSS gf180mcu_fd_sc_mcu7t5v0__nor2_1
XFILLER_3_626 VDD VDD VSS VSS gf180mcu_fd_sc_mcu7t5v0__fillcap_4
XTAP_TAPCELL_ROW_111_1819 VDD VSS gf180mcu_fd_sc_mcu7t5v0__filltie
XTAP_TAPCELL_ROW_111_1808 VDD VSS gf180mcu_fd_sc_mcu7t5v0__filltie
XTAP_TAPCELL_ROW_57_1051 VDD VSS gf180mcu_fd_sc_mcu7t5v0__filltie
XTAP_TAPCELL_ROW_57_1062 VDD VSS gf180mcu_fd_sc_mcu7t5v0__filltie
XPHY_EDGE_ROW_92_Left_211 VDD VSS gf180mcu_fd_sc_mcu7t5v0__endcap
XTAP_TAPCELL_ROW_70_1240 VDD VSS gf180mcu_fd_sc_mcu7t5v0__filltie
Xfanout451 wire454/I _6232_/B VDD VDD VSS VSS gf180mcu_fd_sc_mcu7t5v0__dlyd_1
Xfanout484 wire487/I _6237_/B VDD VDD VSS VSS gf180mcu_fd_sc_mcu7t5v0__dlyd_1
Xfanout473 _6124_/S _6603_/A1 VDD VDD VSS VSS gf180mcu_fd_sc_mcu7t5v0__dlyd_1
Xfanout495 _6204_/B _6195_/C VDD VDD VSS VSS gf180mcu_fd_sc_mcu7t5v0__dlyd_1
XFILLER_48_98 VDD VDD VSS VSS gf180mcu_fd_sc_mcu7t5v0__fill_1
XFILLER_15_766 VDD VDD VSS VSS gf180mcu_fd_sc_mcu7t5v0__fillcap_4
XTAP_TAPCELL_ROW_32_709 VDD VSS gf180mcu_fd_sc_mcu7t5v0__filltie
XTAP_TAPCELL_ROW_81_1391 VDD VSS gf180mcu_fd_sc_mcu7t5v0__filltie
XTAP_TAPCELL_ROW_12_433 VDD VSS gf180mcu_fd_sc_mcu7t5v0__filltie
XTAP_TAPCELL_ROW_12_422 VDD VSS gf180mcu_fd_sc_mcu7t5v0__filltie
XFILLER_7_976 VDD VDD VSS VSS gf180mcu_fd_sc_mcu7t5v0__fillcap_4
XFILLER_97_769 VDD VDD VSS VSS gf180mcu_fd_sc_mcu7t5v0__fill_1
X_4020_ _4029_/A1 _4546_/A2 _4020_/B _6759_/D VDD VDD VSS VSS gf180mcu_fd_sc_mcu7t5v0__oai21_1
XFILLER_65_600 VDD VDD VSS VSS gf180mcu_fd_sc_mcu7t5v0__fill_1
X_5971_ _7152_/Q _6104_/A2 _6104_/B1 _7131_/Q _5973_/A1 VDD VDD VSS VSS gf180mcu_fd_sc_mcu7t5v0__oai22_1
X_7710_ _7710_/D _7710_/RN _7710_/CLK _7710_/Q VDD VDD VSS VSS gf180mcu_fd_sc_mcu7t5v0__dffrnq_1
X_4922_ _4950_/A1 _4924_/A2 _4922_/B _7175_/D VDD VDD VSS VSS gf180mcu_fd_sc_mcu7t5v0__oai21_1
X_7641_ _7641_/D _7782_/RN _7782_/CLK _7641_/Q VDD VDD VSS VSS gf180mcu_fd_sc_mcu7t5v0__dffrnq_1
X_4853_ _7141_/Q _4854_/A2 _4854_/B VDD VDD VSS VSS gf180mcu_fd_sc_mcu7t5v0__nand2_1
X_7572_ _7572_/D _7589_/RN _7711_/CLK _7572_/Q VDD VDD VSS VSS gf180mcu_fd_sc_mcu7t5v0__dffrnq_1
X_3804_ _7767_/Q _7768_/Q _3804_/A3 _3804_/Z VDD VDD VSS VSS gf180mcu_fd_sc_mcu7t5v0__or3_1
X_4784_ _5008_/A1 _4784_/A2 _4784_/B _7106_/D VDD VDD VSS VSS gf180mcu_fd_sc_mcu7t5v0__oai21_1
XTAP_TAPCELL_ROW_99_1641 VDD VSS gf180mcu_fd_sc_mcu7t5v0__filltie
X_6523_ _7683_/Q _6523_/A2 _6523_/Z VDD VDD VSS VSS gf180mcu_fd_sc_mcu7t5v0__xor2_1
X_3735_ _3735_/A1 _3735_/A2 _5815_/C2 VDD VDD VSS VSS gf180mcu_fd_sc_mcu7t5v0__nand2_1
X_6454_ _6436_/Z _6440_/Z _6454_/A3 _6454_/B _6469_/A1 VDD VDD VSS VSS gf180mcu_fd_sc_mcu7t5v0__oai31_1
Xclkload61 _7252_/CLK clkload61/Z VDD VDD VSS VSS gf180mcu_fd_sc_mcu7t5v0__clkbuf_2
X_5405_ _7388_/Q _5604_/A2 _5572_/C2 _7381_/Q _5407_/A1 VDD VDD VSS VSS gf180mcu_fd_sc_mcu7t5v0__oai22_1
X_3666_ _3666_/A1 _3666_/A2 _3666_/B _3775_/A2 VDD VDD VSS VSS gf180mcu_fd_sc_mcu7t5v0__aoi21_1
Xclkload50 _7719_/CLK clkload50/ZN VDD VDD VSS VSS gf180mcu_fd_sc_mcu7t5v0__inv_2
X_6385_ _6451_/A2 _6383_/Z _6385_/B _7656_/D VDD VDD VSS VSS gf180mcu_fd_sc_mcu7t5v0__oai21_1
Xclkload72 _7267_/CLK clkload72/ZN VDD VDD VSS VSS gf180mcu_fd_sc_mcu7t5v0__inv_2
X_3597_ _3593_/Z _3594_/Z _3595_/Z _3597_/Z VDD VDD VSS VSS gf180mcu_fd_sc_mcu7t5v0__xor3_1
XFILLER_88_725 VDD VDD VSS VSS gf180mcu_fd_sc_mcu7t5v0__fill_2
X_5336_ _5343_/I0 _7483_/Q _5337_/S _7483_/D VDD VDD VSS VSS gf180mcu_fd_sc_mcu7t5v0__mux2_2
XFILLER_114_384 VDD VDD VSS VSS gf180mcu_fd_sc_mcu7t5v0__fill_1
X_5267_ _5309_/I0 _7414_/Q _5267_/S _7414_/D VDD VDD VSS VSS gf180mcu_fd_sc_mcu7t5v0__mux2_2
X_7006_ _7006_/D _7668_/CLK _7006_/Q VDD VDD VSS VSS gf180mcu_fd_sc_mcu7t5v0__dffq_1
X_4218_ wire507/Z _6824_/Q _5295_/S _6824_/D VDD VDD VSS VSS gf180mcu_fd_sc_mcu7t5v0__mux2_2
X_5198_ _6353_/I0 _7345_/Q _5204_/S _7345_/D VDD VDD VSS VSS gf180mcu_fd_sc_mcu7t5v0__mux2_2
XFILLER_29_836 VDD VDD VSS VSS gf180mcu_fd_sc_mcu7t5v0__fillcap_4
X_4149_ wire248/Z _5120_/A2 _4149_/B _6800_/D VDD VDD VSS VSS gf180mcu_fd_sc_mcu7t5v0__oai21_1
XTAP_TAPCELL_ROW_108_1770 VDD VSS gf180mcu_fd_sc_mcu7t5v0__filltie
XFILLER_43_349 VDD VDD VSS VSS gf180mcu_fd_sc_mcu7t5v0__fill_1
XFILLER_34_45 VDD VDD VSS VSS gf180mcu_fd_sc_mcu7t5v0__fill_1
XFILLER_24_574 VDD VDD VSS VSS gf180mcu_fd_sc_mcu7t5v0__fillcap_16
Xclkload0 clkload0/I clkload0/ZN VDD VDD VSS VSS gf180mcu_fd_sc_mcu7t5v0__inv_4
XFILLER_11_279 VDD VDD VSS VSS gf180mcu_fd_sc_mcu7t5v0__fill_1
XFILLER_106_852 VDD VDD VSS VSS gf180mcu_fd_sc_mcu7t5v0__fill_1
XFILLER_106_874 VDD VDD VSS VSS gf180mcu_fd_sc_mcu7t5v0__fill_1
XFILLER_4_979 VDD VDD VSS VSS gf180mcu_fd_sc_mcu7t5v0__fill_2
XFILLER_94_739 VDD VDD VSS VSS gf180mcu_fd_sc_mcu7t5v0__fill_1
Xfanout281 wire283/Z _5080_/A1 VDD VDD VSS VSS gf180mcu_fd_sc_mcu7t5v0__dlyd_1
XFILLER_47_611 VDD VDD VSS VSS gf180mcu_fd_sc_mcu7t5v0__fill_1
Xfanout270 _3856_/ZN _4984_/A1 VDD VDD VSS VSS gf180mcu_fd_sc_mcu7t5v0__dlyd_1
XFILLER_19_324 VDD VDD VSS VSS gf180mcu_fd_sc_mcu7t5v0__fill_2
XTAP_TAPCELL_ROW_17_503 VDD VSS gf180mcu_fd_sc_mcu7t5v0__filltie
XFILLER_47_677 VDD VDD VSS VSS gf180mcu_fd_sc_mcu7t5v0__fill_1
XTAP_TAPCELL_ROW_83_1420 VDD VSS gf180mcu_fd_sc_mcu7t5v0__filltie
XTAP_TAPCELL_ROW_45_889 VDD VSS gf180mcu_fd_sc_mcu7t5v0__filltie
X_3520_ _7777_/Q _3903_/A1 _7775_/D VDD VDD VSS VSS gf180mcu_fd_sc_mcu7t5v0__and2_1
X_3451_ _7591_/Q _6278_/A1 VDD VDD VSS VSS gf180mcu_fd_sc_mcu7t5v0__clkinv_1
X_6170_ _6196_/B _6170_/A2 _6170_/A3 _6170_/B1 _6170_/B2 _6184_/A2 VDD VDD VSS VSS
+ gf180mcu_fd_sc_mcu7t5v0__oai32_1
XTAP_TAPCELL_ROW_94_1571 VDD VSS gf180mcu_fd_sc_mcu7t5v0__filltie
X_3382_ _7882_/I _3696_/A2 VDD VDD VSS VSS gf180mcu_fd_sc_mcu7t5v0__clkinv_1
X_5121_ _7275_/Q _5134_/A2 _5122_/B VDD VDD VSS VSS gf180mcu_fd_sc_mcu7t5v0__nand2_1
XFILLER_34_2 VDD VDD VSS VSS gf180mcu_fd_sc_mcu7t5v0__fill_1
XFILLER_112_877 VDD VDD VSS VSS gf180mcu_fd_sc_mcu7t5v0__fillcap_64
X_5052_ _5066_/A1 _5064_/A2 _5052_/B _7240_/D VDD VDD VSS VSS gf180mcu_fd_sc_mcu7t5v0__oai21_1
XFILLER_69_279 VDD VDD VSS VSS gf180mcu_fd_sc_mcu7t5v0__fill_1
X_4003_ _4147_/A1 _4027_/A2 _4476_/A2 VDD VDD VSS VSS gf180mcu_fd_sc_mcu7t5v0__nand2_1
XFILLER_93_772 VDD VDD VSS VSS gf180mcu_fd_sc_mcu7t5v0__fill_2
XFILLER_25_349 VDD VDD VSS VSS gf180mcu_fd_sc_mcu7t5v0__fill_1
XFILLER_37_198 VDD VDD VSS VSS gf180mcu_fd_sc_mcu7t5v0__fill_1
X_5954_ _6907_/Q _6087_/A2 _6084_/C _5958_/A1 VDD VDD VSS VSS gf180mcu_fd_sc_mcu7t5v0__oai21_1
X_4905_ _7167_/Q _4910_/A2 _4906_/B VDD VDD VSS VSS gf180mcu_fd_sc_mcu7t5v0__nand2_1
X_5885_ _7116_/Q wire353/Z _6112_/A2 _7109_/Q _5890_/A1 VDD VDD VSS VSS gf180mcu_fd_sc_mcu7t5v0__oai22_1
X_7624_ _7624_/D _7706_/RN _7693_/CLK _7624_/Q VDD VDD VSS VSS gf180mcu_fd_sc_mcu7t5v0__dffrnq_1
X_4836_ _5060_/A1 _4840_/A2 _4836_/B _7132_/D VDD VDD VSS VSS gf180mcu_fd_sc_mcu7t5v0__oai21_1
X_7555_ _7555_/D _7705_/RN _7780_/CLK _7555_/Q VDD VDD VSS VSS gf180mcu_fd_sc_mcu7t5v0__dffrnq_1
X_4767_ _7098_/Q _4770_/A2 _4768_/B VDD VDD VSS VSS gf180mcu_fd_sc_mcu7t5v0__nand2_1
X_6506_ _6538_/A1 _6505_/Z _7677_/D VDD VDD VSS VSS gf180mcu_fd_sc_mcu7t5v0__nor2_1
X_4698_ wire231/Z _4700_/A2 _4698_/B _7063_/D VDD VDD VSS VSS gf180mcu_fd_sc_mcu7t5v0__oai21_1
XFILLER_107_627 VDD VDD VSS VSS gf180mcu_fd_sc_mcu7t5v0__fill_2
X_7486_ _7486_/D _7489_/CLK _7486_/Q VDD VDD VSS VSS gf180mcu_fd_sc_mcu7t5v0__dffq_1
X_3718_ _7734_/Q _6634_/B _3719_/I VDD VDD VSS VSS gf180mcu_fd_sc_mcu7t5v0__xor2_1
X_6437_ _7665_/Q _7531_/Q _6439_/B VDD VDD VSS VSS gf180mcu_fd_sc_mcu7t5v0__xor2_1
X_3649_ _3643_/Z _3648_/Z _3665_/A1 VDD VDD VSS VSS gf180mcu_fd_sc_mcu7t5v0__nand2_1
XTAP_TAPCELL_ROW_54_1010 VDD VSS gf180mcu_fd_sc_mcu7t5v0__filltie
X_6368_ _7650_/Q _6368_/I1 _7540_/Q _7650_/D VDD VDD VSS VSS gf180mcu_fd_sc_mcu7t5v0__mux2_2
X_5319_ _5347_/I0 _7466_/Q _5323_/S _7466_/D VDD VDD VSS VSS gf180mcu_fd_sc_mcu7t5v0__mux2_2
XTAP_TAPCELL_ROW_54_1021 VDD VSS gf180mcu_fd_sc_mcu7t5v0__filltie
X_6299_ _7535_/Q _6301_/B1 _6300_/B2 VDD VDD VSS VSS gf180mcu_fd_sc_mcu7t5v0__nand2_1
XFILLER_102_332 VDD VDD VSS VSS gf180mcu_fd_sc_mcu7t5v0__fill_1
XFILLER_49_909 VDD VDD VSS VSS gf180mcu_fd_sc_mcu7t5v0__fill_1
XFILLER_103_899 VDD VDD VSS VSS gf180mcu_fd_sc_mcu7t5v0__fill_2
XTAP_TAPCELL_ROW_3_297 VDD VSS gf180mcu_fd_sc_mcu7t5v0__filltie
XFILLER_71_422 VDD VDD VSS VSS gf180mcu_fd_sc_mcu7t5v0__fill_1
XFILLER_71_477 VDD VDD VSS VSS gf180mcu_fd_sc_mcu7t5v0__fill_2
XTAP_TAPCELL_ROW_65_1172 VDD VSS gf180mcu_fd_sc_mcu7t5v0__filltie
XTAP_TAPCELL_ROW_42_848 VDD VSS gf180mcu_fd_sc_mcu7t5v0__filltie
XTAP_TAPCELL_ROW_22_561 VDD VSS gf180mcu_fd_sc_mcu7t5v0__filltie
XTAP_TAPCELL_ROW_22_572 VDD VSS gf180mcu_fd_sc_mcu7t5v0__filltie
XANTENNA_9 _6045_/A2 VDD VDD VSS VSS gf180mcu_fd_sc_mcu7t5v0__antenna
XPHY_EDGE_ROW_20_Left_139 VDD VSS gf180mcu_fd_sc_mcu7t5v0__endcap
XFILLER_75_772 VDD VDD VSS VSS gf180mcu_fd_sc_mcu7t5v0__fill_1
XFILLER_19_187 VDD VDD VSS VSS gf180mcu_fd_sc_mcu7t5v0__fill_2
XFILLER_15_360 VDD VDD VSS VSS gf180mcu_fd_sc_mcu7t5v0__fill_2
XFILLER_43_680 VDD VDD VSS VSS gf180mcu_fd_sc_mcu7t5v0__fillcap_4
XFILLER_31_842 VDD VDD VSS VSS gf180mcu_fd_sc_mcu7t5v0__fillcap_64
X_5670_ _7548_/Q input29/Z _7783_/D _7548_/D VDD VDD VSS VSS gf180mcu_fd_sc_mcu7t5v0__mux2_2
X_4621_ _7025_/Q _4630_/A2 _4622_/B VDD VDD VSS VSS gf180mcu_fd_sc_mcu7t5v0__nand2_1
XTAP_TAPCELL_ROW_96_1600 VDD VSS gf180mcu_fd_sc_mcu7t5v0__filltie
XFILLER_116_402 VDD VDD VSS VSS gf180mcu_fd_sc_mcu7t5v0__fill_2
X_4552_ _4832_/A1 _4560_/A2 _4552_/B _6990_/D VDD VDD VSS VSS gf180mcu_fd_sc_mcu7t5v0__oai21_1
X_7340_ _7340_/D _7378_/CLK _7340_/Q VDD VDD VSS VSS gf180mcu_fd_sc_mcu7t5v0__dffq_1
X_7271_ _7271_/D _7687_/CLK _7271_/Q VDD VDD VSS VSS gf180mcu_fd_sc_mcu7t5v0__dffq_1
X_4483_ _6956_/Q _4490_/A2 _4484_/B VDD VDD VSS VSS gf180mcu_fd_sc_mcu7t5v0__nand2_1
X_3503_ _6603_/A1 _6621_/A1 _3508_/B VDD VDD VSS VSS gf180mcu_fd_sc_mcu7t5v0__nor2_1
X_6222_ _6762_/Q _6229_/A2 _6222_/B1 _6761_/Q _6758_/Q _6229_/B1 _6223_/A2 VDD VDD
+ VSS VSS gf180mcu_fd_sc_mcu7t5v0__oai222_1
X_3434_ _7612_/Q _6312_/A1 VDD VDD VSS VSS gf180mcu_fd_sc_mcu7t5v0__clkinv_1
XFILLER_97_330 VDD VDD VSS VSS gf180mcu_fd_sc_mcu7t5v0__fill_1
X_6153_ _7036_/Q _6153_/A2 _6153_/B1 _7015_/Q _6155_/A1 VDD VDD VSS VSS gf180mcu_fd_sc_mcu7t5v0__oai22_1
Xload_slew440 _6262_/A2 _6283_/A2 VDD VDD VSS VSS gf180mcu_fd_sc_mcu7t5v0__buf_2
X_3365_ _7713_/Q _5754_/A2 VDD VDD VSS VSS gf180mcu_fd_sc_mcu7t5v0__clkinv_1
X_5104_ wire231/Z _5106_/A2 _5104_/B _7266_/D VDD VDD VSS VSS gf180mcu_fd_sc_mcu7t5v0__oai21_1
X_6084_ _6993_/Q wire355/I _6207_/B1 _6916_/Q _6084_/C _6088_/A2 VDD VDD VSS VSS gf180mcu_fd_sc_mcu7t5v0__oai221_1
Xload_slew462 _5582_/C _5614_/B VDD VDD VSS VSS gf180mcu_fd_sc_mcu7t5v0__buf_4
X_5035_ _7232_/Q _5036_/A2 _5036_/B VDD VDD VSS VSS gf180mcu_fd_sc_mcu7t5v0__nand2_1
XFILLER_72_208 VDD VDD VSS VSS gf180mcu_fd_sc_mcu7t5v0__fill_2
XTAP_TAPCELL_ROW_0_245 VDD VSS gf180mcu_fd_sc_mcu7t5v0__filltie
X_6986_ _6986_/D _7687_/CLK _6986_/Q VDD VDD VSS VSS gf180mcu_fd_sc_mcu7t5v0__dffq_1
XTAP_TAPCELL_ROW_0_256 VDD VSS gf180mcu_fd_sc_mcu7t5v0__filltie
X_5937_ _5937_/A1 _5937_/A2 _6244_/C _5937_/C _5938_/A3 VDD VDD VSS VSS gf180mcu_fd_sc_mcu7t5v0__oai211_1
X_7607_ _7607_/D _7611_/RN _7670_/CLK _7607_/Q VDD VDD VSS VSS gf180mcu_fd_sc_mcu7t5v0__dffrnq_1
XFILLER_21_352 VDD VDD VSS VSS gf180mcu_fd_sc_mcu7t5v0__fill_2
X_5868_ _7227_/Q _6236_/A2 _6236_/B1 _7234_/Q _7241_/Q _6235_/B1 _5873_/A1 VDD VDD
+ VSS VSS gf180mcu_fd_sc_mcu7t5v0__oai222_1
X_5799_ _6953_/Q _6089_/B1 _6162_/C _5801_/A1 VDD VDD VSS VSS gf180mcu_fd_sc_mcu7t5v0__oai21_1
X_4819_ _7124_/Q _4826_/A2 _4820_/B VDD VDD VSS VSS gf180mcu_fd_sc_mcu7t5v0__nand2_1
X_7538_ _7538_/D _7652_/RN _7790_/CLK _7538_/Q VDD VDD VSS VSS gf180mcu_fd_sc_mcu7t5v0__dffrnq_1
XFILLER_108_947 VDD VDD VSS VSS gf180mcu_fd_sc_mcu7t5v0__fillcap_32
X_7469_ _7469_/D _7483_/CLK _7469_/Q VDD VDD VSS VSS gf180mcu_fd_sc_mcu7t5v0__dffq_1
XFILLER_1_702 VDD VDD VSS VSS gf180mcu_fd_sc_mcu7t5v0__fillcap_64
XTAP_TAPCELL_ROW_116_1880 VDD VSS gf180mcu_fd_sc_mcu7t5v0__filltie
XFILLER_89_842 VDD VDD VSS VSS gf180mcu_fd_sc_mcu7t5v0__fill_2
Xinput102 tl_i[95] _3631_/A2 VDD VDD VSS VSS gf180mcu_fd_sc_mcu7t5v0__dlyd_1
XTAP_TAPCELL_ROW_8_367 VDD VSS gf180mcu_fd_sc_mcu7t5v0__filltie
XFILLER_76_514 VDD VDD VSS VSS gf180mcu_fd_sc_mcu7t5v0__fill_1
XFILLER_76_569 VDD VDD VSS VSS gf180mcu_fd_sc_mcu7t5v0__fillcap_8
XFILLER_0_289 VDD VDD VSS VSS gf180mcu_fd_sc_mcu7t5v0__fill_2
XFILLER_45_912 VDD VDD VSS VSS gf180mcu_fd_sc_mcu7t5v0__fillcap_64
XTAP_TAPCELL_ROW_47_918 VDD VSS gf180mcu_fd_sc_mcu7t5v0__filltie
XTAP_TAPCELL_ROW_67_1201 VDD VSS gf180mcu_fd_sc_mcu7t5v0__filltie
XPHY_EDGE_ROW_19_Right_19 VDD VSS gf180mcu_fd_sc_mcu7t5v0__endcap
XTAP_TAPCELL_ROW_27_631 VDD VSS gf180mcu_fd_sc_mcu7t5v0__filltie
XTAP_TAPCELL_ROW_27_642 VDD VSS gf180mcu_fd_sc_mcu7t5v0__filltie
XFILLER_72_742 VDD VDD VSS VSS gf180mcu_fd_sc_mcu7t5v0__fill_2
XFILLER_13_842 VDD VDD VSS VSS gf180mcu_fd_sc_mcu7t5v0__fillcap_64
XFILLER_40_661 VDD VDD VSS VSS gf180mcu_fd_sc_mcu7t5v0__fillcap_4
XTAP_TAPCELL_ROW_78_1352 VDD VSS gf180mcu_fd_sc_mcu7t5v0__filltie
XFILLER_99_628 VDD VDD VSS VSS gf180mcu_fd_sc_mcu7t5v0__fill_2
XPHY_EDGE_ROW_28_Right_28 VDD VSS gf180mcu_fd_sc_mcu7t5v0__endcap
XTAP_TAPCELL_ROW_91_1530 VDD VSS gf180mcu_fd_sc_mcu7t5v0__filltie
XFILLER_67_558 VDD VDD VSS VSS gf180mcu_fd_sc_mcu7t5v0__fill_2
XPHY_EDGE_ROW_37_Right_37 VDD VSS gf180mcu_fd_sc_mcu7t5v0__endcap
X_6840_ _6840_/D _7070_/CLK _6840_/Q VDD VDD VSS VSS gf180mcu_fd_sc_mcu7t5v0__dffq_1
X_6771_ _6771_/D _7118_/CLK _6771_/Q VDD VDD VSS VSS gf180mcu_fd_sc_mcu7t5v0__dffq_1
X_3983_ wire248/Z _4378_/A2 _3983_/B _6747_/D VDD VDD VSS VSS gf180mcu_fd_sc_mcu7t5v0__oai21_1
XFILLER_90_594 VDD VDD VSS VSS gf180mcu_fd_sc_mcu7t5v0__fill_1
X_5722_ _6320_/A1 _7674_/Q _7627_/Q _6525_/A1 _6347_/A1 _7692_/Q _5723_/C VDD VDD
+ VSS VSS gf180mcu_fd_sc_mcu7t5v0__aoi222_1
X_5653_ _7536_/Q input64/Z _5653_/S _7536_/D VDD VDD VSS VSS gf180mcu_fd_sc_mcu7t5v0__mux2_2
X_4604_ _5094_/A1 _4616_/A2 _4604_/B _7016_/D VDD VDD VSS VSS gf180mcu_fd_sc_mcu7t5v0__oai21_1
X_5584_ _5584_/I0 _5584_/I1 _5584_/S _5584_/Z VDD VDD VSS VSS gf180mcu_fd_sc_mcu7t5v0__mux2_2
XPHY_EDGE_ROW_46_Right_46 VDD VSS gf180mcu_fd_sc_mcu7t5v0__endcap
X_4535_ _6982_/Q _4546_/A2 _4536_/B VDD VDD VSS VSS gf180mcu_fd_sc_mcu7t5v0__nand2_1
X_7323_ _7323_/D _7489_/CLK _7323_/Q VDD VDD VSS VSS gf180mcu_fd_sc_mcu7t5v0__dffq_1
X_4466_ _5124_/A1 _4476_/A2 _4466_/B _6947_/D VDD VDD VSS VSS gf180mcu_fd_sc_mcu7t5v0__oai21_1
X_7254_ _7254_/D _7254_/CLK _7254_/Q VDD VDD VSS VSS gf180mcu_fd_sc_mcu7t5v0__dffq_1
X_6205_ _6767_/Q _6227_/A2 _6211_/B1 _6768_/Q _6770_/Q wire416/Z _6206_/A2 VDD VDD
+ VSS VSS gf180mcu_fd_sc_mcu7t5v0__oai222_1
X_3417_ _7694_/Q _5712_/B2 VDD VDD VSS VSS gf180mcu_fd_sc_mcu7t5v0__clkinv_1
X_4397_ _6913_/Q _4406_/A2 _4398_/B VDD VDD VSS VSS gf180mcu_fd_sc_mcu7t5v0__nand2_1
X_7185_ _7185_/D _7189_/CLK _7185_/Q VDD VDD VSS VSS gf180mcu_fd_sc_mcu7t5v0__dffq_1
X_6136_ _6136_/A1 _6136_/A2 _6136_/B _6143_/A2 VDD VDD VSS VSS gf180mcu_fd_sc_mcu7t5v0__oai21_1
XTAP_TAPCELL_ROW_5_326 VDD VSS gf180mcu_fd_sc_mcu7t5v0__filltie
XFILLER_100_633 VDD VDD VSS VSS gf180mcu_fd_sc_mcu7t5v0__fill_2
XFILLER_100_677 VDD VDD VSS VSS gf180mcu_fd_sc_mcu7t5v0__fill_2
X_6067_ _6284_/B1 _6067_/A2 _6067_/A3 _6067_/A4 _6068_/B VDD VDD VSS VSS gf180mcu_fd_sc_mcu7t5v0__nand4_1
XFILLER_27_912 VDD VDD VSS VSS gf180mcu_fd_sc_mcu7t5v0__fillcap_64
XFILLER_39_772 VDD VDD VSS VSS gf180mcu_fd_sc_mcu7t5v0__fillcap_64
XPHY_EDGE_ROW_55_Right_55 VDD VSS gf180mcu_fd_sc_mcu7t5v0__endcap
X_5018_ _5102_/A1 _5022_/A2 _5018_/B _7223_/D VDD VDD VSS VSS gf180mcu_fd_sc_mcu7t5v0__oai21_1
XTAP_TAPCELL_ROW_24_601 VDD VSS gf180mcu_fd_sc_mcu7t5v0__filltie
X_6969_ _6969_/D _7276_/CLK _6969_/Q VDD VDD VSS VSS gf180mcu_fd_sc_mcu7t5v0__dffq_1
XTAP_TAPCELL_ROW_62_1120 VDD VSS gf180mcu_fd_sc_mcu7t5v0__filltie
XTAP_TAPCELL_ROW_62_1131 VDD VSS gf180mcu_fd_sc_mcu7t5v0__filltie
XFILLER_10_801 VDD VDD VSS VSS gf180mcu_fd_sc_mcu7t5v0__fillcap_4
XFILLER_22_661 VDD VDD VSS VSS gf180mcu_fd_sc_mcu7t5v0__fillcap_4
XTAP_TAPCELL_ROW_52_987 VDD VSS gf180mcu_fd_sc_mcu7t5v0__filltie
XFILLER_50_981 VDD VDD VSS VSS gf180mcu_fd_sc_mcu7t5v0__fill_1
XPHY_EDGE_ROW_64_Right_64 VDD VSS gf180mcu_fd_sc_mcu7t5v0__endcap
XTAP_TAPCELL_ROW_118_1931 VDD VSS gf180mcu_fd_sc_mcu7t5v0__filltie
XTAP_TAPCELL_ROW_118_1920 VDD VSS gf180mcu_fd_sc_mcu7t5v0__filltie
Xclkbuf_leaf_54_clk_i clkload6/I _7101_/CLK VDD VDD VSS VSS gf180mcu_fd_sc_mcu7t5v0__clkbuf_8
XTAP_TAPCELL_ROW_73_1282 VDD VSS gf180mcu_fd_sc_mcu7t5v0__filltie
XFILLER_77_834 VDD VDD VSS VSS gf180mcu_fd_sc_mcu7t5v0__fillcap_4
XPHY_EDGE_ROW_73_Right_73 VDD VSS gf180mcu_fd_sc_mcu7t5v0__endcap
XFILLER_92_815 VDD VDD VSS VSS gf180mcu_fd_sc_mcu7t5v0__fill_2
XFILLER_92_804 VDD VDD VSS VSS gf180mcu_fd_sc_mcu7t5v0__fill_1
XFILLER_67_97 VDD VDD VSS VSS gf180mcu_fd_sc_mcu7t5v0__fill_1
XFILLER_17_422 VDD VDD VSS VSS gf180mcu_fd_sc_mcu7t5v0__fill_2
Xclkbuf_leaf_69_clk_i clkload3/I _7505_/CLK VDD VDD VSS VSS gf180mcu_fd_sc_mcu7t5v0__clkbuf_8
XFILLER_57_591 VDD VDD VSS VSS gf180mcu_fd_sc_mcu7t5v0__fill_2
XPHY_EDGE_ROW_103_Left_222 VDD VSS gf180mcu_fd_sc_mcu7t5v0__endcap
XPHY_EDGE_ROW_82_Right_82 VDD VSS gf180mcu_fd_sc_mcu7t5v0__endcap
XFILLER_9_632 VDD VDD VSS VSS gf180mcu_fd_sc_mcu7t5v0__fillcap_64
XPHY_EDGE_ROW_112_Left_231 VDD VSS gf180mcu_fd_sc_mcu7t5v0__endcap
XTAP_TAPCELL_ROW_10_394 VDD VSS gf180mcu_fd_sc_mcu7t5v0__filltie
X_4320_ _4950_/A1 _4322_/A2 _4320_/B _6874_/D VDD VDD VSS VSS gf180mcu_fd_sc_mcu7t5v0__oai21_1
X_4251_ _6840_/Q _4252_/A2 _4252_/B VDD VDD VSS VSS gf180mcu_fd_sc_mcu7t5v0__nand2_1
XPHY_EDGE_ROW_91_Right_91 VDD VSS gf180mcu_fd_sc_mcu7t5v0__endcap
X_4182_ _4203_/A1 _4193_/A2 _4189_/A2 VDD VDD VSS VSS gf180mcu_fd_sc_mcu7t5v0__nor2_1
XFILLER_27_208 VDD VDD VSS VSS gf180mcu_fd_sc_mcu7t5v0__fill_2
XFILLER_36_731 VDD VDD VSS VSS gf180mcu_fd_sc_mcu7t5v0__fillcap_4
X_6823_ _6823_/D _7734_/CLK _6823_/Q VDD VDD VSS VSS gf180mcu_fd_sc_mcu7t5v0__dffq_1
X_6754_ _6754_/D _7002_/CLK _6754_/Q VDD VDD VSS VSS gf180mcu_fd_sc_mcu7t5v0__dffq_1
X_3966_ _3966_/A1 _6611_/A2 _4110_/A1 VDD VDD VSS VSS gf180mcu_fd_sc_mcu7t5v0__nor2_2
X_5705_ _7626_/Q _7683_/Q _5705_/Z VDD VDD VSS VSS gf180mcu_fd_sc_mcu7t5v0__xor2_1
XFILLER_32_981 VDD VDD VSS VSS gf180mcu_fd_sc_mcu7t5v0__fill_1
X_6685_ _6717_/A2 _6684_/Z _6685_/B _6692_/C _7743_/D VDD VDD VSS VSS gf180mcu_fd_sc_mcu7t5v0__oai211_1
X_5636_ _5808_/A1 _6315_/A1 _3703_/Z _5636_/ZN VDD VDD VSS VSS gf180mcu_fd_sc_mcu7t5v0__nor3_1
X_3897_ _7568_/Q _3897_/A2 _3897_/B1 _6737_/A1 _7786_/D VDD VDD VSS VSS gf180mcu_fd_sc_mcu7t5v0__aoi22_1
X_5567_ _7442_/Q _5607_/A2 _5607_/B1 _7288_/Q _5569_/A2 VDD VDD VSS VSS gf180mcu_fd_sc_mcu7t5v0__oai22_1
X_4518_ _4532_/A1 _4518_/A2 _4518_/B _6973_/D VDD VDD VSS VSS gf180mcu_fd_sc_mcu7t5v0__oai21_1
X_7306_ _7306_/D _7492_/CLK _7306_/Q VDD VDD VSS VSS gf180mcu_fd_sc_mcu7t5v0__dffq_1
X_5498_ _7426_/Q _5578_/A2 _5501_/B1 _7433_/Q _7454_/Q _5599_/A2 _5499_/A2 VDD VDD
+ VSS VSS gf180mcu_fd_sc_mcu7t5v0__oai222_1
X_4449_ _6939_/Q _4462_/A2 _4450_/B VDD VDD VSS VSS gf180mcu_fd_sc_mcu7t5v0__nand2_1
X_7237_ _7237_/D _7251_/CLK _7237_/Q VDD VDD VSS VSS gf180mcu_fd_sc_mcu7t5v0__dffq_1
X_7168_ _7168_/D _7189_/CLK _7168_/Q VDD VDD VSS VSS gf180mcu_fd_sc_mcu7t5v0__dffq_1
X_6119_ _6119_/I _6120_/B VDD VDD VSS VSS gf180mcu_fd_sc_mcu7t5v0__clkinv_1
X_7099_ _7099_/D _7099_/CLK _7099_/Q VDD VDD VSS VSS gf180mcu_fd_sc_mcu7t5v0__dffq_1
XFILLER_14_414 VDD VDD VSS VSS gf180mcu_fd_sc_mcu7t5v0__fill_1
XTAP_TAPCELL_ROW_37_770 VDD VSS gf180mcu_fd_sc_mcu7t5v0__filltie
XTAP_TAPCELL_ROW_37_781 VDD VSS gf180mcu_fd_sc_mcu7t5v0__filltie
XTAP_TAPCELL_ROW_75_1311 VDD VSS gf180mcu_fd_sc_mcu7t5v0__filltie
XFILLER_64_314 VDD VDD VSS VSS gf180mcu_fd_sc_mcu7t5v0__fill_1
XFILLER_92_656 VDD VDD VSS VSS gf180mcu_fd_sc_mcu7t5v0__fill_1
XFILLER_18_731 VDD VDD VSS VSS gf180mcu_fd_sc_mcu7t5v0__fillcap_4
XTAP_TAPCELL_ROW_86_1462 VDD VSS gf180mcu_fd_sc_mcu7t5v0__filltie
XFILLER_80_829 VDD VDD VSS VSS gf180mcu_fd_sc_mcu7t5v0__fill_2
XFILLER_73_892 VDD VDD VSS VSS gf180mcu_fd_sc_mcu7t5v0__fillcap_4
X_3820_ _7582_/Q _7580_/Q _3820_/Z VDD VDD VSS VSS gf180mcu_fd_sc_mcu7t5v0__xor2_1
XTAP_TAPCELL_ROW_15_475 VDD VSS gf180mcu_fd_sc_mcu7t5v0__filltie
XTAP_TAPCELL_ROW_15_464 VDD VSS gf180mcu_fd_sc_mcu7t5v0__filltie
XFILLER_14_981 VDD VDD VSS VSS gf180mcu_fd_sc_mcu7t5v0__fill_1
X_3751_ _3502_/I _3755_/A2 _3751_/B1 _3751_/B2 _3752_/B VDD VDD VSS VSS gf180mcu_fd_sc_mcu7t5v0__aoi22_1
X_6470_ _7669_/Q _7535_/Q _6473_/A2 _6470_/Z VDD VDD VSS VSS gf180mcu_fd_sc_mcu7t5v0__xor3_1
X_3682_ _3385_/I _3386_/I _3682_/B _3682_/C _3683_/B VDD VDD VSS VSS gf180mcu_fd_sc_mcu7t5v0__aoi211_1
X_5421_ _7304_/Q _5515_/A2 _5514_/C _5423_/A1 VDD VDD VSS VSS gf180mcu_fd_sc_mcu7t5v0__oai21_1
XFILLER_64_2 VDD VDD VSS VSS gf180mcu_fd_sc_mcu7t5v0__fill_1
X_5352_ _5352_/I0 _7499_/Q _5358_/S _7499_/D VDD VDD VSS VSS gf180mcu_fd_sc_mcu7t5v0__mux2_2
X_4303_ _6866_/Q _4308_/A2 _4304_/B VDD VDD VSS VSS gf180mcu_fd_sc_mcu7t5v0__nand2_1
X_7022_ _7022_/D _7062_/CLK _7022_/Q VDD VDD VSS VSS gf180mcu_fd_sc_mcu7t5v0__dffq_1
X_5283_ _5304_/I0 _7430_/Q _5288_/S _7430_/D VDD VDD VSS VSS gf180mcu_fd_sc_mcu7t5v0__mux2_2
X_4234_ _4234_/I0 _6831_/Q _5344_/S _6831_/D VDD VDD VSS VSS gf180mcu_fd_sc_mcu7t5v0__mux2_2
X_4165_ _4173_/A1 _4165_/A2 _6653_/A2 VDD VDD VSS VSS gf180mcu_fd_sc_mcu7t5v0__nor2_2
X_4096_ _6783_/Q _4882_/A2 _4097_/B VDD VDD VSS VSS gf180mcu_fd_sc_mcu7t5v0__nand2_1
XFILLER_36_594 VDD VDD VSS VSS gf180mcu_fd_sc_mcu7t5v0__fill_1
X_6806_ _6806_/D _7492_/CLK _6806_/Q VDD VDD VSS VSS gf180mcu_fd_sc_mcu7t5v0__dffq_1
XTAP_TAPCELL_ROW_34_740 VDD VSS gf180mcu_fd_sc_mcu7t5v0__filltie
X_7786_ _7786_/D _7760_/RN _7794_/CLK _7786_/Q VDD VDD VSS VSS gf180mcu_fd_sc_mcu7t5v0__dffsnq_1
X_4998_ _4998_/A1 _5008_/A2 _4998_/B _7213_/D VDD VDD VSS VSS gf180mcu_fd_sc_mcu7t5v0__oai21_1
X_3949_ _7719_/Q _7720_/Q _6611_/A2 VDD VDD VSS VSS gf180mcu_fd_sc_mcu7t5v0__nand2_1
X_6737_ _6737_/A1 _5359_/Z _6737_/B _7544_/Q _7765_/D VDD VDD VSS VSS gf180mcu_fd_sc_mcu7t5v0__oai211_1
X_6668_ _7746_/Q _7540_/Q _6717_/A1 _6692_/C VDD VDD VSS VSS gf180mcu_fd_sc_mcu7t5v0__nand3_1
X_5619_ _5619_/A1 _5619_/A2 _7514_/D VDD VDD VSS VSS gf180mcu_fd_sc_mcu7t5v0__nand2_1
X_6599_ _6184_/C _6603_/A2 _6601_/B VDD VDD VSS VSS gf180mcu_fd_sc_mcu7t5v0__nand2_1
XTAP_TAPCELL_ROW_111_1809 VDD VSS gf180mcu_fd_sc_mcu7t5v0__filltie
XFILLER_105_533 VDD VDD VSS VSS gf180mcu_fd_sc_mcu7t5v0__fill_2
XTAP_TAPCELL_ROW_57_1052 VDD VSS gf180mcu_fd_sc_mcu7t5v0__filltie
XTAP_TAPCELL_ROW_57_1063 VDD VSS gf180mcu_fd_sc_mcu7t5v0__filltie
XFILLER_105_588 VDD VDD VSS VSS gf180mcu_fd_sc_mcu7t5v0__fill_2
XTAP_TAPCELL_ROW_70_1241 VDD VSS gf180mcu_fd_sc_mcu7t5v0__filltie
Xfanout463 _6634_/B _5531_/B VDD VDD VSS VSS gf180mcu_fd_sc_mcu7t5v0__dlyd_1
XFILLER_14_244 VDD VDD VSS VSS gf180mcu_fd_sc_mcu7t5v0__fill_1
XFILLER_70_851 VDD VDD VSS VSS gf180mcu_fd_sc_mcu7t5v0__fillcap_8
XFILLER_30_737 VDD VDD VSS VSS gf180mcu_fd_sc_mcu7t5v0__fillcap_64
XFILLER_42_597 VDD VDD VSS VSS gf180mcu_fd_sc_mcu7t5v0__fillcap_64
XTAP_TAPCELL_ROW_81_1392 VDD VSS gf180mcu_fd_sc_mcu7t5v0__filltie
XTAP_TAPCELL_ROW_12_423 VDD VSS gf180mcu_fd_sc_mcu7t5v0__filltie
XPHY_EDGE_ROW_108_Right_108 VDD VSS gf180mcu_fd_sc_mcu7t5v0__endcap
X_5970_ _5970_/A1 _5970_/A2 _7716_/Q _5994_/B2 VDD VDD VSS VSS gf180mcu_fd_sc_mcu7t5v0__oai21_1
XFILLER_64_177 VDD VDD VSS VSS gf180mcu_fd_sc_mcu7t5v0__fill_1
XFILLER_18_594 VDD VDD VSS VSS gf180mcu_fd_sc_mcu7t5v0__fill_1
X_4921_ _7175_/Q _4924_/A2 _4922_/B VDD VDD VSS VSS gf180mcu_fd_sc_mcu7t5v0__nand2_1
X_7640_ _7640_/D _7782_/RN _7804_/CLK _7640_/Q VDD VDD VSS VSS gf180mcu_fd_sc_mcu7t5v0__dffrnq_1
X_4852_ _4880_/A1 _4854_/A2 _4852_/B _7140_/D VDD VDD VSS VSS gf180mcu_fd_sc_mcu7t5v0__oai21_1
X_3803_ _7817_/D _7817_/Q _3803_/B _3803_/C _3804_/A3 VDD VDD VSS VSS gf180mcu_fd_sc_mcu7t5v0__aoi211_1
X_7571_ _7571_/D _7612_/RN _7613_/CLK _7886_/I VDD VDD VSS VSS gf180mcu_fd_sc_mcu7t5v0__dffrnq_1
X_4783_ _7106_/Q _4784_/A2 _4784_/B VDD VDD VSS VSS gf180mcu_fd_sc_mcu7t5v0__nand2_1
XTAP_TAPCELL_ROW_99_1642 VDD VSS gf180mcu_fd_sc_mcu7t5v0__filltie
X_6522_ _7682_/Q _7683_/Q _6516_/Z _6525_/A2 VDD VDD VSS VSS gf180mcu_fd_sc_mcu7t5v0__nand3_1
X_3734_ _5373_/A1 _7732_/Q _3735_/A2 VDD VDD VSS VSS gf180mcu_fd_sc_mcu7t5v0__nand2_1
X_6453_ _6453_/I _6456_/A1 VDD VDD VSS VSS gf180mcu_fd_sc_mcu7t5v0__clkinv_1
X_3665_ _3665_/A1 _3665_/A2 _3665_/A3 _3665_/A4 _3666_/A2 VDD VDD VSS VSS gf180mcu_fd_sc_mcu7t5v0__nor4_1
Xclkload40 _7670_/CLK clkload40/Z VDD VDD VSS VSS gf180mcu_fd_sc_mcu7t5v0__clkbuf_2
X_5404_ _7508_/Q _6733_/A4 _5434_/A1 VDD VDD VSS VSS gf180mcu_fd_sc_mcu7t5v0__nand2_1
Xclkload62 _7251_/CLK clkload62/Z VDD VDD VSS VSS gf180mcu_fd_sc_mcu7t5v0__clkbuf_2
Xclkload51 _7248_/CLK clkload51/Z VDD VDD VSS VSS gf180mcu_fd_sc_mcu7t5v0__clkbuf_4
XFILLER_115_842 VDD VDD VSS VSS gf180mcu_fd_sc_mcu7t5v0__fillcap_64
Xclkload73 _7148_/CLK clkload73/ZN VDD VDD VSS VSS gf180mcu_fd_sc_mcu7t5v0__inv_2
X_6384_ _7656_/Q _6451_/A2 _6385_/B VDD VDD VSS VSS gf180mcu_fd_sc_mcu7t5v0__nand2_1
X_3596_ input32/Z input36/Z _3552_/Z _3596_/Z VDD VDD VSS VSS gf180mcu_fd_sc_mcu7t5v0__xor3_1
X_5335_ _5342_/I0 _7482_/Q _5337_/S _7482_/D VDD VDD VSS VSS gf180mcu_fd_sc_mcu7t5v0__mux2_2
X_5266_ wire517/Z _7413_/Q _5267_/S _7413_/D VDD VDD VSS VSS gf180mcu_fd_sc_mcu7t5v0__mux2_2
X_7005_ _7005_/D _7668_/CLK _7005_/Q VDD VDD VSS VSS gf180mcu_fd_sc_mcu7t5v0__dffq_1
X_4217_ _4224_/A1 _6651_/A1 _5295_/S VDD VDD VSS VSS gf180mcu_fd_sc_mcu7t5v0__nand2_1
X_5197_ _5239_/I0 _7344_/Q _5197_/S _7344_/D VDD VDD VSS VSS gf180mcu_fd_sc_mcu7t5v0__mux2_2
XTAP_TAPCELL_ROW_39_810 VDD VSS gf180mcu_fd_sc_mcu7t5v0__filltie
X_4148_ _6800_/Q _5120_/A2 _4149_/B VDD VDD VSS VSS gf180mcu_fd_sc_mcu7t5v0__nand2_1
XFILLER_44_807 VDD VDD VSS VSS gf180mcu_fd_sc_mcu7t5v0__fillcap_8
X_4079_ _6778_/Q _4812_/A2 _4080_/B VDD VDD VSS VSS gf180mcu_fd_sc_mcu7t5v0__nand2_1
XTAP_TAPCELL_ROW_108_1771 VDD VSS gf180mcu_fd_sc_mcu7t5v0__filltie
XFILLER_71_637 VDD VDD VSS VSS gf180mcu_fd_sc_mcu7t5v0__fill_1
XFILLER_24_542 VDD VDD VSS VSS gf180mcu_fd_sc_mcu7t5v0__fillcap_32
XFILLER_52_873 VDD VDD VSS VSS gf180mcu_fd_sc_mcu7t5v0__fill_2
XFILLER_12_737 VDD VDD VSS VSS gf180mcu_fd_sc_mcu7t5v0__fillcap_64
XFILLER_24_597 VDD VDD VSS VSS gf180mcu_fd_sc_mcu7t5v0__fillcap_64
X_7769_ _7769_/D _7827_/RN _7823_/CLK _7769_/Q VDD VDD VSS VSS gf180mcu_fd_sc_mcu7t5v0__dffsnq_1
Xclkload1 clkload1/I clkload1/ZN VDD VDD VSS VSS gf180mcu_fd_sc_mcu7t5v0__clkinv_12
XFILLER_50_34 VDD VDD VSS VSS gf180mcu_fd_sc_mcu7t5v0__fill_1
XFILLER_106_820 VDD VDD VSS VSS gf180mcu_fd_sc_mcu7t5v0__fill_2
XFILLER_3_424 VDD VDD VSS VSS gf180mcu_fd_sc_mcu7t5v0__fill_1
XFILLER_4_947 VDD VDD VSS VSS gf180mcu_fd_sc_mcu7t5v0__fillcap_32
Xfanout260 _5072_/A1 _4708_/A1 VDD VDD VSS VSS gf180mcu_fd_sc_mcu7t5v0__dlyd_1
XFILLER_74_420 VDD VDD VSS VSS gf180mcu_fd_sc_mcu7t5v0__fill_1
XFILLER_19_369 VDD VDD VSS VSS gf180mcu_fd_sc_mcu7t5v0__fill_2
XFILLER_90_935 VDD VDD VSS VSS gf180mcu_fd_sc_mcu7t5v0__fillcap_8
XTAP_TAPCELL_ROW_83_1421 VDD VSS gf180mcu_fd_sc_mcu7t5v0__filltie
XFILLER_34_317 VDD VDD VSS VSS gf180mcu_fd_sc_mcu7t5v0__fill_2
XFILLER_62_637 VDD VDD VSS VSS gf180mcu_fd_sc_mcu7t5v0__fill_2
XFILLER_90_979 VDD VDD VSS VSS gf180mcu_fd_sc_mcu7t5v0__fill_2
XFILLER_15_531 VDD VDD VSS VSS gf180mcu_fd_sc_mcu7t5v0__fillcap_16
X_3450_ _7579_/Q _6251_/A1 VDD VDD VSS VSS gf180mcu_fd_sc_mcu7t5v0__clkinv_1
XTAP_TAPCELL_ROW_94_1572 VDD VSS gf180mcu_fd_sc_mcu7t5v0__filltie
X_3381_ _7881_/I _3696_/A1 VDD VDD VSS VSS gf180mcu_fd_sc_mcu7t5v0__clkinv_1
X_5120_ _5120_/A1 _5120_/A2 _5120_/B _7274_/D VDD VDD VSS VSS gf180mcu_fd_sc_mcu7t5v0__oai21_1
X_5051_ _7240_/Q _5064_/A2 _5052_/B VDD VDD VSS VSS gf180mcu_fd_sc_mcu7t5v0__nand2_1
X_4002_ _4138_/A1 _4002_/A2 _4027_/A2 VDD VDD VSS VSS gf180mcu_fd_sc_mcu7t5v0__nor2_1
XFILLER_26_807 VDD VDD VSS VSS gf180mcu_fd_sc_mcu7t5v0__fillcap_64
XFILLER_38_667 VDD VDD VSS VSS gf180mcu_fd_sc_mcu7t5v0__fillcap_64
X_5953_ _5953_/A1 _5953_/A2 _6122_/C _5998_/A2 VDD VDD VSS VSS gf180mcu_fd_sc_mcu7t5v0__oai21_1
XFILLER_81_979 VDD VDD VSS VSS gf180mcu_fd_sc_mcu7t5v0__fill_1
X_5884_ _5884_/A1 _6284_/A2 _5882_/Z _6274_/B1 _7573_/D VDD VDD VSS VSS gf180mcu_fd_sc_mcu7t5v0__aoi22_1
X_4904_ _4946_/A1 _4910_/A2 _4904_/B _7166_/D VDD VDD VSS VSS gf180mcu_fd_sc_mcu7t5v0__oai21_1
X_4835_ _7132_/Q _4840_/A2 _4836_/B VDD VDD VSS VSS gf180mcu_fd_sc_mcu7t5v0__nand2_1
X_7623_ _7623_/D _7705_/RN _7703_/CLK _7623_/Q VDD VDD VSS VSS gf180mcu_fd_sc_mcu7t5v0__dffrnq_1
X_4766_ _4822_/A1 _4770_/A2 _4766_/B _7097_/D VDD VDD VSS VSS gf180mcu_fd_sc_mcu7t5v0__oai21_1
X_7554_ _7554_/D _7558_/RN _7780_/CLK _7554_/Q VDD VDD VSS VSS gf180mcu_fd_sc_mcu7t5v0__dffrnq_1
X_6505_ _7677_/Q _6505_/A2 _6505_/Z VDD VDD VSS VSS gf180mcu_fd_sc_mcu7t5v0__xor2_1
X_3717_ _7727_/Q _4165_/A2 _3717_/B _3730_/A1 VDD VDD VSS VSS gf180mcu_fd_sc_mcu7t5v0__oai21_1
X_4697_ _7063_/Q _4700_/A2 _4698_/B VDD VDD VSS VSS gf180mcu_fd_sc_mcu7t5v0__nand2_1
X_7485_ _7485_/D _7489_/CLK _7485_/Q VDD VDD VSS VSS gf180mcu_fd_sc_mcu7t5v0__dffq_1
X_6436_ _7665_/Q _7531_/Q _6436_/Z VDD VDD VSS VSS gf180mcu_fd_sc_mcu7t5v0__and2_1
XFILLER_20_37 VDD VDD VSS VSS gf180mcu_fd_sc_mcu7t5v0__fill_2
X_3648_ _3578_/Z _3644_/Z _3647_/Z _3648_/Z VDD VDD VSS VSS gf180mcu_fd_sc_mcu7t5v0__xor3_1
XFILLER_1_906 VDD VDD VSS VSS gf180mcu_fd_sc_mcu7t5v0__fillcap_4
XTAP_TAPCELL_ROW_54_1011 VDD VSS gf180mcu_fd_sc_mcu7t5v0__filltie
X_6367_ _6677_/A1 _3891_/B _6367_/B _7649_/D VDD VDD VSS VSS gf180mcu_fd_sc_mcu7t5v0__oai21_1
X_3579_ _3575_/Z _3576_/Z _3578_/Z _3579_/Z VDD VDD VSS VSS gf180mcu_fd_sc_mcu7t5v0__xor3_1
X_5318_ _5332_/I0 _7465_/Q _5323_/S _7465_/D VDD VDD VSS VSS gf180mcu_fd_sc_mcu7t5v0__mux2_2
XFILLER_0_405 VDD VDD VSS VSS gf180mcu_fd_sc_mcu7t5v0__fill_2
X_6298_ _6298_/A1 _6298_/A2 _6300_/B1 _6298_/B2 _7601_/D VDD VDD VSS VSS gf180mcu_fd_sc_mcu7t5v0__aoi22_1
XFILLER_103_856 VDD VDD VSS VSS gf180mcu_fd_sc_mcu7t5v0__fill_1
X_5249_ _5354_/I0 _7396_/Q _5253_/S _7396_/D VDD VDD VSS VSS gf180mcu_fd_sc_mcu7t5v0__mux2_2
XFILLER_84_762 VDD VDD VSS VSS gf180mcu_fd_sc_mcu7t5v0__fill_2
XFILLER_57_976 VDD VDD VSS VSS gf180mcu_fd_sc_mcu7t5v0__fillcap_4
XTAP_TAPCELL_ROW_3_298 VDD VSS gf180mcu_fd_sc_mcu7t5v0__filltie
XFILLER_72_979 VDD VDD VSS VSS gf180mcu_fd_sc_mcu7t5v0__fill_2
XTAP_TAPCELL_ROW_65_1162 VDD VSS gf180mcu_fd_sc_mcu7t5v0__filltie
XTAP_TAPCELL_ROW_65_1173 VDD VSS gf180mcu_fd_sc_mcu7t5v0__filltie
XTAP_TAPCELL_ROW_42_849 VDD VSS gf180mcu_fd_sc_mcu7t5v0__filltie
XFILLER_8_527 VDD VDD VSS VSS gf180mcu_fd_sc_mcu7t5v0__fillcap_64
XTAP_TAPCELL_ROW_22_562 VDD VSS gf180mcu_fd_sc_mcu7t5v0__filltie
XTAP_TAPCELL_ROW_22_573 VDD VSS gf180mcu_fd_sc_mcu7t5v0__filltie
XFILLER_90_721 VDD VDD VSS VSS gf180mcu_fd_sc_mcu7t5v0__fill_2
XFILLER_74_261 VDD VDD VSS VSS gf180mcu_fd_sc_mcu7t5v0__fill_1
XFILLER_35_626 VDD VDD VSS VSS gf180mcu_fd_sc_mcu7t5v0__fillcap_4
XFILLER_63_979 VDD VDD VSS VSS gf180mcu_fd_sc_mcu7t5v0__fill_1
X_4620_ _4998_/A1 _4630_/A2 _4620_/B _7024_/D VDD VDD VSS VSS gf180mcu_fd_sc_mcu7t5v0__oai21_1
XFILLER_30_342 VDD VDD VSS VSS gf180mcu_fd_sc_mcu7t5v0__fill_2
XTAP_TAPCELL_ROW_96_1601 VDD VSS gf180mcu_fd_sc_mcu7t5v0__filltie
X_4551_ _6990_/Q _4560_/A2 _4552_/B VDD VDD VSS VSS gf180mcu_fd_sc_mcu7t5v0__nand2_1
X_4482_ _5126_/A1 _4490_/A2 _4482_/B _6955_/D VDD VDD VSS VSS gf180mcu_fd_sc_mcu7t5v0__oai21_1
Xwire491 _6090_/C _6221_/B VDD VDD VSS VSS gf180mcu_fd_sc_mcu7t5v0__clkbuf_4
X_7270_ _7270_/D _7724_/CLK _7270_/Q VDD VDD VSS VSS gf180mcu_fd_sc_mcu7t5v0__dffq_1
X_3502_ _3502_/I _7800_/D VDD VDD VSS VSS gf180mcu_fd_sc_mcu7t5v0__clkinv_1
Xwire480 wire481/I _5926_/B VDD VDD VSS VSS gf180mcu_fd_sc_mcu7t5v0__clkbuf_4
X_6221_ _6759_/Q _6228_/B1 _6221_/B _6223_/A1 VDD VDD VSS VSS gf180mcu_fd_sc_mcu7t5v0__oai21_1
X_3433_ _7772_/Q _3902_/A1 VDD VDD VSS VSS gf180mcu_fd_sc_mcu7t5v0__clkinv_1
X_6152_ _6152_/A1 _6152_/A2 _6156_/B1 VDD VDD VSS VSS gf180mcu_fd_sc_mcu7t5v0__nor2_1
X_5103_ _7266_/Q _5106_/A2 _5104_/B VDD VDD VSS VSS gf180mcu_fd_sc_mcu7t5v0__nand2_1
Xload_slew430 _6632_/A1 _5604_/A2 VDD VDD VSS VSS gf180mcu_fd_sc_mcu7t5v0__buf_4
X_3364_ _7720_/Q _3962_/A2 VDD VDD VSS VSS gf180mcu_fd_sc_mcu7t5v0__clkinv_1
Xload_slew441 _6303_/S _6310_/S VDD VDD VSS VSS gf180mcu_fd_sc_mcu7t5v0__buf_4
X_6083_ _7070_/Q _6225_/A2 _6212_/B1 _6839_/Q _6088_/A1 VDD VDD VSS VSS gf180mcu_fd_sc_mcu7t5v0__oai22_1
Xload_slew452 _6084_/C _6208_/C VDD VDD VSS VSS gf180mcu_fd_sc_mcu7t5v0__buf_4
Xload_slew474 _6244_/C _5997_/C VDD VDD VSS VSS gf180mcu_fd_sc_mcu7t5v0__buf_4
Xload_slew485 _6237_/B _6216_/B VDD VDD VSS VSS gf180mcu_fd_sc_mcu7t5v0__buf_3
X_5034_ _5076_/A1 _5036_/A2 _5034_/B _7231_/D VDD VDD VSS VSS gf180mcu_fd_sc_mcu7t5v0__oai21_1
XFILLER_38_453 VDD VDD VSS VSS gf180mcu_fd_sc_mcu7t5v0__fill_2
XFILLER_39_976 VDD VDD VSS VSS gf180mcu_fd_sc_mcu7t5v0__fillcap_4
XTAP_TAPCELL_ROW_105_1730 VDD VSS gf180mcu_fd_sc_mcu7t5v0__filltie
X_6985_ _6985_/D _7695_/CLK _6985_/Q VDD VDD VSS VSS gf180mcu_fd_sc_mcu7t5v0__dffq_1
XFILLER_80_242 VDD VDD VSS VSS gf180mcu_fd_sc_mcu7t5v0__fill_2
XTAP_TAPCELL_ROW_0_246 VDD VSS gf180mcu_fd_sc_mcu7t5v0__filltie
XTAP_TAPCELL_ROW_0_257 VDD VSS gf180mcu_fd_sc_mcu7t5v0__filltie
XFILLER_54_979 VDD VDD VSS VSS gf180mcu_fd_sc_mcu7t5v0__fill_2
X_5936_ _5936_/A1 _5936_/A2 _5936_/B1 _5936_/B2 _6231_/C _5938_/A2 VDD VDD VSS VSS
+ gf180mcu_fd_sc_mcu7t5v0__oai221_1
X_7606_ _7606_/D _7612_/RN _7670_/CLK _7606_/Q VDD VDD VSS VSS gf180mcu_fd_sc_mcu7t5v0__dffrnq_1
X_5867_ _5867_/A1 _5867_/A2 _5867_/B _5874_/A2 VDD VDD VSS VSS gf180mcu_fd_sc_mcu7t5v0__oai21_1
X_5798_ _5798_/A1 _5798_/A2 _6196_/B _5805_/A2 VDD VDD VSS VSS gf180mcu_fd_sc_mcu7t5v0__oai21_1
X_4818_ _5070_/A1 _4826_/A2 _4818_/B _7123_/D VDD VDD VSS VSS gf180mcu_fd_sc_mcu7t5v0__oai21_1
X_4749_ _7089_/Q _4756_/A2 _4750_/B VDD VDD VSS VSS gf180mcu_fd_sc_mcu7t5v0__nand2_1
X_7537_ _7537_/D _7785_/RN _7794_/CLK _7537_/Q VDD VDD VSS VSS gf180mcu_fd_sc_mcu7t5v0__dffrnq_1
XTAP_TAPCELL_ROW_60_1092 VDD VSS gf180mcu_fd_sc_mcu7t5v0__filltie
X_7468_ _7468_/D _7489_/CLK _7468_/Q VDD VDD VSS VSS gf180mcu_fd_sc_mcu7t5v0__dffq_1
X_6419_ _7662_/Q _7528_/Q _6419_/Z VDD VDD VSS VSS gf180mcu_fd_sc_mcu7t5v0__or2_1
XFILLER_116_981 VDD VDD VSS VSS gf180mcu_fd_sc_mcu7t5v0__fill_1
XTAP_TAPCELL_ROW_116_1881 VDD VSS gf180mcu_fd_sc_mcu7t5v0__filltie
X_7399_ _7399_/D _7456_/CLK _7399_/Q VDD VDD VSS VSS gf180mcu_fd_sc_mcu7t5v0__dffq_1
XTAP_TAPCELL_ROW_8_368 VDD VSS gf180mcu_fd_sc_mcu7t5v0__filltie
Xinput103 tl_i[96] _3563_/A2 VDD VDD VSS VSS gf180mcu_fd_sc_mcu7t5v0__dlyd_1
XTAP_TAPCELL_ROW_47_919 VDD VSS gf180mcu_fd_sc_mcu7t5v0__filltie
XFILLER_17_626 VDD VDD VSS VSS gf180mcu_fd_sc_mcu7t5v0__fillcap_4
XTAP_TAPCELL_ROW_67_1202 VDD VSS gf180mcu_fd_sc_mcu7t5v0__filltie
XTAP_TAPCELL_ROW_27_632 VDD VSS gf180mcu_fd_sc_mcu7t5v0__filltie
XTAP_TAPCELL_ROW_27_643 VDD VSS gf180mcu_fd_sc_mcu7t5v0__filltie
XFILLER_9_836 VDD VDD VSS VSS gf180mcu_fd_sc_mcu7t5v0__fillcap_4
XTAP_TAPCELL_ROW_78_1353 VDD VSS gf180mcu_fd_sc_mcu7t5v0__filltie
XTAP_TAPCELL_ROW_91_1531 VDD VSS gf180mcu_fd_sc_mcu7t5v0__filltie
XFILLER_94_312 VDD VDD VSS VSS gf180mcu_fd_sc_mcu7t5v0__fill_2
XFILLER_48_773 VDD VDD VSS VSS gf180mcu_fd_sc_mcu7t5v0__fillcap_4
XFILLER_48_784 VDD VDD VSS VSS gf180mcu_fd_sc_mcu7t5v0__fillcap_16
XFILLER_36_979 VDD VDD VSS VSS gf180mcu_fd_sc_mcu7t5v0__fill_2
X_6770_ _6770_/D _7055_/CLK _6770_/Q VDD VDD VSS VSS gf180mcu_fd_sc_mcu7t5v0__dffq_1
X_3982_ _6747_/Q _4378_/A2 _3983_/B VDD VDD VSS VSS gf180mcu_fd_sc_mcu7t5v0__nand2_1
XFILLER_35_489 VDD VDD VSS VSS gf180mcu_fd_sc_mcu7t5v0__fill_1
XFILLER_62_264 VDD VDD VSS VSS gf180mcu_fd_sc_mcu7t5v0__fill_2
XFILLER_94_2 VDD VDD VSS VSS gf180mcu_fd_sc_mcu7t5v0__fill_1
X_5721_ _7627_/Q _6525_/A1 _7631_/Q _5731_/A2 _5724_/B VDD VDD VSS VSS gf180mcu_fd_sc_mcu7t5v0__oai22_1
X_5652_ _7535_/Q input62/Z _5653_/S _7535_/D VDD VDD VSS VSS gf180mcu_fd_sc_mcu7t5v0__mux2_2
XTAP_TAPCELL_ROW_100_1660 VDD VSS gf180mcu_fd_sc_mcu7t5v0__filltie
X_4603_ _7016_/Q _4616_/A2 _4604_/B VDD VDD VSS VSS gf180mcu_fd_sc_mcu7t5v0__nand2_1
X_5583_ _5493_/S _5583_/A2 _5583_/A3 _5583_/B _5584_/I1 VDD VDD VSS VSS gf180mcu_fd_sc_mcu7t5v0__oai31_1
X_4534_ _5122_/A1 _4546_/A2 _4534_/B _6981_/D VDD VDD VSS VSS gf180mcu_fd_sc_mcu7t5v0__oai21_1
X_7322_ _7322_/D _7504_/CLK _7322_/Q VDD VDD VSS VSS gf180mcu_fd_sc_mcu7t5v0__dffq_1
X_4465_ _6947_/Q _4476_/A2 _4466_/B VDD VDD VSS VSS gf180mcu_fd_sc_mcu7t5v0__nand2_1
X_7253_ _7253_/D _7253_/CLK _7253_/Q VDD VDD VSS VSS gf180mcu_fd_sc_mcu7t5v0__dffq_1
X_3416_ _7637_/Q _6351_/A1 VDD VDD VSS VSS gf180mcu_fd_sc_mcu7t5v0__clkinv_1
X_6204_ _6769_/Q _6225_/B1 _6204_/B _6206_/A1 VDD VDD VSS VSS gf180mcu_fd_sc_mcu7t5v0__oai21_1
X_4396_ _4396_/A1 _4406_/A2 _4396_/B _6912_/D VDD VDD VSS VSS gf180mcu_fd_sc_mcu7t5v0__oai21_1
X_7184_ _7184_/D _7453_/CLK _7184_/Q VDD VDD VSS VSS gf180mcu_fd_sc_mcu7t5v0__dffq_1
X_6135_ _6135_/A1 _6135_/A2 _6143_/A1 VDD VDD VSS VSS gf180mcu_fd_sc_mcu7t5v0__nor2_1
XTAP_TAPCELL_ROW_5_327 VDD VSS gf180mcu_fd_sc_mcu7t5v0__filltie
Xload_slew282 _5080_/A1 _5094_/A1 VDD VDD VSS VSS gf180mcu_fd_sc_mcu7t5v0__buf_4
XFILLER_86_857 VDD VDD VSS VSS gf180mcu_fd_sc_mcu7t5v0__fill_1
X_6066_ _3729_/Z _6283_/B1 _6067_/A4 VDD VDD VSS VSS gf180mcu_fd_sc_mcu7t5v0__nand2_1
Xload_slew271 _4984_/A1 _4998_/A1 VDD VDD VSS VSS gf180mcu_fd_sc_mcu7t5v0__clkbuf_4
XFILLER_100_667 VDD VDD VSS VSS gf180mcu_fd_sc_mcu7t5v0__fill_1
X_5017_ _7223_/Q _5022_/A2 _5018_/B VDD VDD VSS VSS gf180mcu_fd_sc_mcu7t5v0__nand2_1
XFILLER_45_209 VDD VDD VSS VSS gf180mcu_fd_sc_mcu7t5v0__fill_1
Xload_slew293 _5120_/A1 _4826_/A1 VDD VDD VSS VSS gf180mcu_fd_sc_mcu7t5v0__buf_4
XFILLER_66_581 VDD VDD VSS VSS gf180mcu_fd_sc_mcu7t5v0__fill_1
X_6968_ _6968_/D _7667_/CLK _6968_/Q VDD VDD VSS VSS gf180mcu_fd_sc_mcu7t5v0__dffq_1
XTAP_TAPCELL_ROW_62_1121 VDD VSS gf180mcu_fd_sc_mcu7t5v0__filltie
X_6899_ _6899_/D _7148_/CLK _6899_/Q VDD VDD VSS VSS gf180mcu_fd_sc_mcu7t5v0__dffq_1
X_5919_ _6969_/Q _6073_/A2 _6091_/A2 _6962_/Q _6955_/Q _6089_/B1 _5920_/A2 VDD VDD
+ VSS VSS gf180mcu_fd_sc_mcu7t5v0__oai222_1
XTAP_TAPCELL_ROW_52_988 VDD VSS gf180mcu_fd_sc_mcu7t5v0__filltie
XTAP_TAPCELL_ROW_62_1132 VDD VSS gf180mcu_fd_sc_mcu7t5v0__filltie
XTAP_TAPCELL_ROW_118_1921 VDD VSS gf180mcu_fd_sc_mcu7t5v0__filltie
XTAP_TAPCELL_ROW_118_1910 VDD VSS gf180mcu_fd_sc_mcu7t5v0__filltie
XFILLER_1_500 VDD VDD VSS VSS gf180mcu_fd_sc_mcu7t5v0__fill_1
XTAP_TAPCELL_ROW_73_1283 VDD VSS gf180mcu_fd_sc_mcu7t5v0__filltie
XFILLER_45_710 VDD VDD VSS VSS gf180mcu_fd_sc_mcu7t5v0__fill_1
XFILLER_18_979 VDD VDD VSS VSS gf180mcu_fd_sc_mcu7t5v0__fill_2
XFILLER_17_489 VDD VDD VSS VSS gf180mcu_fd_sc_mcu7t5v0__fill_1
XFILLER_60_746 VDD VDD VSS VSS gf180mcu_fd_sc_mcu7t5v0__fillcap_4
XTAP_TAPCELL_ROW_10_395 VDD VSS gf180mcu_fd_sc_mcu7t5v0__filltie
X_4250_ _5076_/A1 _4252_/A2 _4250_/B _6839_/D VDD VDD VSS VSS gf180mcu_fd_sc_mcu7t5v0__oai21_1
X_4181_ _4221_/A1 _7736_/Q _4193_/A2 VDD VDD VSS VSS gf180mcu_fd_sc_mcu7t5v0__nand2_1
XFILLER_95_698 VDD VDD VSS VSS gf180mcu_fd_sc_mcu7t5v0__fill_2
X_6822_ _6822_/D _7754_/CLK _6822_/Q VDD VDD VSS VSS gf180mcu_fd_sc_mcu7t5v0__dffq_1
X_6753_ _6753_/D _7055_/CLK _6753_/Q VDD VDD VSS VSS gf180mcu_fd_sc_mcu7t5v0__dffq_1
X_3965_ wire248/I _4322_/A2 _3965_/B _6743_/D VDD VDD VSS VSS gf180mcu_fd_sc_mcu7t5v0__oai21_1
X_6684_ _7743_/Q _7742_/Q _6684_/Z VDD VDD VSS VSS gf180mcu_fd_sc_mcu7t5v0__xor2_1
X_3896_ _7543_/Q _7568_/Q _3897_/B1 VDD VDD VSS VSS gf180mcu_fd_sc_mcu7t5v0__nor2_1
X_5704_ _7620_/Q _7677_/Q _5718_/C VDD VDD VSS VSS gf180mcu_fd_sc_mcu7t5v0__xor2_1
X_5635_ _5808_/A1 _6315_/A1 _5635_/ZN VDD VDD VSS VSS gf180mcu_fd_sc_mcu7t5v0__nor2_1
X_5566_ _5566_/A1 _5566_/A2 _5570_/A2 VDD VDD VSS VSS gf180mcu_fd_sc_mcu7t5v0__nor2_1
X_4517_ _6973_/Q _4518_/A2 _4518_/B VDD VDD VSS VSS gf180mcu_fd_sc_mcu7t5v0__nand2_1
XFILLER_105_704 VDD VDD VSS VSS gf180mcu_fd_sc_mcu7t5v0__fill_1
X_7305_ _7305_/D _7491_/CLK _7305_/Q VDD VDD VSS VSS gf180mcu_fd_sc_mcu7t5v0__dffq_1
X_5497_ _7447_/Q _5544_/A2 _5599_/B _5499_/A1 VDD VDD VSS VSS gf180mcu_fd_sc_mcu7t5v0__oai21_1
X_4448_ wire292/Z _4448_/A2 _4448_/B _6938_/D VDD VDD VSS VSS gf180mcu_fd_sc_mcu7t5v0__oai21_1
XTAP_TAPCELL_ROW_113_1840 VDD VSS gf180mcu_fd_sc_mcu7t5v0__filltie
X_7236_ _7236_/D _7248_/CLK _7236_/Q VDD VDD VSS VSS gf180mcu_fd_sc_mcu7t5v0__dffq_1
X_4379_ _6904_/Q _4392_/A2 _4380_/B VDD VDD VSS VSS gf180mcu_fd_sc_mcu7t5v0__nand2_1
X_7167_ _7167_/D _7189_/CLK _7167_/Q VDD VDD VSS VSS gf180mcu_fd_sc_mcu7t5v0__dffq_1
X_6118_ _7042_/Q _6153_/B1 wire313/Z _7049_/Q _7063_/Q _6153_/A2 _6119_/I VDD VDD
+ VSS VSS gf180mcu_fd_sc_mcu7t5v0__oai222_1
XFILLER_101_965 VDD VDD VSS VSS gf180mcu_fd_sc_mcu7t5v0__fillcap_8
X_7098_ _7098_/D _7101_/CLK _7098_/Q VDD VDD VSS VSS gf180mcu_fd_sc_mcu7t5v0__dffq_1
XFILLER_74_827 VDD VDD VSS VSS gf180mcu_fd_sc_mcu7t5v0__fillcap_4
XFILLER_46_518 VDD VDD VSS VSS gf180mcu_fd_sc_mcu7t5v0__fillcap_4
X_6049_ _7195_/Q _6098_/A2 _6232_/A2 _7202_/Q _7216_/Q _6233_/A2 _6052_/A2 VDD VDD
+ VSS VSS gf180mcu_fd_sc_mcu7t5v0__oai222_1
XTAP_TAPCELL_ROW_37_771 VDD VSS gf180mcu_fd_sc_mcu7t5v0__filltie
XTAP_TAPCELL_ROW_37_782 VDD VSS gf180mcu_fd_sc_mcu7t5v0__filltie
XFILLER_50_790 VDD VDD VSS VSS gf180mcu_fd_sc_mcu7t5v0__fill_2
XTAP_TAPCELL_ROW_75_1312 VDD VSS gf180mcu_fd_sc_mcu7t5v0__filltie
XFILLER_97_908 VDD VDD VSS VSS gf180mcu_fd_sc_mcu7t5v0__fill_2
XFILLER_94_96 VDD VDD VSS VSS gf180mcu_fd_sc_mcu7t5v0__fill_2
XTAP_TAPCELL_ROW_86_1463 VDD VSS gf180mcu_fd_sc_mcu7t5v0__filltie
XFILLER_73_860 VDD VDD VSS VSS gf180mcu_fd_sc_mcu7t5v0__fill_2
XFILLER_33_702 VDD VDD VSS VSS gf180mcu_fd_sc_mcu7t5v0__fillcap_64
XFILLER_45_551 VDD VDD VSS VSS gf180mcu_fd_sc_mcu7t5v0__fill_1
XFILLER_45_562 VDD VDD VSS VSS gf180mcu_fd_sc_mcu7t5v0__fill_2
XFILLER_60_532 VDD VDD VSS VSS gf180mcu_fd_sc_mcu7t5v0__fillcap_4
XTAP_TAPCELL_ROW_15_465 VDD VSS gf180mcu_fd_sc_mcu7t5v0__filltie
X_3750_ _7798_/D _3750_/A2 _3750_/B1 _7799_/D _3750_/C _3751_/B2 VDD VDD VSS VSS gf180mcu_fd_sc_mcu7t5v0__oai221_1
XFILLER_118_339 VDD VDD VSS VSS gf180mcu_fd_sc_mcu7t5v0__fill_1
X_3681_ _3677_/S _3681_/A2 _3681_/B _3681_/C _3682_/B VDD VDD VSS VSS gf180mcu_fd_sc_mcu7t5v0__aoi211_1
X_5420_ _5514_/C _5420_/A2 _5420_/A3 _5430_/A2 VDD VDD VSS VSS gf180mcu_fd_sc_mcu7t5v0__nor3_1
X_5351_ _7645_/Q _7498_/Q _5351_/S _7498_/D VDD VDD VSS VSS gf180mcu_fd_sc_mcu7t5v0__mux2_2
X_4302_ _4540_/A1 _4308_/A2 _4302_/B _6865_/D VDD VDD VSS VSS gf180mcu_fd_sc_mcu7t5v0__oai21_1
X_5282_ _5303_/I0 _7429_/Q _5288_/S _7429_/D VDD VDD VSS VSS gf180mcu_fd_sc_mcu7t5v0__mux2_2
X_7021_ _7021_/D _7060_/CLK _7021_/Q VDD VDD VSS VSS gf180mcu_fd_sc_mcu7t5v0__dffq_1
X_4233_ _6653_/A2 _4233_/A2 _5344_/S VDD VDD VSS VSS gf180mcu_fd_sc_mcu7t5v0__nand2_1
XFILLER_4_94 VDD VDD VSS VSS gf180mcu_fd_sc_mcu7t5v0__fill_1
X_4164_ _4238_/I0 _6803_/Q _5148_/S _6803_/D VDD VDD VSS VSS gf180mcu_fd_sc_mcu7t5v0__mux2_2
XFILLER_67_142 VDD VDD VSS VSS gf180mcu_fd_sc_mcu7t5v0__fill_2
X_4095_ _4120_/A1 _4110_/A2 _4882_/A2 VDD VDD VSS VSS gf180mcu_fd_sc_mcu7t5v0__nand2_1
XFILLER_23_212 VDD VDD VSS VSS gf180mcu_fd_sc_mcu7t5v0__fill_1
X_6805_ _6805_/D _7491_/CLK _6805_/Q VDD VDD VSS VSS gf180mcu_fd_sc_mcu7t5v0__dffq_1
XTAP_TAPCELL_ROW_34_730 VDD VSS gf180mcu_fd_sc_mcu7t5v0__filltie
XTAP_TAPCELL_ROW_34_741 VDD VSS gf180mcu_fd_sc_mcu7t5v0__filltie
X_7785_ _7785_/D _7785_/RN _7790_/CLK _7785_/Q VDD VDD VSS VSS gf180mcu_fd_sc_mcu7t5v0__dffrnq_1
Xclkbuf_leaf_53_clk_i clkload6/I _7099_/CLK VDD VDD VSS VSS gf180mcu_fd_sc_mcu7t5v0__clkbuf_8
X_6736_ _7506_/Q _5359_/Z _6737_/B VDD VDD VSS VSS gf180mcu_fd_sc_mcu7t5v0__nand2_1
X_4997_ _7213_/Q _5008_/A2 _4998_/B VDD VDD VSS VSS gf180mcu_fd_sc_mcu7t5v0__nand2_1
X_3948_ wire248/Z _4266_/A2 _3948_/B _6739_/D VDD VDD VSS VSS gf180mcu_fd_sc_mcu7t5v0__oai21_1
XFILLER_20_941 VDD VDD VSS VSS gf180mcu_fd_sc_mcu7t5v0__fillcap_4
X_6667_ _6697_/A1 _3787_/Z _6667_/A3 _7740_/D VDD VDD VSS VSS gf180mcu_fd_sc_mcu7t5v0__nor3_1
X_3879_ _7648_/Q _7649_/Q _7650_/Q _3890_/A2 _3879_/Z VDD VDD VSS VSS gf180mcu_fd_sc_mcu7t5v0__and4_1
X_5618_ _7515_/Q _6732_/A1 _6728_/B _5618_/C _5619_/A2 VDD VDD VSS VSS gf180mcu_fd_sc_mcu7t5v0__oai211_1
X_6598_ _6601_/A1 _6597_/Z _6598_/B _7715_/D VDD VDD VSS VSS gf180mcu_fd_sc_mcu7t5v0__oai21_1
X_5549_ _7371_/Q wire420/Z _5549_/B _5549_/C _5552_/B VDD VDD VSS VSS gf180mcu_fd_sc_mcu7t5v0__oai211_1
Xclkbuf_leaf_68_clk_i clkload4/I _7218_/CLK VDD VDD VSS VSS gf180mcu_fd_sc_mcu7t5v0__clkbuf_8
XTAP_TAPCELL_ROW_57_1053 VDD VSS gf180mcu_fd_sc_mcu7t5v0__filltie
X_7219_ _7219_/D _7254_/CLK _7219_/Q VDD VDD VSS VSS gf180mcu_fd_sc_mcu7t5v0__dffq_1
Xfanout431 _5579_/A2 _5453_/C2 VDD VDD VSS VSS gf180mcu_fd_sc_mcu7t5v0__dlyd_1
XFILLER_87_952 VDD VDD VSS VSS gf180mcu_fd_sc_mcu7t5v0__fillcap_16
Xfanout442 _6229_/C _5823_/C VDD VDD VSS VSS gf180mcu_fd_sc_mcu7t5v0__dlyd_1
XTAP_TAPCELL_ROW_70_1242 VDD VSS gf180mcu_fd_sc_mcu7t5v0__filltie
XFILLER_74_602 VDD VDD VSS VSS gf180mcu_fd_sc_mcu7t5v0__fill_1
XFILLER_47_838 VDD VDD VSS VSS gf180mcu_fd_sc_mcu7t5v0__fill_2
Xfanout486 _7715_/Q wire487/I VDD VDD VSS VSS gf180mcu_fd_sc_mcu7t5v0__dlyd_1
Xfanout497 _7714_/Q _6147_/B VDD VDD VSS VSS gf180mcu_fd_sc_mcu7t5v0__dlyd_1
XFILLER_15_702 VDD VDD VSS VSS gf180mcu_fd_sc_mcu7t5v0__fillcap_64
XFILLER_27_562 VDD VDD VSS VSS gf180mcu_fd_sc_mcu7t5v0__fillcap_64
XFILLER_70_874 VDD VDD VSS VSS gf180mcu_fd_sc_mcu7t5v0__fill_1
XTAP_TAPCELL_ROW_81_1393 VDD VSS gf180mcu_fd_sc_mcu7t5v0__filltie
XTAP_TAPCELL_ROW_12_424 VDD VSS gf180mcu_fd_sc_mcu7t5v0__filltie
XFILLER_7_912 VDD VDD VSS VSS gf180mcu_fd_sc_mcu7t5v0__fillcap_64
XFILLER_2_661 VDD VDD VSS VSS gf180mcu_fd_sc_mcu7t5v0__fillcap_4
XFILLER_93_977 VDD VDD VSS VSS gf180mcu_fd_sc_mcu7t5v0__fill_2
XFILLER_92_454 VDD VDD VSS VSS gf180mcu_fd_sc_mcu7t5v0__fill_1
X_4920_ _4948_/A1 _4924_/A2 _4920_/B _7174_/D VDD VDD VSS VSS gf180mcu_fd_sc_mcu7t5v0__oai21_1
X_4851_ _7140_/Q _4854_/A2 _4852_/B VDD VDD VSS VSS gf180mcu_fd_sc_mcu7t5v0__nand2_1
X_3802_ _7766_/Q _3802_/A2 _3803_/C VDD VDD VSS VSS gf180mcu_fd_sc_mcu7t5v0__nand2_1
X_7570_ _7570_/D _7612_/RN _7613_/CLK _7884_/I VDD VDD VSS VSS gf180mcu_fd_sc_mcu7t5v0__dffrnq_1
X_4782_ _4824_/A1 _4784_/A2 _4782_/B _7105_/D VDD VDD VSS VSS gf180mcu_fd_sc_mcu7t5v0__oai21_1
XTAP_TAPCELL_ROW_99_1643 VDD VSS gf180mcu_fd_sc_mcu7t5v0__filltie
X_6521_ _6521_/A1 _6521_/A2 _6519_/Z _6523_/A2 _7682_/D VDD VDD VSS VSS gf180mcu_fd_sc_mcu7t5v0__and4_1
X_3733_ _3713_/Z _3733_/A2 _3738_/B VDD VDD VSS VSS gf180mcu_fd_sc_mcu7t5v0__xor2_1
X_6452_ _7667_/Q _7533_/Q _6453_/I VDD VDD VSS VSS gf180mcu_fd_sc_mcu7t5v0__xor2_1
XFILLER_9_282 VDD VDD VSS VSS gf180mcu_fd_sc_mcu7t5v0__fill_2
X_3664_ _3548_/Z _3662_/Z _3664_/B _3665_/A4 VDD VDD VSS VSS gf180mcu_fd_sc_mcu7t5v0__oai21_1
Xclkload30 _7504_/CLK clkload30/Z VDD VDD VSS VSS gf180mcu_fd_sc_mcu7t5v0__clkbuf_2
X_5403_ _5403_/A1 _5403_/A2 _7507_/D VDD VDD VSS VSS gf180mcu_fd_sc_mcu7t5v0__nand2_1
Xclkload41 _7792_/CLK clkload41/ZN VDD VDD VSS VSS gf180mcu_fd_sc_mcu7t5v0__inv_2
Xclkload52 _7189_/CLK clkload52/Z VDD VDD VSS VSS gf180mcu_fd_sc_mcu7t5v0__clkbuf_2
Xclkload74 _7008_/CLK clkload74/ZN VDD VDD VSS VSS gf180mcu_fd_sc_mcu7t5v0__inv_3
X_6383_ _7656_/Q _7522_/Q _6388_/A1 _6383_/Z VDD VDD VSS VSS gf180mcu_fd_sc_mcu7t5v0__xor3_1
X_3595_ input49/Z input50/Z input56/Z _3595_/Z VDD VDD VSS VSS gf180mcu_fd_sc_mcu7t5v0__xor3_1
Xclkload63 _7216_/CLK clkload63/Z VDD VDD VSS VSS gf180mcu_fd_sc_mcu7t5v0__clkbuf_2
X_5334_ _5341_/I0 _7481_/Q _5337_/S _7481_/D VDD VDD VSS VSS gf180mcu_fd_sc_mcu7t5v0__mux2_2
X_5265_ wire521/Z _7412_/Q _5267_/S _7412_/D VDD VDD VSS VSS gf180mcu_fd_sc_mcu7t5v0__mux2_2
X_7004_ _7004_/D _7276_/CLK _7004_/Q VDD VDD VSS VSS gf180mcu_fd_sc_mcu7t5v0__dffq_1
X_5196_ _5245_/I0 _7343_/Q _5197_/S _7343_/D VDD VDD VSS VSS gf180mcu_fd_sc_mcu7t5v0__mux2_2
X_4216_ _4223_/I0 _6823_/Q _5288_/S _6823_/D VDD VDD VSS VSS gf180mcu_fd_sc_mcu7t5v0__mux2_2
X_4147_ _4147_/A1 _4150_/A1 _5120_/A2 VDD VDD VSS VSS gf180mcu_fd_sc_mcu7t5v0__nand2_1
XFILLER_18_15 VDD VDD VSS VSS gf180mcu_fd_sc_mcu7t5v0__fill_2
XTAP_TAPCELL_ROW_39_800 VDD VSS gf180mcu_fd_sc_mcu7t5v0__filltie
XTAP_TAPCELL_ROW_39_811 VDD VSS gf180mcu_fd_sc_mcu7t5v0__filltie
XFILLER_18_37 VDD VDD VSS VSS gf180mcu_fd_sc_mcu7t5v0__fill_2
X_4078_ _4141_/A2 _4081_/A2 _4812_/A2 VDD VDD VSS VSS gf180mcu_fd_sc_mcu7t5v0__nand2_1
XTAP_TAPCELL_ROW_108_1772 VDD VSS gf180mcu_fd_sc_mcu7t5v0__filltie
XFILLER_24_521 VDD VDD VSS VSS gf180mcu_fd_sc_mcu7t5v0__fillcap_4
XFILLER_71_627 VDD VDD VSS VSS gf180mcu_fd_sc_mcu7t5v0__fill_2
X_7768_ _7768_/D _7827_/RN clkload7/I _7768_/Q VDD VDD VSS VSS gf180mcu_fd_sc_mcu7t5v0__dffrnq_1
Xclkload2 clkload2/I clkload2/ZN VDD VDD VSS VSS gf180mcu_fd_sc_mcu7t5v0__inv_12
X_6719_ _7757_/Q _6571_/S _7758_/Q _6720_/A2 VDD VDD VSS VSS gf180mcu_fd_sc_mcu7t5v0__aoi21_1
X_7699_ _7699_/D _7783_/RN _7792_/CLK _7699_/Q VDD VDD VSS VSS gf180mcu_fd_sc_mcu7t5v0__dffrnq_1
Xfanout261 _3859_/ZN _5072_/A1 VDD VDD VSS VSS gf180mcu_fd_sc_mcu7t5v0__dlyd_1
XFILLER_19_326 VDD VDD VSS VSS gf180mcu_fd_sc_mcu7t5v0__fill_1
XFILLER_75_977 VDD VDD VSS VSS gf180mcu_fd_sc_mcu7t5v0__fill_2
XFILLER_90_947 VDD VDD VSS VSS gf180mcu_fd_sc_mcu7t5v0__fillcap_32
XFILLER_28_871 VDD VDD VSS VSS gf180mcu_fd_sc_mcu7t5v0__fillcap_4
XTAP_TAPCELL_ROW_83_1422 VDD VSS gf180mcu_fd_sc_mcu7t5v0__filltie
XFILLER_30_579 VDD VDD VSS VSS gf180mcu_fd_sc_mcu7t5v0__fillcap_16
XFILLER_112_802 VDD VDD VSS VSS gf180mcu_fd_sc_mcu7t5v0__fill_2
XTAP_TAPCELL_ROW_94_1573 VDD VSS gf180mcu_fd_sc_mcu7t5v0__filltie
X_3380_ _7880_/I _3668_/A2 VDD VDD VSS VSS gf180mcu_fd_sc_mcu7t5v0__clkinv_1
XFILLER_97_557 VDD VDD VSS VSS gf180mcu_fd_sc_mcu7t5v0__fill_2
X_5050_ _5078_/A1 _5050_/A2 _5050_/B _7239_/D VDD VDD VSS VSS gf180mcu_fd_sc_mcu7t5v0__oai21_1
X_4001_ _4143_/A1 _4462_/A2 _4001_/B _6753_/D VDD VDD VSS VSS gf180mcu_fd_sc_mcu7t5v0__oai21_1
XFILLER_66_944 VDD VDD VSS VSS gf180mcu_fd_sc_mcu7t5v0__fill_1
XFILLER_93_774 VDD VDD VSS VSS gf180mcu_fd_sc_mcu7t5v0__fill_1
X_5952_ _7145_/Q _6167_/B1 _6085_/B1 _7222_/Q _7257_/Q wire355/Z _5953_/A2 VDD VDD
+ VSS VSS gf180mcu_fd_sc_mcu7t5v0__oai222_1
XFILLER_80_457 VDD VDD VSS VSS gf180mcu_fd_sc_mcu7t5v0__fill_1
X_4903_ _7166_/Q _4910_/A2 _4904_/B VDD VDD VSS VSS gf180mcu_fd_sc_mcu7t5v0__nand2_1
X_5883_ _6315_/A1 _6262_/A2 _5883_/B _5883_/C _5883_/ZN VDD VDD VSS VSS gf180mcu_fd_sc_mcu7t5v0__aoi211_1
XTAP_TAPCELL_ROW_44_880 VDD VSS gf180mcu_fd_sc_mcu7t5v0__filltie
X_7622_ _7622_/D _7703_/RN _7693_/CLK _7622_/Q VDD VDD VSS VSS gf180mcu_fd_sc_mcu7t5v0__dffrnq_1
X_4834_ _4918_/A1 _4840_/A2 _4834_/B _7131_/D VDD VDD VSS VSS gf180mcu_fd_sc_mcu7t5v0__oai21_1
X_4765_ _7097_/Q _4770_/A2 _4766_/B VDD VDD VSS VSS gf180mcu_fd_sc_mcu7t5v0__nand2_1
X_7553_ _7553_/D _7785_/RN _7794_/CLK _7553_/Q VDD VDD VSS VSS gf180mcu_fd_sc_mcu7t5v0__dffrnq_1
X_3716_ _3735_/A1 _3715_/Z _3717_/B VDD VDD VSS VSS gf180mcu_fd_sc_mcu7t5v0__nand2_1
X_6504_ _7675_/Q _7676_/Q _7677_/Q _6495_/Z _6508_/A2 VDD VDD VSS VSS gf180mcu_fd_sc_mcu7t5v0__nand4_1
XFILLER_107_629 VDD VDD VSS VSS gf180mcu_fd_sc_mcu7t5v0__fill_1
X_4696_ _4752_/A1 _4700_/A2 _4696_/B _7062_/D VDD VDD VSS VSS gf180mcu_fd_sc_mcu7t5v0__oai21_1
X_7484_ _7484_/D _7490_/CLK _7484_/Q VDD VDD VSS VSS gf180mcu_fd_sc_mcu7t5v0__dffq_1
X_6435_ _6479_/S _6434_/Z _6435_/B _7664_/D VDD VDD VSS VSS gf180mcu_fd_sc_mcu7t5v0__aoi21_1
X_3647_ input49/Z input48/Z _3646_/Z _3647_/Z VDD VDD VSS VSS gf180mcu_fd_sc_mcu7t5v0__xor3_1
X_6366_ _7649_/Q _6677_/A1 _6367_/B VDD VDD VSS VSS gf180mcu_fd_sc_mcu7t5v0__nand2_1
X_3578_ input44/Z input43/Z _3578_/Z VDD VDD VSS VSS gf180mcu_fd_sc_mcu7t5v0__xor2_1
XFILLER_88_524 VDD VDD VSS VSS gf180mcu_fd_sc_mcu7t5v0__fill_1
XFILLER_88_502 VDD VDD VSS VSS gf180mcu_fd_sc_mcu7t5v0__fill_2
X_5317_ _5345_/I0 _7464_/Q _5323_/S _7464_/D VDD VDD VSS VSS gf180mcu_fd_sc_mcu7t5v0__mux2_2
XTAP_TAPCELL_ROW_54_1012 VDD VSS gf180mcu_fd_sc_mcu7t5v0__filltie
X_6297_ _7534_/Q _6301_/B1 _6298_/B2 VDD VDD VSS VSS gf180mcu_fd_sc_mcu7t5v0__nand2_1
X_5248_ _5304_/I0 _7395_/Q _5253_/S _7395_/D VDD VDD VSS VSS gf180mcu_fd_sc_mcu7t5v0__mux2_2
XFILLER_29_47 VDD VDD VSS VSS gf180mcu_fd_sc_mcu7t5v0__fill_1
X_5179_ _5228_/I0 _7326_/Q _5183_/S _7326_/D VDD VDD VSS VSS gf180mcu_fd_sc_mcu7t5v0__mux2_2
XFILLER_72_947 VDD VDD VSS VSS gf180mcu_fd_sc_mcu7t5v0__fillcap_32
XTAP_TAPCELL_ROW_3_299 VDD VSS gf180mcu_fd_sc_mcu7t5v0__filltie
XFILLER_45_46 VDD VDD VSS VSS gf180mcu_fd_sc_mcu7t5v0__fill_1
XFILLER_44_649 VDD VDD VSS VSS gf180mcu_fd_sc_mcu7t5v0__fill_2
XTAP_TAPCELL_ROW_65_1163 VDD VSS gf180mcu_fd_sc_mcu7t5v0__filltie
XTAP_TAPCELL_ROW_65_1174 VDD VSS gf180mcu_fd_sc_mcu7t5v0__filltie
XFILLER_71_479 VDD VDD VSS VSS gf180mcu_fd_sc_mcu7t5v0__fill_1
XFILLER_12_524 VDD VDD VSS VSS gf180mcu_fd_sc_mcu7t5v0__fill_1
XFILLER_40_877 VDD VDD VSS VSS gf180mcu_fd_sc_mcu7t5v0__fillcap_64
Xclkbuf_3_6__f_clk_i clkbuf_0_clk_i/Z clkload5/I VDD VDD VSS VSS gf180mcu_fd_sc_mcu7t5v0__clkbuf_16
XTAP_TAPCELL_ROW_22_563 VDD VSS gf180mcu_fd_sc_mcu7t5v0__filltie
XFILLER_79_557 VDD VDD VSS VSS gf180mcu_fd_sc_mcu7t5v0__fill_2
XFILLER_79_535 VDD VDD VSS VSS gf180mcu_fd_sc_mcu7t5v0__fill_1
XFILLER_59_270 VDD VDD VSS VSS gf180mcu_fd_sc_mcu7t5v0__fill_1
XFILLER_90_733 VDD VDD VSS VSS gf180mcu_fd_sc_mcu7t5v0__fill_2
XFILLER_75_796 VDD VDD VSS VSS gf180mcu_fd_sc_mcu7t5v0__fill_1
XFILLER_43_693 VDD VDD VSS VSS gf180mcu_fd_sc_mcu7t5v0__fill_2
XFILLER_42_192 VDD VDD VSS VSS gf180mcu_fd_sc_mcu7t5v0__fill_1
XTAP_TAPCELL_ROW_96_1602 VDD VSS gf180mcu_fd_sc_mcu7t5v0__filltie
XFILLER_116_404 VDD VDD VSS VSS gf180mcu_fd_sc_mcu7t5v0__fill_1
X_4550_ _4550_/A1 _4560_/A2 _4550_/B _6989_/D VDD VDD VSS VSS gf180mcu_fd_sc_mcu7t5v0__oai21_1
XFILLER_7_550 VDD VDD VSS VSS gf180mcu_fd_sc_mcu7t5v0__fillcap_8
X_4481_ _6955_/Q _4490_/A2 _4482_/B VDD VDD VSS VSS gf180mcu_fd_sc_mcu7t5v0__nand2_1
X_3501_ _3925_/A3 _3505_/A2 _3502_/I VDD VDD VSS VSS gf180mcu_fd_sc_mcu7t5v0__xor2_1
Xwire481 wire481/I _6136_/B VDD VDD VSS VSS gf180mcu_fd_sc_mcu7t5v0__clkbuf_4
X_6220_ _6754_/Q _6229_/B1 _6228_/B1 _6755_/Q _6229_/C _6224_/A2 VDD VDD VSS VSS gf180mcu_fd_sc_mcu7t5v0__oai221_1
X_3432_ _7826_/Q _3797_/B VDD VDD VSS VSS gf180mcu_fd_sc_mcu7t5v0__clkinv_1
X_6151_ _7043_/Q _6151_/A2 wire313/Z _7050_/Q _7064_/Q _6151_/C2 _6152_/A2 VDD VDD
+ VSS VSS gf180mcu_fd_sc_mcu7t5v0__oai222_1
X_3363_ _7712_/Q _5753_/A1 VDD VDD VSS VSS gf180mcu_fd_sc_mcu7t5v0__clkinv_1
X_5102_ _5102_/A1 _5106_/A2 _5102_/B _7265_/D VDD VDD VSS VSS gf180mcu_fd_sc_mcu7t5v0__oai21_1
X_6082_ _6082_/A1 _6082_/A2 _6082_/B1 _6224_/B _7716_/Q _6096_/A1 VDD VDD VSS VSS
+ gf180mcu_fd_sc_mcu7t5v0__oai221_1
XFILLER_98_888 VDD VDD VSS VSS gf180mcu_fd_sc_mcu7t5v0__fill_2
XFILLER_98_877 VDD VDD VSS VSS gf180mcu_fd_sc_mcu7t5v0__fillcap_4
Xload_slew464 _5531_/B _5508_/C VDD VDD VSS VSS gf180mcu_fd_sc_mcu7t5v0__buf_4
XFILLER_58_719 VDD VDD VSS VSS gf180mcu_fd_sc_mcu7t5v0__fill_2
X_5033_ _7231_/Q _5036_/A2 _5034_/B VDD VDD VSS VSS gf180mcu_fd_sc_mcu7t5v0__nand2_1
Xload_slew475 _6603_/A1 _6244_/C VDD VDD VSS VSS gf180mcu_fd_sc_mcu7t5v0__buf_4
XTAP_TAPCELL_ROW_49_950 VDD VSS gf180mcu_fd_sc_mcu7t5v0__filltie
XFILLER_54_947 VDD VDD VSS VSS gf180mcu_fd_sc_mcu7t5v0__fillcap_32
XTAP_TAPCELL_ROW_105_1731 VDD VSS gf180mcu_fd_sc_mcu7t5v0__filltie
X_6984_ _6984_/D _7668_/CLK _6984_/Q VDD VDD VSS VSS gf180mcu_fd_sc_mcu7t5v0__dffq_1
XFILLER_81_766 VDD VDD VSS VSS gf180mcu_fd_sc_mcu7t5v0__fillcap_4
XTAP_TAPCELL_ROW_0_247 VDD VSS gf180mcu_fd_sc_mcu7t5v0__filltie
XTAP_TAPCELL_ROW_0_258 VDD VSS gf180mcu_fd_sc_mcu7t5v0__filltie
X_5935_ _5997_/C _5935_/A2 _5935_/B _6122_/C _5939_/A2 VDD VDD VSS VSS gf180mcu_fd_sc_mcu7t5v0__oai211_1
X_5866_ _7185_/Q _6055_/A2 _5866_/B _6242_/C _5867_/B VDD VDD VSS VSS gf180mcu_fd_sc_mcu7t5v0__oai211_1
X_7605_ _7605_/D _7612_/RN _7669_/CLK _7605_/Q VDD VDD VSS VSS gf180mcu_fd_sc_mcu7t5v0__dffrnq_1
XFILLER_22_877 VDD VDD VSS VSS gf180mcu_fd_sc_mcu7t5v0__fillcap_64
X_4817_ _7123_/Q _4826_/A2 _4818_/B VDD VDD VSS VSS gf180mcu_fd_sc_mcu7t5v0__nand2_1
X_5797_ _6918_/Q _6167_/B1 _6085_/B1 _6925_/Q _6195_/C _5798_/A2 VDD VDD VSS VSS gf180mcu_fd_sc_mcu7t5v0__oai221_1
X_7536_ _7536_/D _7664_/RN _7671_/CLK _7536_/Q VDD VDD VSS VSS gf180mcu_fd_sc_mcu7t5v0__dffrnq_1
X_4748_ _4748_/A1 _4756_/A2 _4748_/B _7088_/D VDD VDD VSS VSS gf180mcu_fd_sc_mcu7t5v0__oai21_1
XTAP_TAPCELL_ROW_60_1093 VDD VSS gf180mcu_fd_sc_mcu7t5v0__filltie
XFILLER_108_938 VDD VDD VSS VSS gf180mcu_fd_sc_mcu7t5v0__fillcap_4
X_4679_ _7054_/Q _4686_/A2 _4680_/B VDD VDD VSS VSS gf180mcu_fd_sc_mcu7t5v0__nand2_1
X_7467_ _7467_/D _7483_/CLK _7467_/Q VDD VDD VSS VSS gf180mcu_fd_sc_mcu7t5v0__dffq_1
X_6418_ _6418_/I _6426_/B VDD VDD VSS VSS gf180mcu_fd_sc_mcu7t5v0__clkinv_1
XPHY_EDGE_ROW_1_Right_1 VDD VSS gf180mcu_fd_sc_mcu7t5v0__endcap
XTAP_TAPCELL_ROW_116_1882 VDD VSS gf180mcu_fd_sc_mcu7t5v0__filltie
X_7398_ _7398_/D _7451_/CLK _7398_/Q VDD VDD VSS VSS gf180mcu_fd_sc_mcu7t5v0__dffq_1
XTAP_TAPCELL_ROW_8_369 VDD VSS gf180mcu_fd_sc_mcu7t5v0__filltie
X_6349_ _6349_/A1 _6341_/S _6349_/B _7636_/D VDD VDD VSS VSS gf180mcu_fd_sc_mcu7t5v0__oai21_1
Xinput104 tl_i[97] _6303_/I1 VDD VDD VSS VSS gf180mcu_fd_sc_mcu7t5v0__dlyd_1
XFILLER_16_104 VDD VDD VSS VSS gf180mcu_fd_sc_mcu7t5v0__fill_1
XFILLER_29_465 VDD VDD VSS VSS gf180mcu_fd_sc_mcu7t5v0__fill_1
XFILLER_56_262 VDD VDD VSS VSS gf180mcu_fd_sc_mcu7t5v0__fill_2
XTAP_TAPCELL_ROW_67_1203 VDD VSS gf180mcu_fd_sc_mcu7t5v0__filltie
XTAP_TAPCELL_ROW_27_633 VDD VSS gf180mcu_fd_sc_mcu7t5v0__filltie
XFILLER_44_457 VDD VDD VSS VSS gf180mcu_fd_sc_mcu7t5v0__fill_2
XFILLER_72_744 VDD VDD VSS VSS gf180mcu_fd_sc_mcu7t5v0__fill_1
XFILLER_72_766 VDD VDD VSS VSS gf180mcu_fd_sc_mcu7t5v0__fillcap_4
XTAP_TAPCELL_ROW_78_1354 VDD VSS gf180mcu_fd_sc_mcu7t5v0__filltie
XTAP_TAPCELL_ROW_91_1532 VDD VSS gf180mcu_fd_sc_mcu7t5v0__filltie
XFILLER_4_597 VDD VDD VSS VSS gf180mcu_fd_sc_mcu7t5v0__fillcap_64
XFILLER_95_836 VDD VDD VSS VSS gf180mcu_fd_sc_mcu7t5v0__fillcap_4
XFILLER_95_847 VDD VDD VSS VSS gf180mcu_fd_sc_mcu7t5v0__fillcap_8
XFILLER_36_947 VDD VDD VSS VSS gf180mcu_fd_sc_mcu7t5v0__fillcap_32
X_3981_ _4120_/A1 _3999_/A2 _4378_/A2 VDD VDD VSS VSS gf180mcu_fd_sc_mcu7t5v0__nand2_1
X_5720_ _5720_/A1 _5720_/A2 _5720_/A3 _5732_/A2 VDD VDD VSS VSS gf180mcu_fd_sc_mcu7t5v0__nor3_1
X_5651_ _7534_/Q input61/Z _5651_/S _7534_/D VDD VDD VSS VSS gf180mcu_fd_sc_mcu7t5v0__mux2_2
XTAP_TAPCELL_ROW_100_1661 VDD VSS gf180mcu_fd_sc_mcu7t5v0__filltie
XFILLER_31_696 VDD VDD VSS VSS gf180mcu_fd_sc_mcu7t5v0__fillcap_4
X_4602_ wire291/Z _4602_/A2 _4602_/B _7015_/D VDD VDD VSS VSS gf180mcu_fd_sc_mcu7t5v0__oai21_1
X_5582_ _5582_/A1 _5582_/A2 _5582_/B _5582_/C _5583_/B VDD VDD VSS VSS gf180mcu_fd_sc_mcu7t5v0__oai211_1
X_4533_ _6981_/Q _4546_/A2 _4534_/B VDD VDD VSS VSS gf180mcu_fd_sc_mcu7t5v0__nand2_1
X_7321_ _7321_/D _7492_/CLK _7321_/Q VDD VDD VSS VSS gf180mcu_fd_sc_mcu7t5v0__dffq_1
XFILLER_7_72 VDD VDD VSS VSS gf180mcu_fd_sc_mcu7t5v0__fill_1
XFILLER_7_380 VDD VDD VSS VSS gf180mcu_fd_sc_mcu7t5v0__fill_1
X_7252_ _7252_/D _7252_/CLK _7252_/Q VDD VDD VSS VSS gf180mcu_fd_sc_mcu7t5v0__dffq_1
X_4464_ _4506_/A1 _4476_/A2 _4464_/B _6946_/D VDD VDD VSS VSS gf180mcu_fd_sc_mcu7t5v0__oai21_1
X_6203_ _6203_/A1 _6203_/A2 _6203_/B1 _6203_/B2 _6218_/A2 VDD VDD VSS VSS gf180mcu_fd_sc_mcu7t5v0__oai22_1
X_4395_ _6912_/Q _4406_/A2 _4396_/B VDD VDD VSS VSS gf180mcu_fd_sc_mcu7t5v0__nand2_1
X_3415_ _7636_/Q _6349_/A1 VDD VDD VSS VSS gf180mcu_fd_sc_mcu7t5v0__clkinv_1
X_7183_ _7183_/D _7748_/CLK _7183_/Q VDD VDD VSS VSS gf180mcu_fd_sc_mcu7t5v0__dffq_1
XFILLER_100_602 VDD VDD VSS VSS gf180mcu_fd_sc_mcu7t5v0__fill_1
X_6134_ _6854_/Q _6593_/A2 _6201_/B1 _7281_/Q _6134_/C _6135_/A2 VDD VDD VSS VSS gf180mcu_fd_sc_mcu7t5v0__oai221_1
XTAP_TAPCELL_ROW_5_328 VDD VSS gf180mcu_fd_sc_mcu7t5v0__filltie
Xload_slew250 _4071_/A1 _4143_/A1 VDD VDD VSS VSS gf180mcu_fd_sc_mcu7t5v0__clkbuf_4
XFILLER_58_527 VDD VDD VSS VSS gf180mcu_fd_sc_mcu7t5v0__fill_1
X_6065_ _7746_/Q _5809_/I _6254_/B1 _7700_/Q _6065_/C _6067_/A3 VDD VDD VSS VSS gf180mcu_fd_sc_mcu7t5v0__aoi221_1
Xload_slew272 _4984_/A1 _4550_/A1 VDD VDD VSS VSS gf180mcu_fd_sc_mcu7t5v0__buf_4
X_5016_ _5086_/A1 _5022_/A2 _5016_/B _7222_/D VDD VDD VSS VSS gf180mcu_fd_sc_mcu7t5v0__oai21_1
Xload_slew294 _6254_/B1 _6268_/B1 VDD VDD VSS VSS gf180mcu_fd_sc_mcu7t5v0__buf_4
XFILLER_100_679 VDD VDD VSS VSS gf180mcu_fd_sc_mcu7t5v0__fill_1
XFILLER_26_37 VDD VDD VSS VSS gf180mcu_fd_sc_mcu7t5v0__fill_1
XFILLER_66_593 VDD VDD VSS VSS gf180mcu_fd_sc_mcu7t5v0__fill_2
X_6967_ _6967_/D _7003_/CLK _6967_/Q VDD VDD VSS VSS gf180mcu_fd_sc_mcu7t5v0__dffq_1
X_5918_ _6948_/Q _6198_/C2 _6197_/B _5920_/A1 VDD VDD VSS VSS gf180mcu_fd_sc_mcu7t5v0__oai21_1
XTAP_TAPCELL_ROW_62_1122 VDD VSS gf180mcu_fd_sc_mcu7t5v0__filltie
X_6898_ _6898_/D _6939_/CLK _6898_/Q VDD VDD VSS VSS gf180mcu_fd_sc_mcu7t5v0__dffq_1
XFILLER_42_25 VDD VDD VSS VSS gf180mcu_fd_sc_mcu7t5v0__fill_2
XTAP_TAPCELL_ROW_62_1133 VDD VSS gf180mcu_fd_sc_mcu7t5v0__filltie
XTAP_TAPCELL_ROW_52_989 VDD VSS gf180mcu_fd_sc_mcu7t5v0__filltie
X_5849_ _7115_/Q wire353/Z _6112_/A2 _7108_/Q _5854_/A1 VDD VDD VSS VSS gf180mcu_fd_sc_mcu7t5v0__oai22_1
XTAP_TAPCELL_ROW_118_1922 VDD VSS gf180mcu_fd_sc_mcu7t5v0__filltie
XTAP_TAPCELL_ROW_118_1911 VDD VSS gf180mcu_fd_sc_mcu7t5v0__filltie
XFILLER_6_807 VDD VDD VSS VSS gf180mcu_fd_sc_mcu7t5v0__fillcap_64
X_7519_ _7519_/D _7811_/RN clkload8/I _7519_/Q VDD VDD VSS VSS gf180mcu_fd_sc_mcu7t5v0__dffrnq_1
XTAP_TAPCELL_ROW_73_1284 VDD VSS gf180mcu_fd_sc_mcu7t5v0__filltie
XFILLER_1_556 VDD VDD VSS VSS gf180mcu_fd_sc_mcu7t5v0__fillcap_4
XFILLER_89_696 VDD VDD VSS VSS gf180mcu_fd_sc_mcu7t5v0__fillcap_4
XFILLER_92_817 VDD VDD VSS VSS gf180mcu_fd_sc_mcu7t5v0__fill_1
XFILLER_18_947 VDD VDD VSS VSS gf180mcu_fd_sc_mcu7t5v0__fillcap_32
XFILLER_33_906 VDD VDD VSS VSS gf180mcu_fd_sc_mcu7t5v0__fillcap_4
XFILLER_16_92 VDD VDD VSS VSS gf180mcu_fd_sc_mcu7t5v0__fill_2
XPHY_EDGE_ROW_17_Left_136 VDD VSS gf180mcu_fd_sc_mcu7t5v0__endcap
XFILLER_13_696 VDD VDD VSS VSS gf180mcu_fd_sc_mcu7t5v0__fillcap_4
XFILLER_40_482 VDD VDD VSS VSS gf180mcu_fd_sc_mcu7t5v0__fill_1
XFILLER_8_177 VDD VDD VSS VSS gf180mcu_fd_sc_mcu7t5v0__fill_1
XFILLER_99_405 VDD VDD VSS VSS gf180mcu_fd_sc_mcu7t5v0__fill_1
XTAP_TAPCELL_ROW_10_396 VDD VSS gf180mcu_fd_sc_mcu7t5v0__filltie
XPHY_EDGE_ROW_26_Left_145 VDD VSS gf180mcu_fd_sc_mcu7t5v0__endcap
X_4180_ _4238_/I0 _6808_/Q _5183_/S _6808_/D VDD VDD VSS VSS gf180mcu_fd_sc_mcu7t5v0__mux2_2
XFILLER_68_858 VDD VDD VSS VSS gf180mcu_fd_sc_mcu7t5v0__fill_2
XFILLER_91_850 VDD VDD VSS VSS gf180mcu_fd_sc_mcu7t5v0__fillcap_4
X_6821_ _6821_/D _7499_/CLK _6821_/Q VDD VDD VSS VSS gf180mcu_fd_sc_mcu7t5v0__dffq_1
XPHY_EDGE_ROW_35_Left_154 VDD VSS gf180mcu_fd_sc_mcu7t5v0__endcap
X_6752_ _6752_/D _6944_/CLK _6752_/Q VDD VDD VSS VSS gf180mcu_fd_sc_mcu7t5v0__dffq_1
X_3964_ _6743_/Q _4322_/A2 _3965_/B VDD VDD VSS VSS gf180mcu_fd_sc_mcu7t5v0__nand2_1
XFILLER_50_257 VDD VDD VSS VSS gf180mcu_fd_sc_mcu7t5v0__fill_2
X_6683_ _7743_/Q _6694_/A2 _6685_/B VDD VDD VSS VSS gf180mcu_fd_sc_mcu7t5v0__nand2_1
X_3895_ _6370_/A2 _3895_/A2 _3895_/A3 _7784_/D VDD VDD VSS VSS gf180mcu_fd_sc_mcu7t5v0__nand3_1
X_5703_ _7616_/Q _7673_/Q _5703_/Z VDD VDD VSS VSS gf180mcu_fd_sc_mcu7t5v0__xor2_1
X_5634_ _5634_/A1 _5634_/A2 _5634_/B _7518_/D VDD VDD VSS VSS gf180mcu_fd_sc_mcu7t5v0__aoi21_1
X_7304_ _7304_/D _7418_/CLK _7304_/Q VDD VDD VSS VSS gf180mcu_fd_sc_mcu7t5v0__dffq_1
X_5565_ _7491_/Q _5604_/A2 _5607_/A2 _7484_/Q _7470_/Q wire420/I _5566_/A2 VDD VDD
+ VSS VSS gf180mcu_fd_sc_mcu7t5v0__oai222_1
X_4516_ _5118_/A1 _4518_/A2 _4516_/B _6972_/D VDD VDD VSS VSS gf180mcu_fd_sc_mcu7t5v0__oai21_1
X_5496_ _5496_/A1 _5496_/A2 _7510_/D VDD VDD VSS VSS gf180mcu_fd_sc_mcu7t5v0__nand2_1
XPHY_EDGE_ROW_44_Left_163 VDD VSS gf180mcu_fd_sc_mcu7t5v0__endcap
X_4447_ _6938_/Q _4448_/A2 _4448_/B VDD VDD VSS VSS gf180mcu_fd_sc_mcu7t5v0__nand2_1
XTAP_TAPCELL_ROW_113_1841 VDD VSS gf180mcu_fd_sc_mcu7t5v0__filltie
X_7235_ _7235_/D _7247_/CLK _7235_/Q VDD VDD VSS VSS gf180mcu_fd_sc_mcu7t5v0__dffq_1
X_7166_ _7166_/D _7719_/CLK _7166_/Q VDD VDD VSS VSS gf180mcu_fd_sc_mcu7t5v0__dffq_1
X_4378_ _4532_/A1 _4378_/A2 _4378_/B _6903_/D VDD VDD VSS VSS gf180mcu_fd_sc_mcu7t5v0__oai21_1
X_6117_ _7035_/Q _6153_/A2 _6153_/B1 _7014_/Q _6208_/C _6121_/A2 VDD VDD VSS VSS gf180mcu_fd_sc_mcu7t5v0__oai221_1
XFILLER_101_977 VDD VDD VSS VSS gf180mcu_fd_sc_mcu7t5v0__fill_2
X_7097_ _7097_/D _7097_/CLK _7097_/Q VDD VDD VSS VSS gf180mcu_fd_sc_mcu7t5v0__dffq_1
XFILLER_100_465 VDD VDD VSS VSS gf180mcu_fd_sc_mcu7t5v0__fill_1
X_6048_ _7209_/Q _6233_/B1 _6174_/B _6052_/A1 VDD VDD VSS VSS gf180mcu_fd_sc_mcu7t5v0__oai21_1
XFILLER_15_906 VDD VDD VSS VSS gf180mcu_fd_sc_mcu7t5v0__fillcap_4
XFILLER_27_766 VDD VDD VSS VSS gf180mcu_fd_sc_mcu7t5v0__fillcap_4
XPHY_EDGE_ROW_53_Left_172 VDD VSS gf180mcu_fd_sc_mcu7t5v0__endcap
XTAP_TAPCELL_ROW_37_772 VDD VSS gf180mcu_fd_sc_mcu7t5v0__filltie
XTAP_TAPCELL_ROW_37_783 VDD VSS gf180mcu_fd_sc_mcu7t5v0__filltie
XFILLER_41_224 VDD VDD VSS VSS gf180mcu_fd_sc_mcu7t5v0__fill_1
XTAP_TAPCELL_ROW_75_1302 VDD VSS gf180mcu_fd_sc_mcu7t5v0__filltie
XPHY_EDGE_ROW_62_Left_181 VDD VSS gf180mcu_fd_sc_mcu7t5v0__endcap
XTAP_TAPCELL_ROW_75_1313 VDD VSS gf180mcu_fd_sc_mcu7t5v0__filltie
XFILLER_65_806 VDD VDD VSS VSS gf180mcu_fd_sc_mcu7t5v0__fillcap_4
XPHY_EDGE_ROW_71_Left_190 VDD VSS gf180mcu_fd_sc_mcu7t5v0__endcap
XTAP_TAPCELL_ROW_86_1464 VDD VSS gf180mcu_fd_sc_mcu7t5v0__filltie
XFILLER_73_850 VDD VDD VSS VSS gf180mcu_fd_sc_mcu7t5v0__fill_2
XFILLER_60_522 VDD VDD VSS VSS gf180mcu_fd_sc_mcu7t5v0__fill_2
XFILLER_32_257 VDD VDD VSS VSS gf180mcu_fd_sc_mcu7t5v0__fill_2
XFILLER_60_544 VDD VDD VSS VSS gf180mcu_fd_sc_mcu7t5v0__fillcap_8
XTAP_TAPCELL_ROW_15_466 VDD VSS gf180mcu_fd_sc_mcu7t5v0__filltie
X_3680_ _3677_/S _3386_/I _3681_/B VDD VDD VSS VSS gf180mcu_fd_sc_mcu7t5v0__nor2_1
X_5350_ _7644_/Q _7497_/Q _5351_/S _7497_/D VDD VDD VSS VSS gf180mcu_fd_sc_mcu7t5v0__mux2_2
XFILLER_114_524 VDD VDD VSS VSS gf180mcu_fd_sc_mcu7t5v0__fill_1
X_4301_ _6865_/Q _4308_/A2 _4302_/B VDD VDD VSS VSS gf180mcu_fd_sc_mcu7t5v0__nand2_1
X_5281_ _5309_/I0 _7428_/Q _5281_/S _7428_/D VDD VDD VSS VSS gf180mcu_fd_sc_mcu7t5v0__mux2_2
X_7020_ _7020_/D _7062_/CLK _7020_/Q VDD VDD VSS VSS gf180mcu_fd_sc_mcu7t5v0__dffq_1
X_4232_ _4234_/I0 _6830_/Q _5337_/S _6830_/D VDD VDD VSS VSS gf180mcu_fd_sc_mcu7t5v0__mux2_2
XFILLER_95_441 VDD VDD VSS VSS gf180mcu_fd_sc_mcu7t5v0__fill_2
X_4163_ _6651_/A1 _4237_/A1 _5148_/S VDD VDD VSS VSS gf180mcu_fd_sc_mcu7t5v0__nand2_1
X_4094_ _4146_/A1 _4868_/A2 _4094_/B _6782_/D VDD VDD VSS VSS gf180mcu_fd_sc_mcu7t5v0__oai21_1
XFILLER_56_828 VDD VDD VSS VSS gf180mcu_fd_sc_mcu7t5v0__fillcap_4
XFILLER_83_669 VDD VDD VSS VSS gf180mcu_fd_sc_mcu7t5v0__fill_2
XFILLER_64_872 VDD VDD VSS VSS gf180mcu_fd_sc_mcu7t5v0__fill_2
XFILLER_36_574 VDD VDD VSS VSS gf180mcu_fd_sc_mcu7t5v0__fillcap_16
X_6804_ _6804_/D _7504_/CLK _6804_/Q VDD VDD VSS VSS gf180mcu_fd_sc_mcu7t5v0__dffq_1
XTAP_TAPCELL_ROW_34_731 VDD VSS gf180mcu_fd_sc_mcu7t5v0__filltie
XFILLER_51_544 VDD VDD VSS VSS gf180mcu_fd_sc_mcu7t5v0__fillcap_8
X_4996_ _4996_/A1 _5008_/A2 _4996_/B _7212_/D VDD VDD VSS VSS gf180mcu_fd_sc_mcu7t5v0__oai21_1
X_7784_ _7784_/D _7791_/RN _7792_/CLK _7784_/Q VDD VDD VSS VSS gf180mcu_fd_sc_mcu7t5v0__dffrnq_1
X_3947_ _6739_/Q _4266_/A2 _3948_/B VDD VDD VSS VSS gf180mcu_fd_sc_mcu7t5v0__nand2_1
X_6735_ _7764_/Q _6735_/A2 _6735_/B _7764_/D VDD VDD VSS VSS gf180mcu_fd_sc_mcu7t5v0__aoi21_1
XFILLER_23_279 VDD VDD VSS VSS gf180mcu_fd_sc_mcu7t5v0__fill_1
X_6666_ _7740_/Q _3786_/Z _6667_/A3 VDD VDD VSS VSS gf180mcu_fd_sc_mcu7t5v0__nor2_1
X_3878_ _6363_/A1 _3877_/Z _3890_/A2 VDD VDD VSS VSS gf180mcu_fd_sc_mcu7t5v0__nor2_1
XFILLER_118_852 VDD VDD VSS VSS gf180mcu_fd_sc_mcu7t5v0__fillcap_32
X_5617_ _5366_/Z _5616_/Z _5618_/C VDD VDD VSS VSS gf180mcu_fd_sc_mcu7t5v0__nand2_1
X_6597_ _5926_/B _6597_/A2 _6597_/Z VDD VDD VSS VSS gf180mcu_fd_sc_mcu7t5v0__xor2_1
X_5548_ _5548_/I _5549_/B VDD VDD VSS VSS gf180mcu_fd_sc_mcu7t5v0__clkinv_1
XFILLER_105_535 VDD VDD VSS VSS gf180mcu_fd_sc_mcu7t5v0__fill_1
XTAP_TAPCELL_ROW_57_1054 VDD VSS gf180mcu_fd_sc_mcu7t5v0__filltie
X_5479_ _5584_/S _5479_/A2 _5479_/A3 _5479_/B1 _5479_/B2 _5493_/I0 VDD VDD VSS VSS
+ gf180mcu_fd_sc_mcu7t5v0__oai32_1
X_7218_ _7218_/D _7218_/CLK _7218_/Q VDD VDD VSS VSS gf180mcu_fd_sc_mcu7t5v0__dffq_1
XFILLER_99_780 VDD VDD VSS VSS gf180mcu_fd_sc_mcu7t5v0__fillcap_4
XFILLER_87_920 VDD VDD VSS VSS gf180mcu_fd_sc_mcu7t5v0__fillcap_32
Xfanout421 _5596_/B1 _5442_/A2 VDD VDD VSS VSS gf180mcu_fd_sc_mcu7t5v0__dlyd_1
XTAP_TAPCELL_ROW_70_1232 VDD VSS gf180mcu_fd_sc_mcu7t5v0__filltie
Xfanout465 _5577_/B _6634_/B VDD VDD VSS VSS gf180mcu_fd_sc_mcu7t5v0__dlyd_1
X_7149_ _7149_/D _7233_/CLK _7149_/Q VDD VDD VSS VSS gf180mcu_fd_sc_mcu7t5v0__dffq_1
XTAP_TAPCELL_ROW_70_1243 VDD VSS gf180mcu_fd_sc_mcu7t5v0__filltie
Xfanout476 _7717_/Q _6124_/S VDD VDD VSS VSS gf180mcu_fd_sc_mcu7t5v0__dlyd_1
XFILLER_27_530 VDD VDD VSS VSS gf180mcu_fd_sc_mcu7t5v0__fillcap_16
XFILLER_42_500 VDD VDD VSS VSS gf180mcu_fd_sc_mcu7t5v0__fillcap_4
XTAP_TAPCELL_ROW_81_1394 VDD VSS gf180mcu_fd_sc_mcu7t5v0__filltie
XTAP_TAPCELL_ROW_12_425 VDD VSS gf180mcu_fd_sc_mcu7t5v0__filltie
XFILLER_80_628 VDD VDD VSS VSS gf180mcu_fd_sc_mcu7t5v0__fillcap_8
XFILLER_18_574 VDD VDD VSS VSS gf180mcu_fd_sc_mcu7t5v0__fillcap_16
XFILLER_46_872 VDD VDD VSS VSS gf180mcu_fd_sc_mcu7t5v0__fill_2
X_4850_ _5060_/A1 _4854_/A2 _4850_/B _7139_/D VDD VDD VSS VSS gf180mcu_fd_sc_mcu7t5v0__oai21_1
XFILLER_61_842 VDD VDD VSS VSS gf180mcu_fd_sc_mcu7t5v0__fill_2
X_3801_ _7816_/D _7816_/Q _3802_/A2 VDD VDD VSS VSS gf180mcu_fd_sc_mcu7t5v0__nand2_1
XFILLER_61_886 VDD VDD VSS VSS gf180mcu_fd_sc_mcu7t5v0__fillcap_16
X_6520_ _7682_/Q _6516_/Z _6523_/A2 VDD VDD VSS VSS gf180mcu_fd_sc_mcu7t5v0__nand2_1
X_4781_ _7105_/Q _4784_/A2 _4782_/B VDD VDD VSS VSS gf180mcu_fd_sc_mcu7t5v0__nand2_1
XTAP_TAPCELL_ROW_99_1644 VDD VSS gf180mcu_fd_sc_mcu7t5v0__filltie
X_3732_ _3730_/Z _5877_/A1 _3738_/A2 VDD VDD VSS VSS gf180mcu_fd_sc_mcu7t5v0__nand2_1
X_6451_ _7667_/Q _6451_/A2 _6458_/B VDD VDD VSS VSS gf180mcu_fd_sc_mcu7t5v0__nand2_1
Xclkload20 _7793_/CLK clkload20/ZN VDD VDD VSS VSS gf180mcu_fd_sc_mcu7t5v0__clkinv_2
X_3663_ _3619_/Z _3663_/A2 _3662_/Z _3548_/Z _3664_/B VDD VDD VSS VSS gf180mcu_fd_sc_mcu7t5v0__aoi22_1
X_6382_ _7656_/Q _7522_/Q _6388_/A2 VDD VDD VSS VSS gf180mcu_fd_sc_mcu7t5v0__nor2_1
Xclkload31 _7491_/CLK clkload31/ZN VDD VDD VSS VSS gf180mcu_fd_sc_mcu7t5v0__inv_2
X_5402_ _7507_/Q _6733_/A4 _5403_/A2 VDD VDD VSS VSS gf180mcu_fd_sc_mcu7t5v0__nand2_1
Xclkload53 _7247_/CLK clkload53/Z VDD VDD VSS VSS gf180mcu_fd_sc_mcu7t5v0__clkbuf_4
Xclkload42 _7755_/CLK clkload42/ZN VDD VDD VSS VSS gf180mcu_fd_sc_mcu7t5v0__clkinv_2
Xclkload75 _6939_/CLK clkload75/Z VDD VDD VSS VSS gf180mcu_fd_sc_mcu7t5v0__clkbuf_4
X_5333_ _5347_/I0 _7480_/Q _5337_/S _7480_/D VDD VDD VSS VSS gf180mcu_fd_sc_mcu7t5v0__mux2_2
Xclkload64 _7218_/CLK clkload64/ZN VDD VDD VSS VSS gf180mcu_fd_sc_mcu7t5v0__clkinv_8
X_3594_ input44/Z input59/Z _3594_/Z VDD VDD VSS VSS gf180mcu_fd_sc_mcu7t5v0__xor2_1
XFILLER_88_717 VDD VDD VSS VSS gf180mcu_fd_sc_mcu7t5v0__fillcap_8
XTAP_TAPCELL_ROW_110_1800 VDD VSS gf180mcu_fd_sc_mcu7t5v0__filltie
X_5264_ wire525/Z _7411_/Q _5267_/S _7411_/D VDD VDD VSS VSS gf180mcu_fd_sc_mcu7t5v0__mux2_2
X_7003_ _7003_/D _7003_/CLK _7003_/Q VDD VDD VSS VSS gf180mcu_fd_sc_mcu7t5v0__dffq_1
X_5195_ _5244_/I0 _7342_/Q _5197_/S _7342_/D VDD VDD VSS VSS gf180mcu_fd_sc_mcu7t5v0__mux2_2
X_4215_ _6651_/A2 _4219_/A2 _5288_/S VDD VDD VSS VSS gf180mcu_fd_sc_mcu7t5v0__nand2_1
XFILLER_110_560 VDD VDD VSS VSS gf180mcu_fd_sc_mcu7t5v0__fill_1
X_4146_ _4146_/A1 _5106_/A2 _4146_/B _6799_/D VDD VDD VSS VSS gf180mcu_fd_sc_mcu7t5v0__oai21_1
XTAP_TAPCELL_ROW_39_801 VDD VSS gf180mcu_fd_sc_mcu7t5v0__filltie
XFILLER_69_975 VDD VDD VSS VSS gf180mcu_fd_sc_mcu7t5v0__fillcap_4
XFILLER_18_49 VDD VDD VSS VSS gf180mcu_fd_sc_mcu7t5v0__fill_2
XFILLER_83_444 VDD VDD VSS VSS gf180mcu_fd_sc_mcu7t5v0__fill_2
X_4077_ _4088_/A1 _4798_/A2 _4077_/B _6777_/D VDD VDD VSS VSS gf180mcu_fd_sc_mcu7t5v0__oai21_1
XTAP_TAPCELL_ROW_108_1773 VDD VSS gf180mcu_fd_sc_mcu7t5v0__filltie
XFILLER_52_853 VDD VDD VSS VSS gf180mcu_fd_sc_mcu7t5v0__fillcap_16
XFILLER_51_352 VDD VDD VSS VSS gf180mcu_fd_sc_mcu7t5v0__fill_1
X_7767_ _7767_/D _7823_/RN clkload7/I _7767_/Q VDD VDD VSS VSS gf180mcu_fd_sc_mcu7t5v0__dffrnq_1
X_4979_ _7204_/Q _4980_/A2 _4980_/B VDD VDD VSS VSS gf180mcu_fd_sc_mcu7t5v0__nand2_1
X_6718_ _7757_/Q _6571_/S _7757_/D VDD VDD VSS VSS gf180mcu_fd_sc_mcu7t5v0__xor2_1
Xclkload3 clkload3/I clkload3/ZN VDD VDD VSS VSS gf180mcu_fd_sc_mcu7t5v0__clkinv_16
X_7698_ _7698_/D _7783_/RN _7780_/CLK _7698_/Q VDD VDD VSS VSS gf180mcu_fd_sc_mcu7t5v0__dffrnq_1
XFILLER_109_137 VDD VDD VSS VSS gf180mcu_fd_sc_mcu7t5v0__fill_2
X_6649_ _7732_/Q _6652_/A1 _6649_/B _7732_/D VDD VDD VSS VSS gf180mcu_fd_sc_mcu7t5v0__oai21_1
XFILLER_106_822 VDD VDD VSS VSS gf180mcu_fd_sc_mcu7t5v0__fill_1
Xfanout251 fanout251/I _4029_/A1 VDD VDD VSS VSS gf180mcu_fd_sc_mcu7t5v0__dlyd_1
XFILLER_46_113 VDD VDD VSS VSS gf180mcu_fd_sc_mcu7t5v0__fill_1
Xfanout284 _5120_/A1 _4336_/A1 VDD VDD VSS VSS gf180mcu_fd_sc_mcu7t5v0__dlyd_1
Xfanout295 _5754_/ZN _6241_/B1 VDD VDD VSS VSS gf180mcu_fd_sc_mcu7t5v0__dlyd_1
XFILLER_90_904 VDD VDD VSS VSS gf180mcu_fd_sc_mcu7t5v0__fillcap_4
XFILLER_34_319 VDD VDD VSS VSS gf180mcu_fd_sc_mcu7t5v0__fill_1
XFILLER_62_639 VDD VDD VSS VSS gf180mcu_fd_sc_mcu7t5v0__fill_1
XTAP_TAPCELL_ROW_83_1423 VDD VSS gf180mcu_fd_sc_mcu7t5v0__filltie
XFILLER_43_842 VDD VDD VSS VSS gf180mcu_fd_sc_mcu7t5v0__fillcap_64
XFILLER_55_691 VDD VDD VSS VSS gf180mcu_fd_sc_mcu7t5v0__fill_1
XFILLER_15_555 VDD VDD VSS VSS gf180mcu_fd_sc_mcu7t5v0__fillcap_4
XFILLER_30_547 VDD VDD VSS VSS gf180mcu_fd_sc_mcu7t5v0__fillcap_32
XFILLER_11_772 VDD VDD VSS VSS gf180mcu_fd_sc_mcu7t5v0__fillcap_64
XTAP_TAPCELL_ROW_94_1574 VDD VSS gf180mcu_fd_sc_mcu7t5v0__filltie
X_4000_ _6753_/Q _4462_/A2 _4001_/B VDD VDD VSS VSS gf180mcu_fd_sc_mcu7t5v0__nand2_1
Xclkbuf_leaf_52_clk_i clkload6/I _7097_/CLK VDD VDD VSS VSS gf180mcu_fd_sc_mcu7t5v0__clkbuf_8
XFILLER_78_783 VDD VDD VSS VSS gf180mcu_fd_sc_mcu7t5v0__fill_2
X_5951_ _7264_/Q _6087_/A2 _6195_/C _5953_/A1 VDD VDD VSS VSS gf180mcu_fd_sc_mcu7t5v0__oai21_1
XPHY_EDGE_ROW_9_Left_128 VDD VSS gf180mcu_fd_sc_mcu7t5v0__endcap
Xclkbuf_leaf_67_clk_i clkload4/I _7216_/CLK VDD VDD VSS VSS gf180mcu_fd_sc_mcu7t5v0__clkbuf_8
X_4902_ _5112_/A1 _4910_/A2 _4902_/B _7165_/D VDD VDD VSS VSS gf180mcu_fd_sc_mcu7t5v0__oai21_1
X_5882_ _5882_/A1 _5882_/A2 _5882_/Z VDD VDD VSS VSS gf180mcu_fd_sc_mcu7t5v0__and2_1
X_7621_ _7621_/D _7703_/RN _7703_/CLK _7621_/Q VDD VDD VSS VSS gf180mcu_fd_sc_mcu7t5v0__dffrnq_1
XTAP_TAPCELL_ROW_44_870 VDD VSS gf180mcu_fd_sc_mcu7t5v0__filltie
XTAP_TAPCELL_ROW_44_881 VDD VSS gf180mcu_fd_sc_mcu7t5v0__filltie
X_4833_ _7131_/Q _4840_/A2 _4834_/B VDD VDD VSS VSS gf180mcu_fd_sc_mcu7t5v0__nand2_1
X_7552_ _7552_/D _7740_/RN _7793_/CLK _7552_/Q VDD VDD VSS VSS gf180mcu_fd_sc_mcu7t5v0__dffrnq_1
X_4764_ _4988_/A1 _4770_/A2 _4764_/B _7096_/D VDD VDD VSS VSS gf180mcu_fd_sc_mcu7t5v0__oai21_1
X_7483_ _7483_/D _7483_/CLK _7483_/Q VDD VDD VSS VSS gf180mcu_fd_sc_mcu7t5v0__dffq_1
X_3715_ _7727_/Q _4165_/A2 _3715_/Z VDD VDD VSS VSS gf180mcu_fd_sc_mcu7t5v0__xor2_1
X_6503_ _6538_/A1 _6502_/Z _7676_/D VDD VDD VSS VSS gf180mcu_fd_sc_mcu7t5v0__nor2_1
X_6434_ _6434_/A1 _6434_/A2 _6434_/Z VDD VDD VSS VSS gf180mcu_fd_sc_mcu7t5v0__xor2_1
X_4695_ _7062_/Q _4700_/A2 _4696_/B VDD VDD VSS VSS gf180mcu_fd_sc_mcu7t5v0__nand2_1
XFILLER_106_107 VDD VDD VSS VSS gf180mcu_fd_sc_mcu7t5v0__fill_1
X_3646_ _3576_/Z _3646_/A2 _3645_/Z _3646_/Z VDD VDD VSS VSS gf180mcu_fd_sc_mcu7t5v0__xor3_1
X_6365_ _6677_/A1 _6365_/A2 _6365_/B _7648_/D VDD VDD VSS VSS gf180mcu_fd_sc_mcu7t5v0__oai21_1
X_3577_ input55/Z input54/Z _3592_/A3 VDD VDD VSS VSS gf180mcu_fd_sc_mcu7t5v0__xnor2_1
X_6296_ _6296_/A1 _6298_/A2 _6300_/B1 _6296_/B2 _7600_/D VDD VDD VSS VSS gf180mcu_fd_sc_mcu7t5v0__aoi22_1
XFILLER_0_407 VDD VDD VSS VSS gf180mcu_fd_sc_mcu7t5v0__fill_1
X_5316_ _5344_/I0 _7463_/Q _5316_/S _7463_/D VDD VDD VSS VSS gf180mcu_fd_sc_mcu7t5v0__mux2_2
XTAP_TAPCELL_ROW_54_1013 VDD VSS gf180mcu_fd_sc_mcu7t5v0__filltie
XFILLER_115_696 VDD VDD VSS VSS gf180mcu_fd_sc_mcu7t5v0__fillcap_4
XFILLER_76_709 VDD VDD VSS VSS gf180mcu_fd_sc_mcu7t5v0__fill_1
X_5247_ _5303_/I0 _7394_/Q _5253_/S _7394_/D VDD VDD VSS VSS gf180mcu_fd_sc_mcu7t5v0__mux2_2
XFILLER_57_912 VDD VDD VSS VSS gf180mcu_fd_sc_mcu7t5v0__fillcap_64
XFILLER_69_772 VDD VDD VSS VSS gf180mcu_fd_sc_mcu7t5v0__fill_2
X_5178_ _5339_/I0 _7325_/Q _5183_/S _7325_/D VDD VDD VSS VSS gf180mcu_fd_sc_mcu7t5v0__mux2_2
XFILLER_28_113 VDD VDD VSS VSS gf180mcu_fd_sc_mcu7t5v0__fill_1
X_4129_ _4129_/A1 _4135_/A2 _5036_/A2 VDD VDD VSS VSS gf180mcu_fd_sc_mcu7t5v0__nand2_1
XFILLER_25_842 VDD VDD VSS VSS gf180mcu_fd_sc_mcu7t5v0__fillcap_64
XFILLER_80_981 VDD VDD VSS VSS gf180mcu_fd_sc_mcu7t5v0__fill_1
XFILLER_40_801 VDD VDD VSS VSS gf180mcu_fd_sc_mcu7t5v0__fillcap_4
XFILLER_52_650 VDD VDD VSS VSS gf180mcu_fd_sc_mcu7t5v0__fill_1
XFILLER_52_672 VDD VDD VSS VSS gf180mcu_fd_sc_mcu7t5v0__fill_1
XTAP_TAPCELL_ROW_65_1164 VDD VSS gf180mcu_fd_sc_mcu7t5v0__filltie
X_7819_ _7819_/D _7822_/RN _7823_/CLK _7819_/Q VDD VDD VSS VSS gf180mcu_fd_sc_mcu7t5v0__dffrnq_1
XTAP_TAPCELL_ROW_65_1175 VDD VSS gf180mcu_fd_sc_mcu7t5v0__filltie
XTAP_TAPCELL_ROW_22_564 VDD VSS gf180mcu_fd_sc_mcu7t5v0__filltie
XFILLER_20_591 VDD VDD VSS VSS gf180mcu_fd_sc_mcu7t5v0__fillcap_4
XFILLER_6_19 VDD VDD VSS VSS gf180mcu_fd_sc_mcu7t5v0__fill_1
XFILLER_106_685 VDD VDD VSS VSS gf180mcu_fd_sc_mcu7t5v0__fill_2
XFILLER_87_580 VDD VDD VSS VSS gf180mcu_fd_sc_mcu7t5v0__fill_2
XFILLER_47_422 VDD VDD VSS VSS gf180mcu_fd_sc_mcu7t5v0__fill_1
XFILLER_19_157 VDD VDD VSS VSS gf180mcu_fd_sc_mcu7t5v0__fill_1
XFILLER_47_488 VDD VDD VSS VSS gf180mcu_fd_sc_mcu7t5v0__fill_2
XFILLER_15_341 VDD VDD VSS VSS gf180mcu_fd_sc_mcu7t5v0__fill_1
XFILLER_43_672 VDD VDD VSS VSS gf180mcu_fd_sc_mcu7t5v0__fillcap_8
XFILLER_117_906 VDD VDD VSS VSS gf180mcu_fd_sc_mcu7t5v0__fillcap_4
XTAP_TAPCELL_ROW_96_1603 VDD VSS gf180mcu_fd_sc_mcu7t5v0__filltie
X_3500_ _3491_/I _3500_/A2 _3500_/B _3505_/A2 VDD VDD VSS VSS gf180mcu_fd_sc_mcu7t5v0__aoi21_1
X_4480_ _5124_/A1 _4490_/A2 _4480_/B _6954_/D VDD VDD VSS VSS gf180mcu_fd_sc_mcu7t5v0__oai21_1
XFILLER_7_562 VDD VDD VSS VSS gf180mcu_fd_sc_mcu7t5v0__fillcap_64
X_3431_ _7799_/Q _6486_/A1 VDD VDD VSS VSS gf180mcu_fd_sc_mcu7t5v0__clkinv_1
X_6150_ _7057_/Q _6154_/A2 _6204_/B _6152_/A1 VDD VDD VSS VSS gf180mcu_fd_sc_mcu7t5v0__oai21_1
X_3362_ _7719_/Q _6609_/A1 VDD VDD VSS VSS gf180mcu_fd_sc_mcu7t5v0__clkinv_1
X_5101_ _7265_/Q _5106_/A2 _5102_/B VDD VDD VSS VSS gf180mcu_fd_sc_mcu7t5v0__nand2_1
Xload_slew410 fanout409/Z _6214_/A2 VDD VDD VSS VSS gf180mcu_fd_sc_mcu7t5v0__clkbuf_4
X_6081_ _6081_/A1 _6081_/A2 _6081_/B _6082_/B1 VDD VDD VSS VSS gf180mcu_fd_sc_mcu7t5v0__oai21_1
Xload_slew432 _5612_/A2 _5535_/C2 VDD VDD VSS VSS gf180mcu_fd_sc_mcu7t5v0__buf_4
XFILLER_39_912 VDD VDD VSS VSS gf180mcu_fd_sc_mcu7t5v0__fillcap_64
X_5032_ wire241/Z _5036_/A2 _5032_/B _7230_/D VDD VDD VSS VSS gf180mcu_fd_sc_mcu7t5v0__oai21_1
XTAP_TAPCELL_ROW_49_940 VDD VSS gf180mcu_fd_sc_mcu7t5v0__filltie
XTAP_TAPCELL_ROW_49_951 VDD VSS gf180mcu_fd_sc_mcu7t5v0__filltie
XTAP_TAPCELL_ROW_105_1732 VDD VSS gf180mcu_fd_sc_mcu7t5v0__filltie
X_6983_ _6983_/D _7276_/CLK _6983_/Q VDD VDD VSS VSS gf180mcu_fd_sc_mcu7t5v0__dffq_1
XTAP_TAPCELL_ROW_0_248 VDD VSS gf180mcu_fd_sc_mcu7t5v0__filltie
XTAP_TAPCELL_ROW_0_259 VDD VSS gf180mcu_fd_sc_mcu7t5v0__filltie
X_5934_ _5934_/A1 _5934_/A2 _5934_/B1 _6176_/B _6217_/B _5935_/B VDD VDD VSS VSS gf180mcu_fd_sc_mcu7t5v0__oai221_1
XFILLER_80_244 VDD VDD VSS VSS gf180mcu_fd_sc_mcu7t5v0__fill_1
XFILLER_15_39 VDD VDD VSS VSS gf180mcu_fd_sc_mcu7t5v0__fill_2
XFILLER_22_801 VDD VDD VSS VSS gf180mcu_fd_sc_mcu7t5v0__fillcap_4
XFILLER_34_661 VDD VDD VSS VSS gf180mcu_fd_sc_mcu7t5v0__fillcap_4
XFILLER_33_171 VDD VDD VSS VSS gf180mcu_fd_sc_mcu7t5v0__fill_2
X_5865_ _5865_/I _5866_/B VDD VDD VSS VSS gf180mcu_fd_sc_mcu7t5v0__clkinv_1
XFILLER_62_981 VDD VDD VSS VSS gf180mcu_fd_sc_mcu7t5v0__fill_1
X_7604_ _7604_/D _7612_/RN _7669_/CLK _7604_/Q VDD VDD VSS VSS gf180mcu_fd_sc_mcu7t5v0__dffrnq_1
X_4816_ wire268/Z _4826_/A2 _4816_/B _7122_/D VDD VDD VSS VSS gf180mcu_fd_sc_mcu7t5v0__oai21_1
X_5796_ _6939_/Q _6087_/A2 wire355/Z _6932_/Q _5798_/A1 VDD VDD VSS VSS gf180mcu_fd_sc_mcu7t5v0__oai22_1
X_7535_ _7535_/D _7664_/RN _7669_/CLK _7535_/Q VDD VDD VSS VSS gf180mcu_fd_sc_mcu7t5v0__dffrnq_1
X_4747_ _7088_/Q _4756_/A2 _4748_/B VDD VDD VSS VSS gf180mcu_fd_sc_mcu7t5v0__nand2_1
XTAP_TAPCELL_ROW_60_1094 VDD VSS gf180mcu_fd_sc_mcu7t5v0__filltie
X_4678_ _4748_/A1 _4686_/A2 _4678_/B _7053_/D VDD VDD VSS VSS gf180mcu_fd_sc_mcu7t5v0__oai21_1
X_7466_ _7466_/D _7490_/CLK _7466_/Q VDD VDD VSS VSS gf180mcu_fd_sc_mcu7t5v0__dffq_1
X_6417_ _7662_/Q _7528_/Q _6418_/I VDD VDD VSS VSS gf180mcu_fd_sc_mcu7t5v0__nand2_1
X_3629_ input99/Z input23/Z _3636_/A3 _3629_/Z VDD VDD VSS VSS gf180mcu_fd_sc_mcu7t5v0__xor3_1
X_7397_ _7397_/D _7500_/CLK _7397_/Q VDD VDD VSS VSS gf180mcu_fd_sc_mcu7t5v0__dffq_1
XTAP_TAPCELL_ROW_116_1883 VDD VSS gf180mcu_fd_sc_mcu7t5v0__filltie
X_6348_ input53/Z _6341_/S _6349_/B VDD VDD VSS VSS gf180mcu_fd_sc_mcu7t5v0__nand2_1
Xinput105 tl_i[98] _6304_/I1 VDD VDD VSS VSS gf180mcu_fd_sc_mcu7t5v0__dlyd_1
X_6279_ _7635_/Q _6285_/A2 _6283_/B1 _7800_/D _6283_/C1 _7525_/Q _6280_/B2 VDD VDD
+ VSS VSS gf180mcu_fd_sc_mcu7t5v0__aoi222_1
XFILLER_29_422 VDD VDD VSS VSS gf180mcu_fd_sc_mcu7t5v0__fill_2
XFILLER_57_764 VDD VDD VSS VSS gf180mcu_fd_sc_mcu7t5v0__fill_1
XTAP_TAPCELL_ROW_27_634 VDD VSS gf180mcu_fd_sc_mcu7t5v0__filltie
XFILLER_72_734 VDD VDD VSS VSS gf180mcu_fd_sc_mcu7t5v0__fill_1
XTAP_TAPCELL_ROW_78_1344 VDD VSS gf180mcu_fd_sc_mcu7t5v0__filltie
XTAP_TAPCELL_ROW_78_1355 VDD VSS gf180mcu_fd_sc_mcu7t5v0__filltie
XTAP_TAPCELL_ROW_91_1533 VDD VSS gf180mcu_fd_sc_mcu7t5v0__filltie
XFILLER_94_314 VDD VDD VSS VSS gf180mcu_fd_sc_mcu7t5v0__fill_1
XFILLER_47_230 VDD VDD VSS VSS gf180mcu_fd_sc_mcu7t5v0__fill_2
XFILLER_75_583 VDD VDD VSS VSS gf180mcu_fd_sc_mcu7t5v0__fillcap_4
X_3980_ wire248/Z _4364_/A2 _3980_/B _6746_/D VDD VDD VSS VSS gf180mcu_fd_sc_mcu7t5v0__oai21_1
XFILLER_16_661 VDD VDD VSS VSS gf180mcu_fd_sc_mcu7t5v0__fillcap_4
XFILLER_51_907 VDD VDD VSS VSS gf180mcu_fd_sc_mcu7t5v0__fill_2
XFILLER_44_981 VDD VDD VSS VSS gf180mcu_fd_sc_mcu7t5v0__fill_1
X_5650_ _7533_/Q input60/Z _5651_/S _7533_/D VDD VDD VSS VSS gf180mcu_fd_sc_mcu7t5v0__mux2_2
XPHY_EDGE_ROW_99_Left_218 VDD VSS gf180mcu_fd_sc_mcu7t5v0__endcap
XTAP_TAPCELL_ROW_100_1662 VDD VSS gf180mcu_fd_sc_mcu7t5v0__filltie
X_4601_ _7015_/Q _4602_/A2 _4602_/B VDD VDD VSS VSS gf180mcu_fd_sc_mcu7t5v0__nand2_1
X_5581_ _5577_/B _5581_/A2 _5581_/A3 _5582_/B VDD VDD VSS VSS gf180mcu_fd_sc_mcu7t5v0__or3_1
X_4532_ _4532_/A1 _4532_/A2 _4532_/B _6980_/D VDD VDD VSS VSS gf180mcu_fd_sc_mcu7t5v0__oai21_1
X_7320_ _7320_/D _7492_/CLK _7320_/Q VDD VDD VSS VSS gf180mcu_fd_sc_mcu7t5v0__dffq_1
XFILLER_8_871 VDD VDD VSS VSS gf180mcu_fd_sc_mcu7t5v0__fillcap_4
XFILLER_117_769 VDD VDD VSS VSS gf180mcu_fd_sc_mcu7t5v0__fill_1
X_4463_ _6946_/Q _4476_/A2 _4464_/B VDD VDD VSS VSS gf180mcu_fd_sc_mcu7t5v0__nand2_1
X_7251_ _7251_/D _7251_/CLK _7251_/Q VDD VDD VSS VSS gf180mcu_fd_sc_mcu7t5v0__dffq_1
X_3414_ _7635_/Q _6347_/A1 VDD VDD VSS VSS gf180mcu_fd_sc_mcu7t5v0__clkinv_1
X_6202_ _6202_/A1 _6202_/A2 _6202_/B _6203_/B2 VDD VDD VSS VSS gf180mcu_fd_sc_mcu7t5v0__oai21_1
X_4394_ _4786_/A1 _4406_/A2 _4394_/B _6911_/D VDD VDD VSS VSS gf180mcu_fd_sc_mcu7t5v0__oai21_1
XPHY_EDGE_ROW_15_Right_15 VDD VSS gf180mcu_fd_sc_mcu7t5v0__endcap
X_7182_ _7182_/D _7719_/CLK _7182_/Q VDD VDD VSS VSS gf180mcu_fd_sc_mcu7t5v0__dffq_1
XFILLER_86_804 VDD VDD VSS VSS gf180mcu_fd_sc_mcu7t5v0__fill_1
X_6133_ _6847_/Q wire341/I _6201_/A2 _7274_/Q _6135_/A1 VDD VDD VSS VSS gf180mcu_fd_sc_mcu7t5v0__oai22_1
XTAP_TAPCELL_ROW_5_329 VDD VSS gf180mcu_fd_sc_mcu7t5v0__filltie
X_6064_ _6064_/A1 _6064_/A2 _6065_/C VDD VDD VSS VSS gf180mcu_fd_sc_mcu7t5v0__nand2_1
Xload_slew262 _3859_/ZN _5128_/A1 VDD VDD VSS VSS gf180mcu_fd_sc_mcu7t5v0__clkbuf_4
Xload_slew273 _3856_/ZN _5110_/A1 VDD VDD VSS VSS gf180mcu_fd_sc_mcu7t5v0__buf_2
X_5015_ _7222_/Q _5022_/A2 _5016_/B VDD VDD VSS VSS gf180mcu_fd_sc_mcu7t5v0__nand2_1
XFILLER_54_745 VDD VDD VSS VSS gf180mcu_fd_sc_mcu7t5v0__fill_2
X_6966_ _6966_/D _7002_/CLK _6966_/Q VDD VDD VSS VSS gf180mcu_fd_sc_mcu7t5v0__dffq_1
XPHY_EDGE_ROW_24_Right_24 VDD VSS gf180mcu_fd_sc_mcu7t5v0__endcap
X_5917_ _5917_/A1 _5917_/A2 _5936_/B1 VDD VDD VSS VSS gf180mcu_fd_sc_mcu7t5v0__nor2_1
XFILLER_53_288 VDD VDD VSS VSS gf180mcu_fd_sc_mcu7t5v0__fill_2
X_6897_ _6897_/D _7008_/CLK _6897_/Q VDD VDD VSS VSS gf180mcu_fd_sc_mcu7t5v0__dffq_1
XTAP_TAPCELL_ROW_62_1123 VDD VSS gf180mcu_fd_sc_mcu7t5v0__filltie
X_5848_ _6184_/C _5848_/A2 _5848_/B _5876_/A2 VDD VDD VSS VSS gf180mcu_fd_sc_mcu7t5v0__oai21_1
XTAP_TAPCELL_ROW_118_1912 VDD VSS gf180mcu_fd_sc_mcu7t5v0__filltie
X_5779_ _6122_/C _5779_/A2 _5779_/A3 _5807_/A1 VDD VDD VSS VSS gf180mcu_fd_sc_mcu7t5v0__nand3_1
XTAP_TAPCELL_ROW_118_1923 VDD VSS gf180mcu_fd_sc_mcu7t5v0__filltie
X_7518_ _7518_/D _7827_/RN clkload7/I _7518_/Q VDD VDD VSS VSS gf180mcu_fd_sc_mcu7t5v0__dffrnq_1
XPHY_EDGE_ROW_33_Right_33 VDD VSS gf180mcu_fd_sc_mcu7t5v0__endcap
X_7449_ _7449_/D _7456_/CLK _7449_/Q VDD VDD VSS VSS gf180mcu_fd_sc_mcu7t5v0__dffq_1
XTAP_TAPCELL_ROW_73_1274 VDD VSS gf180mcu_fd_sc_mcu7t5v0__filltie
XTAP_TAPCELL_ROW_73_1285 VDD VSS gf180mcu_fd_sc_mcu7t5v0__filltie
XPHY_EDGE_ROW_42_Right_42 VDD VSS gf180mcu_fd_sc_mcu7t5v0__endcap
XFILLER_72_531 VDD VDD VSS VSS gf180mcu_fd_sc_mcu7t5v0__fill_2
XFILLER_45_767 VDD VDD VSS VSS gf180mcu_fd_sc_mcu7t5v0__fill_2
XFILLER_26_981 VDD VDD VSS VSS gf180mcu_fd_sc_mcu7t5v0__fill_1
XFILLER_60_737 VDD VDD VSS VSS gf180mcu_fd_sc_mcu7t5v0__fill_1
XFILLER_72_597 VDD VDD VSS VSS gf180mcu_fd_sc_mcu7t5v0__fillcap_4
XPHY_EDGE_ROW_51_Right_51 VDD VSS gf180mcu_fd_sc_mcu7t5v0__endcap
XTAP_TAPCELL_ROW_10_397 VDD VSS gf180mcu_fd_sc_mcu7t5v0__filltie
XFILLER_107_780 VDD VDD VSS VSS gf180mcu_fd_sc_mcu7t5v0__fillcap_4
XFILLER_68_804 VDD VDD VSS VSS gf180mcu_fd_sc_mcu7t5v0__fill_1
XFILLER_68_826 VDD VDD VSS VSS gf180mcu_fd_sc_mcu7t5v0__fill_2
XFILLER_82_317 VDD VDD VSS VSS gf180mcu_fd_sc_mcu7t5v0__fill_2
XPHY_EDGE_ROW_60_Right_60 VDD VSS gf180mcu_fd_sc_mcu7t5v0__endcap
X_6820_ _6820_/D _7499_/CLK _6820_/Q VDD VDD VSS VSS gf180mcu_fd_sc_mcu7t5v0__dffq_1
XFILLER_91_884 VDD VDD VSS VSS gf180mcu_fd_sc_mcu7t5v0__fillcap_4
X_6751_ _6751_/D _7055_/CLK _6751_/Q VDD VDD VSS VSS gf180mcu_fd_sc_mcu7t5v0__dffq_1
X_3963_ _4150_/A1 _4141_/A2 _4322_/A2 VDD VDD VSS VSS gf180mcu_fd_sc_mcu7t5v0__nand2_1
X_5702_ _7638_/Q _7695_/Q _5716_/C VDD VDD VSS VSS gf180mcu_fd_sc_mcu7t5v0__xor2_1
X_3894_ _7784_/Q _6717_/A1 _3895_/A3 VDD VDD VSS VSS gf180mcu_fd_sc_mcu7t5v0__nand2_1
X_6682_ _7743_/Q _7742_/Q _6686_/A2 VDD VDD VSS VSS gf180mcu_fd_sc_mcu7t5v0__nor2_1
X_5633_ _7766_/Q _7766_/D _5633_/B _5634_/B VDD VDD VSS VSS gf180mcu_fd_sc_mcu7t5v0__aoi21_1
X_5564_ _7477_/Q _5603_/A2 _6634_/B _5566_/A1 VDD VDD VSS VSS gf180mcu_fd_sc_mcu7t5v0__oai21_1
X_4515_ _6972_/Q _4518_/A2 _4516_/B VDD VDD VSS VSS gf180mcu_fd_sc_mcu7t5v0__nand2_1
X_7303_ _7303_/D _7499_/CLK _7303_/Q VDD VDD VSS VSS gf180mcu_fd_sc_mcu7t5v0__dffq_1
XPHY_EDGE_ROW_103_Right_103 VDD VSS gf180mcu_fd_sc_mcu7t5v0__endcap
X_5495_ _7511_/Q _6732_/A1 _6728_/B _5495_/C _5496_/A2 VDD VDD VSS VSS gf180mcu_fd_sc_mcu7t5v0__oai211_1
XTAP_TAPCELL_ROW_113_1842 VDD VSS gf180mcu_fd_sc_mcu7t5v0__filltie
X_4446_ _4460_/A1 _4448_/A2 _4446_/B _6937_/D VDD VDD VSS VSS gf180mcu_fd_sc_mcu7t5v0__oai21_1
X_7234_ _7234_/D _7247_/CLK _7234_/Q VDD VDD VSS VSS gf180mcu_fd_sc_mcu7t5v0__dffq_1
X_4377_ _6903_/Q _4378_/A2 _4378_/B VDD VDD VSS VSS gf180mcu_fd_sc_mcu7t5v0__nand2_1
X_7165_ _7165_/D _7719_/CLK _7165_/Q VDD VDD VSS VSS gf180mcu_fd_sc_mcu7t5v0__dffq_1
XFILLER_113_772 VDD VDD VSS VSS gf180mcu_fd_sc_mcu7t5v0__fillcap_64
X_6116_ _7028_/Q _6144_/A2 wire313/I _7021_/Q _6121_/A1 VDD VDD VSS VSS gf180mcu_fd_sc_mcu7t5v0__oai22_1
XFILLER_86_667 VDD VDD VSS VSS gf180mcu_fd_sc_mcu7t5v0__fillcap_4
XFILLER_74_807 VDD VDD VSS VSS gf180mcu_fd_sc_mcu7t5v0__fillcap_4
X_7096_ _7096_/D _7250_/CLK _7096_/Q VDD VDD VSS VSS gf180mcu_fd_sc_mcu7t5v0__dffq_1
X_6047_ _6047_/A1 _6047_/A2 _6047_/B _6231_/C _6060_/A2 VDD VDD VSS VSS gf180mcu_fd_sc_mcu7t5v0__oai211_1
XFILLER_39_550 VDD VDD VSS VSS gf180mcu_fd_sc_mcu7t5v0__fillcap_8
XFILLER_82_840 VDD VDD VSS VSS gf180mcu_fd_sc_mcu7t5v0__fillcap_8
XTAP_TAPCELL_ROW_37_773 VDD VSS gf180mcu_fd_sc_mcu7t5v0__filltie
XFILLER_42_737 VDD VDD VSS VSS gf180mcu_fd_sc_mcu7t5v0__fillcap_64
XFILLER_54_597 VDD VDD VSS VSS gf180mcu_fd_sc_mcu7t5v0__fill_1
X_6949_ _6949_/D _7687_/CLK _6949_/Q VDD VDD VSS VSS gf180mcu_fd_sc_mcu7t5v0__dffq_1
XFILLER_50_792 VDD VDD VSS VSS gf180mcu_fd_sc_mcu7t5v0__fill_1
XFILLER_10_667 VDD VDD VSS VSS gf180mcu_fd_sc_mcu7t5v0__fillcap_64
XTAP_TAPCELL_ROW_75_1314 VDD VSS gf180mcu_fd_sc_mcu7t5v0__filltie
XTAP_TAPCELL_ROW_75_1303 VDD VSS gf180mcu_fd_sc_mcu7t5v0__filltie
XFILLER_2_877 VDD VDD VSS VSS gf180mcu_fd_sc_mcu7t5v0__fillcap_64
XFILLER_94_98 VDD VDD VSS VSS gf180mcu_fd_sc_mcu7t5v0__fill_1
XTAP_TAPCELL_ROW_86_1465 VDD VSS gf180mcu_fd_sc_mcu7t5v0__filltie
XFILLER_45_564 VDD VDD VSS VSS gf180mcu_fd_sc_mcu7t5v0__fill_1
XFILLER_72_383 VDD VDD VSS VSS gf180mcu_fd_sc_mcu7t5v0__fill_2
XTAP_TAPCELL_ROW_15_467 VDD VSS gf180mcu_fd_sc_mcu7t5v0__filltie
X_4300_ _4832_/A1 _4308_/A2 _4300_/B _6864_/D VDD VDD VSS VSS gf180mcu_fd_sc_mcu7t5v0__oai21_1
X_5280_ wire517/I _7427_/Q _5281_/S _7427_/D VDD VDD VSS VSS gf180mcu_fd_sc_mcu7t5v0__mux2_2
X_4231_ _6651_/A1 _4233_/A2 _5337_/S VDD VDD VSS VSS gf180mcu_fd_sc_mcu7t5v0__nand2_1
XFILLER_96_943 VDD VDD VSS VSS gf180mcu_fd_sc_mcu7t5v0__fill_2
X_4162_ _4203_/A1 _4170_/A1 _4237_/A1 VDD VDD VSS VSS gf180mcu_fd_sc_mcu7t5v0__nor2_1
X_4093_ _6782_/Q _4868_/A2 _4094_/B VDD VDD VSS VSS gf180mcu_fd_sc_mcu7t5v0__nand2_1
XFILLER_67_144 VDD VDD VSS VSS gf180mcu_fd_sc_mcu7t5v0__fill_1
XFILLER_36_542 VDD VDD VSS VSS gf180mcu_fd_sc_mcu7t5v0__fillcap_32
XFILLER_64_862 VDD VDD VSS VSS gf180mcu_fd_sc_mcu7t5v0__fill_2
XFILLER_24_737 VDD VDD VSS VSS gf180mcu_fd_sc_mcu7t5v0__fillcap_64
XFILLER_36_597 VDD VDD VSS VSS gf180mcu_fd_sc_mcu7t5v0__fillcap_64
X_6803_ _6803_/D _7504_/CLK _6803_/Q VDD VDD VSS VSS gf180mcu_fd_sc_mcu7t5v0__dffq_1
XFILLER_23_236 VDD VDD VSS VSS gf180mcu_fd_sc_mcu7t5v0__fill_2
XTAP_TAPCELL_ROW_34_732 VDD VSS gf180mcu_fd_sc_mcu7t5v0__filltie
X_4995_ _7212_/Q _5008_/A2 _4996_/B VDD VDD VSS VSS gf180mcu_fd_sc_mcu7t5v0__nand2_1
X_7783_ _7783_/D _7783_/RN _7793_/CLK _7783_/Q VDD VDD VSS VSS gf180mcu_fd_sc_mcu7t5v0__dffrnq_1
X_3946_ _4120_/A1 _4150_/A1 _4266_/A2 VDD VDD VSS VSS gf180mcu_fd_sc_mcu7t5v0__nand2_1
X_6734_ _7764_/Q _6735_/A2 _7544_/Q _6735_/B VDD VDD VSS VSS gf180mcu_fd_sc_mcu7t5v0__oai21_1
X_6665_ _6697_/A1 _3786_/Z _6665_/A3 _7739_/D VDD VDD VSS VSS gf180mcu_fd_sc_mcu7t5v0__nor3_1
X_3877_ _3877_/A1 _3877_/A2 _3877_/A3 _3877_/A4 _3877_/Z VDD VDD VSS VSS gf180mcu_fd_sc_mcu7t5v0__or4_1
X_5616_ _5616_/I0 _5616_/I1 _5616_/S _5616_/Z VDD VDD VSS VSS gf180mcu_fd_sc_mcu7t5v0__mux2_2
X_6596_ _5926_/B _6603_/A2 _6598_/B VDD VDD VSS VSS gf180mcu_fd_sc_mcu7t5v0__nand2_1
XFILLER_118_886 VDD VDD VSS VSS gf180mcu_fd_sc_mcu7t5v0__fillcap_32
X_5547_ _7392_/Q _6632_/A1 _5572_/C2 _7385_/Q _7378_/Q _5594_/B1 _5548_/I VDD VDD
+ VSS VSS gf180mcu_fd_sc_mcu7t5v0__oai222_1
X_5478_ _5508_/C _5478_/A2 _5478_/A3 _5479_/A3 VDD VDD VSS VSS gf180mcu_fd_sc_mcu7t5v0__nor3_1
X_4429_ _6929_/Q _4434_/A2 _4430_/B VDD VDD VSS VSS gf180mcu_fd_sc_mcu7t5v0__nand2_1
XTAP_TAPCELL_ROW_57_1055 VDD VSS gf180mcu_fd_sc_mcu7t5v0__filltie
X_7217_ _7217_/D _7217_/CLK _7217_/Q VDD VDD VSS VSS gf180mcu_fd_sc_mcu7t5v0__dffq_1
Xfanout411 wire416/Z _6207_/A2 VDD VDD VSS VSS gf180mcu_fd_sc_mcu7t5v0__dlyd_1
Xfanout400 _6229_/A2 _5776_/A2 VDD VDD VSS VSS gf180mcu_fd_sc_mcu7t5v0__dlyd_1
X_7148_ _7148_/D _7148_/CLK _7148_/Q VDD VDD VSS VSS gf180mcu_fd_sc_mcu7t5v0__dffq_1
Xfanout455 _7730_/Q _6641_/A1 VDD VDD VSS VSS gf180mcu_fd_sc_mcu7t5v0__dlyd_1
XFILLER_48_47 VDD VDD VSS VSS gf180mcu_fd_sc_mcu7t5v0__fill_1
XTAP_TAPCELL_ROW_70_1233 VDD VSS gf180mcu_fd_sc_mcu7t5v0__filltie
XTAP_TAPCELL_ROW_70_1244 VDD VSS gf180mcu_fd_sc_mcu7t5v0__filltie
XFILLER_87_976 VDD VDD VSS VSS gf180mcu_fd_sc_mcu7t5v0__fillcap_4
Xfanout499 _6574_/S _6571_/S VDD VDD VSS VSS gf180mcu_fd_sc_mcu7t5v0__dlyd_1
X_7079_ _7079_/D _7118_/CLK _7079_/Q VDD VDD VSS VSS gf180mcu_fd_sc_mcu7t5v0__dffq_1
Xfanout488 _6147_/B _6201_/C VDD VDD VSS VSS gf180mcu_fd_sc_mcu7t5v0__dlyd_1
XTAP_TAPCELL_ROW_81_1395 VDD VSS gf180mcu_fd_sc_mcu7t5v0__filltie
XTAP_TAPCELL_ROW_12_426 VDD VSS gf180mcu_fd_sc_mcu7t5v0__filltie
XFILLER_11_976 VDD VDD VSS VSS gf180mcu_fd_sc_mcu7t5v0__fillcap_4
XFILLER_109_842 VDD VDD VSS VSS gf180mcu_fd_sc_mcu7t5v0__fillcap_4
XFILLER_109_831 VDD VDD VSS VSS gf180mcu_fd_sc_mcu7t5v0__fill_1
XFILLER_78_943 VDD VDD VSS VSS gf180mcu_fd_sc_mcu7t5v0__fill_2
XFILLER_38_807 VDD VDD VSS VSS gf180mcu_fd_sc_mcu7t5v0__fillcap_64
XFILLER_65_637 VDD VDD VSS VSS gf180mcu_fd_sc_mcu7t5v0__fill_1
XFILLER_93_979 VDD VDD VSS VSS gf180mcu_fd_sc_mcu7t5v0__fill_1
XFILLER_18_542 VDD VDD VSS VSS gf180mcu_fd_sc_mcu7t5v0__fillcap_32
XFILLER_18_597 VDD VDD VSS VSS gf180mcu_fd_sc_mcu7t5v0__fillcap_64
X_3800_ _7816_/D _7816_/Q _7817_/Q _7817_/D _3803_/B VDD VDD VSS VSS gf180mcu_fd_sc_mcu7t5v0__oai22_1
XFILLER_33_556 VDD VDD VSS VSS gf180mcu_fd_sc_mcu7t5v0__fillcap_4
X_4780_ _4822_/A1 _4784_/A2 _4780_/B _7104_/D VDD VDD VSS VSS gf180mcu_fd_sc_mcu7t5v0__oai21_1
X_3731_ _3735_/A1 _3715_/Z _5877_/A1 VDD VDD VSS VSS gf180mcu_fd_sc_mcu7t5v0__xnor2_1
XTAP_TAPCELL_ROW_99_1645 VDD VSS gf180mcu_fd_sc_mcu7t5v0__filltie
X_6450_ _6479_/S _6449_/Z _6450_/B _7666_/D VDD VDD VSS VSS gf180mcu_fd_sc_mcu7t5v0__aoi21_1
XFILLER_9_284 VDD VDD VSS VSS gf180mcu_fd_sc_mcu7t5v0__fill_1
Xclkload10 _7378_/CLK clkload10/Z VDD VDD VSS VSS gf180mcu_fd_sc_mcu7t5v0__clkbuf_2
X_3662_ _7882_/I _3541_/Z _3547_/Z _3662_/Z VDD VDD VSS VSS gf180mcu_fd_sc_mcu7t5v0__xor3_1
X_6381_ _7656_/Q _7522_/Q _6388_/B VDD VDD VSS VSS gf180mcu_fd_sc_mcu7t5v0__nand2_1
Xclkload32 _7490_/CLK clkload32/Z VDD VDD VSS VSS gf180mcu_fd_sc_mcu7t5v0__clkbuf_4
Xclkload21 _7500_/CLK clkload21/Z VDD VDD VSS VSS gf180mcu_fd_sc_mcu7t5v0__clkbuf_4
X_5401_ _7508_/Q _6732_/A1 _6728_/B _5401_/C _5403_/A1 VDD VDD VSS VSS gf180mcu_fd_sc_mcu7t5v0__oai211_1
X_3593_ input58/Z input61/Z _3593_/Z VDD VDD VSS VSS gf180mcu_fd_sc_mcu7t5v0__xor2_1
XFILLER_62_2 VDD VDD VSS VSS gf180mcu_fd_sc_mcu7t5v0__fill_2
Xclkload43 _7796_/CLK clkload43/Z VDD VDD VSS VSS gf180mcu_fd_sc_mcu7t5v0__clkbuf_2
Xclkload65 _7276_/CLK clkload65/Z VDD VDD VSS VSS gf180mcu_fd_sc_mcu7t5v0__clkbuf_2
Xclkload76 _7254_/CLK clkload76/ZN VDD VDD VSS VSS gf180mcu_fd_sc_mcu7t5v0__inv_2
X_5332_ _5332_/I0 _7479_/Q _5337_/S _7479_/D VDD VDD VSS VSS gf180mcu_fd_sc_mcu7t5v0__mux2_2
Xclkload54 _7253_/CLK clkload54/ZN VDD VDD VSS VSS gf180mcu_fd_sc_mcu7t5v0__inv_2
XTAP_TAPCELL_ROW_110_1801 VDD VSS gf180mcu_fd_sc_mcu7t5v0__filltie
X_5263_ _5354_/I0 _7410_/Q _5267_/S _7410_/D VDD VDD VSS VSS gf180mcu_fd_sc_mcu7t5v0__mux2_2
X_7002_ _7002_/D _7002_/CLK _7002_/Q VDD VDD VSS VSS gf180mcu_fd_sc_mcu7t5v0__dffq_1
X_5194_ _5341_/I0 _7341_/Q _5197_/S _7341_/D VDD VDD VSS VSS gf180mcu_fd_sc_mcu7t5v0__mux2_2
X_4214_ _4223_/I0 _6822_/Q _5281_/S _6822_/D VDD VDD VSS VSS gf180mcu_fd_sc_mcu7t5v0__mux2_2
X_4145_ _6799_/Q _5106_/A2 _4146_/B VDD VDD VSS VSS gf180mcu_fd_sc_mcu7t5v0__nand2_1
XTAP_TAPCELL_ROW_39_802 VDD VSS gf180mcu_fd_sc_mcu7t5v0__filltie
XFILLER_84_979 VDD VDD VSS VSS gf180mcu_fd_sc_mcu7t5v0__fill_2
X_4076_ _6777_/Q _4798_/A2 _4077_/B VDD VDD VSS VSS gf180mcu_fd_sc_mcu7t5v0__nand2_1
XTAP_TAPCELL_ROW_108_1774 VDD VSS gf180mcu_fd_sc_mcu7t5v0__filltie
XFILLER_71_629 VDD VDD VSS VSS gf180mcu_fd_sc_mcu7t5v0__fill_1
XFILLER_51_342 VDD VDD VSS VSS gf180mcu_fd_sc_mcu7t5v0__fill_2
X_7766_ _7766_/D _7827_/RN clkload7/I _7766_/Q VDD VDD VSS VSS gf180mcu_fd_sc_mcu7t5v0__dffsnq_1
X_4978_ _5006_/A1 _4980_/A2 _4978_/B _7203_/D VDD VDD VSS VSS gf180mcu_fd_sc_mcu7t5v0__oai21_1
X_6717_ _6717_/A1 _6717_/A2 _6717_/B _7756_/D VDD VDD VSS VSS gf180mcu_fd_sc_mcu7t5v0__oai21_1
X_3929_ _7754_/Q _7755_/Q _3929_/Z VDD VDD VSS VSS gf180mcu_fd_sc_mcu7t5v0__xor2_1
X_7697_ _7697_/D _7783_/RN _7793_/CLK _7697_/Q VDD VDD VSS VSS gf180mcu_fd_sc_mcu7t5v0__dffrnq_1
Xclkload4 clkload4/I clkload4/ZN VDD VDD VSS VSS gf180mcu_fd_sc_mcu7t5v0__clkinv_20
X_6648_ _4155_/Z _6658_/A2 _6652_/A1 VDD VDD VSS VSS gf180mcu_fd_sc_mcu7t5v0__nand2_1
XFILLER_50_37 VDD VDD VSS VSS gf180mcu_fd_sc_mcu7t5v0__fill_1
X_6579_ _7793_/Q _5630_/B _3702_/Z _5748_/Z _6605_/A1 VDD VDD VSS VSS gf180mcu_fd_sc_mcu7t5v0__nor4_1
Xfanout263 _4396_/A1 _5012_/A1 VDD VDD VSS VSS gf180mcu_fd_sc_mcu7t5v0__dlyd_1
Xfanout274 _4940_/A1 _5066_/A1 VDD VDD VSS VSS gf180mcu_fd_sc_mcu7t5v0__dlyd_1
XFILLER_47_637 VDD VDD VSS VSS gf180mcu_fd_sc_mcu7t5v0__fill_1
XFILLER_75_979 VDD VDD VSS VSS gf180mcu_fd_sc_mcu7t5v0__fill_1
XTAP_TAPCELL_ROW_83_1424 VDD VSS gf180mcu_fd_sc_mcu7t5v0__filltie
XFILLER_61_139 VDD VDD VSS VSS gf180mcu_fd_sc_mcu7t5v0__fill_1
XFILLER_7_766 VDD VDD VSS VSS gf180mcu_fd_sc_mcu7t5v0__fillcap_4
XFILLER_6_232 VDD VDD VSS VSS gf180mcu_fd_sc_mcu7t5v0__fill_1
XFILLER_6_276 VDD VDD VSS VSS gf180mcu_fd_sc_mcu7t5v0__fill_1
XTAP_TAPCELL_ROW_94_1575 VDD VSS gf180mcu_fd_sc_mcu7t5v0__filltie
XFILLER_112_804 VDD VDD VSS VSS gf180mcu_fd_sc_mcu7t5v0__fill_1
XFILLER_97_559 VDD VDD VSS VSS gf180mcu_fd_sc_mcu7t5v0__fill_1
XFILLER_93_721 VDD VDD VSS VSS gf180mcu_fd_sc_mcu7t5v0__fill_2
XFILLER_92_242 VDD VDD VSS VSS gf180mcu_fd_sc_mcu7t5v0__fill_2
XFILLER_66_979 VDD VDD VSS VSS gf180mcu_fd_sc_mcu7t5v0__fill_2
X_5950_ _5950_/A1 _5950_/A2 _5998_/A1 VDD VDD VSS VSS gf180mcu_fd_sc_mcu7t5v0__nor2_1
X_4901_ _7165_/Q _4910_/A2 _4902_/B VDD VDD VSS VSS gf180mcu_fd_sc_mcu7t5v0__nand2_1
X_5881_ _3928_/I _5809_/I _5881_/B _5881_/C _5882_/A2 VDD VDD VSS VSS gf180mcu_fd_sc_mcu7t5v0__aoi211_1
X_7620_ _7620_/D _7703_/RN _7703_/CLK _7620_/Q VDD VDD VSS VSS gf180mcu_fd_sc_mcu7t5v0__dffrnq_1
XTAP_TAPCELL_ROW_44_871 VDD VSS gf180mcu_fd_sc_mcu7t5v0__filltie
X_4832_ _4832_/A1 _4840_/A2 _4832_/B _7130_/D VDD VDD VSS VSS gf180mcu_fd_sc_mcu7t5v0__oai21_1
X_4763_ _7096_/Q _4770_/A2 _4764_/B VDD VDD VSS VSS gf180mcu_fd_sc_mcu7t5v0__nand2_1
XFILLER_21_559 VDD VDD VSS VSS gf180mcu_fd_sc_mcu7t5v0__fill_1
X_7551_ _7551_/D _7558_/RN _7780_/CLK _7551_/Q VDD VDD VSS VSS gf180mcu_fd_sc_mcu7t5v0__dffrnq_1
X_4694_ _4708_/A1 _4700_/A2 _4694_/B _7061_/D VDD VDD VSS VSS gf180mcu_fd_sc_mcu7t5v0__oai21_1
X_6502_ _7676_/Q _6502_/A2 _6502_/Z VDD VDD VSS VSS gf180mcu_fd_sc_mcu7t5v0__xor2_1
X_7482_ _7482_/D _7482_/CLK _7482_/Q VDD VDD VSS VSS gf180mcu_fd_sc_mcu7t5v0__dffq_1
X_3714_ _7726_/Q _4173_/A1 _3735_/A1 VDD VDD VSS VSS gf180mcu_fd_sc_mcu7t5v0__nand2_1
X_6433_ _6438_/B _6432_/Z _6434_/A2 VDD VDD VSS VSS gf180mcu_fd_sc_mcu7t5v0__nand2_1
X_3645_ input42/Z input61/Z input28/Z _3645_/Z VDD VDD VSS VSS gf180mcu_fd_sc_mcu7t5v0__xor3_1
XFILLER_115_653 VDD VDD VSS VSS gf180mcu_fd_sc_mcu7t5v0__fill_1
X_3576_ input29/Z input35/Z _3576_/Z VDD VDD VSS VSS gf180mcu_fd_sc_mcu7t5v0__xor2_1
X_6364_ _7648_/Q _6677_/A1 _6365_/B VDD VDD VSS VSS gf180mcu_fd_sc_mcu7t5v0__nand2_1
X_6295_ _7533_/Q _6301_/B1 _6296_/B2 VDD VDD VSS VSS gf180mcu_fd_sc_mcu7t5v0__nand2_1
XFILLER_103_815 VDD VDD VSS VSS gf180mcu_fd_sc_mcu7t5v0__fillcap_16
X_5315_ _5343_/I0 _7462_/Q _5316_/S _7462_/D VDD VDD VSS VSS gf180mcu_fd_sc_mcu7t5v0__mux2_2
XTAP_TAPCELL_ROW_54_1014 VDD VSS gf180mcu_fd_sc_mcu7t5v0__filltie
X_5246_ wire513/Z _7393_/Q _5246_/S _7393_/D VDD VDD VSS VSS gf180mcu_fd_sc_mcu7t5v0__mux2_2
XPHY_EDGE_ROW_89_Right_89 VDD VSS gf180mcu_fd_sc_mcu7t5v0__endcap
X_5177_ _5345_/I0 _7324_/Q _5183_/S _7324_/D VDD VDD VSS VSS gf180mcu_fd_sc_mcu7t5v0__mux2_2
XFILLER_29_626 VDD VDD VSS VSS gf180mcu_fd_sc_mcu7t5v0__fillcap_4
X_4128_ _4143_/A1 _5022_/A2 _4128_/B _6793_/D VDD VDD VSS VSS gf180mcu_fd_sc_mcu7t5v0__oai21_1
XFILLER_84_754 VDD VDD VSS VSS gf180mcu_fd_sc_mcu7t5v0__fillcap_8
X_4059_ _4138_/A1 _4059_/A2 _4081_/A2 VDD VDD VSS VSS gf180mcu_fd_sc_mcu7t5v0__nor2_1
XTAP_TAPCELL_ROW_65_1165 VDD VSS gf180mcu_fd_sc_mcu7t5v0__filltie
XPHY_EDGE_ROW_98_Right_98 VDD VSS gf180mcu_fd_sc_mcu7t5v0__endcap
X_7818_ input2/Z _7823_/RN _7822_/CLK _7819_/D VDD VDD VSS VSS gf180mcu_fd_sc_mcu7t5v0__dffrnq_1
XFILLER_51_194 VDD VDD VSS VSS gf180mcu_fd_sc_mcu7t5v0__fill_1
X_7749_ _7749_/D _7755_/RN _7755_/CLK _7749_/Q VDD VDD VSS VSS gf180mcu_fd_sc_mcu7t5v0__dffrnq_1
XTAP_TAPCELL_ROW_22_565 VDD VSS gf180mcu_fd_sc_mcu7t5v0__filltie
XFILLER_79_559 VDD VDD VSS VSS gf180mcu_fd_sc_mcu7t5v0__fill_1
XFILLER_0_920 VDD VDD VSS VSS gf180mcu_fd_sc_mcu7t5v0__fillcap_32
XFILLER_48_979 VDD VDD VSS VSS gf180mcu_fd_sc_mcu7t5v0__fill_2
XTAP_TAPCELL_ROW_2_290 VDD VSS gf180mcu_fd_sc_mcu7t5v0__filltie
XFILLER_43_640 VDD VDD VSS VSS gf180mcu_fd_sc_mcu7t5v0__fill_2
XFILLER_42_172 VDD VDD VSS VSS gf180mcu_fd_sc_mcu7t5v0__fill_2
XTAP_TAPCELL_ROW_41_830 VDD VSS gf180mcu_fd_sc_mcu7t5v0__filltie
XTAP_TAPCELL_ROW_96_1604 VDD VSS gf180mcu_fd_sc_mcu7t5v0__filltie
X_3430_ _7540_/Q _6677_/A1 VDD VDD VSS VSS gf180mcu_fd_sc_mcu7t5v0__clkinv_1
XFILLER_98_802 VDD VDD VSS VSS gf180mcu_fd_sc_mcu7t5v0__fill_2
X_3361_ _7821_/Q _3466_/A1 VDD VDD VSS VSS gf180mcu_fd_sc_mcu7t5v0__clkinv_1
X_6080_ _6944_/Q _6087_/A2 _6085_/B1 _6930_/Q _6080_/C _6081_/B VDD VDD VSS VSS gf180mcu_fd_sc_mcu7t5v0__oai221_1
X_5100_ _5100_/A1 _5106_/A2 _5100_/B _7264_/D VDD VDD VSS VSS gf180mcu_fd_sc_mcu7t5v0__oai21_1
Xload_slew422 _5515_/A2 _5613_/B1 VDD VDD VSS VSS gf180mcu_fd_sc_mcu7t5v0__buf_4
XFILLER_112_667 VDD VDD VSS VSS gf180mcu_fd_sc_mcu7t5v0__fill_1
XFILLER_112_656 VDD VDD VSS VSS gf180mcu_fd_sc_mcu7t5v0__fill_1
XFILLER_100_818 VDD VDD VSS VSS gf180mcu_fd_sc_mcu7t5v0__fill_1
XFILLER_100_807 VDD VDD VSS VSS gf180mcu_fd_sc_mcu7t5v0__fill_2
Xload_slew444 _5823_/C _6162_/C VDD VDD VSS VSS gf180mcu_fd_sc_mcu7t5v0__buf_4
Xload_slew433 _5453_/C2 _5612_/A2 VDD VDD VSS VSS gf180mcu_fd_sc_mcu7t5v0__buf_2
X_5031_ _7230_/Q _5036_/A2 _5032_/B VDD VDD VSS VSS gf180mcu_fd_sc_mcu7t5v0__nand2_1
Xload_slew466 _6634_/B _5549_/C VDD VDD VSS VSS gf180mcu_fd_sc_mcu7t5v0__clkbuf_4
Xload_slew477 _6124_/S _6217_/B VDD VDD VSS VSS gf180mcu_fd_sc_mcu7t5v0__clkbuf_4
XFILLER_78_592 VDD VDD VSS VSS gf180mcu_fd_sc_mcu7t5v0__fill_2
XTAP_TAPCELL_ROW_49_941 VDD VSS gf180mcu_fd_sc_mcu7t5v0__filltie
XFILLER_65_264 VDD VDD VSS VSS gf180mcu_fd_sc_mcu7t5v0__fill_2
X_6982_ _6982_/D _7667_/CLK _6982_/Q VDD VDD VSS VSS gf180mcu_fd_sc_mcu7t5v0__dffq_1
XTAP_TAPCELL_ROW_105_1722 VDD VSS gf180mcu_fd_sc_mcu7t5v0__filltie
XTAP_TAPCELL_ROW_0_249 VDD VSS gf180mcu_fd_sc_mcu7t5v0__filltie
XTAP_TAPCELL_ROW_0_238 VDD VSS gf180mcu_fd_sc_mcu7t5v0__filltie
XTAP_TAPCELL_ROW_105_1733 VDD VSS gf180mcu_fd_sc_mcu7t5v0__filltie
X_5933_ _5933_/A1 _5933_/A2 _5933_/B1 _5933_/B2 _5935_/A2 VDD VDD VSS VSS gf180mcu_fd_sc_mcu7t5v0__oai22_1
X_5864_ _7164_/Q _6177_/C2 _6241_/B1 _7171_/Q _7178_/Q _6177_/B1 _5865_/I VDD VDD
+ VSS VSS gf180mcu_fd_sc_mcu7t5v0__oai222_1
X_7603_ _7603_/D _7660_/RN _7671_/CLK _7603_/Q VDD VDD VSS VSS gf180mcu_fd_sc_mcu7t5v0__dffrnq_1
X_4815_ _7122_/Q _4826_/A2 _4816_/B VDD VDD VSS VSS gf180mcu_fd_sc_mcu7t5v0__nand2_1
X_7534_ _7534_/D _7668_/RN _7667_/CLK _7534_/Q VDD VDD VSS VSS gf180mcu_fd_sc_mcu7t5v0__dffrnq_1
X_5795_ _5795_/A1 _5795_/A2 _5805_/A1 VDD VDD VSS VSS gf180mcu_fd_sc_mcu7t5v0__nor2_1
X_4746_ wire268/Z _4756_/A2 _4746_/B _7087_/D VDD VDD VSS VSS gf180mcu_fd_sc_mcu7t5v0__oai21_1
XTAP_TAPCELL_ROW_60_1095 VDD VSS gf180mcu_fd_sc_mcu7t5v0__filltie
XFILLER_107_417 VDD VDD VSS VSS gf180mcu_fd_sc_mcu7t5v0__fill_2
X_4677_ _7053_/Q _4686_/A2 _4678_/B VDD VDD VSS VSS gf180mcu_fd_sc_mcu7t5v0__nand2_1
X_7465_ _7465_/D _7472_/CLK _7465_/Q VDD VDD VSS VSS gf180mcu_fd_sc_mcu7t5v0__dffq_1
X_6416_ _7662_/Q _6479_/S _6423_/B VDD VDD VSS VSS gf180mcu_fd_sc_mcu7t5v0__nor2_1
X_3628_ input98/Z input97/Z _3636_/A3 VDD VDD VSS VSS gf180mcu_fd_sc_mcu7t5v0__xnor2_1
X_7396_ _7396_/D _7499_/CLK _7396_/Q VDD VDD VSS VSS gf180mcu_fd_sc_mcu7t5v0__dffq_1
XTAP_TAPCELL_ROW_116_1884 VDD VSS gf180mcu_fd_sc_mcu7t5v0__filltie
XFILLER_89_824 VDD VDD VSS VSS gf180mcu_fd_sc_mcu7t5v0__fillcap_4
X_6347_ _6347_/A1 _6352_/S _6347_/B _7635_/D VDD VDD VSS VSS gf180mcu_fd_sc_mcu7t5v0__oai21_1
XFILLER_89_857 VDD VDD VSS VSS gf180mcu_fd_sc_mcu7t5v0__fillcap_4
X_3559_ _3557_/Z _3558_/Z _3559_/Z VDD VDD VSS VSS gf180mcu_fd_sc_mcu7t5v0__xor2_1
X_6278_ _6278_/A1 _6284_/A2 _6284_/B1 _6278_/B2 _7591_/D VDD VDD VSS VSS gf180mcu_fd_sc_mcu7t5v0__aoi22_1
Xinput106 tl_i[99] _6305_/I1 VDD VDD VSS VSS gf180mcu_fd_sc_mcu7t5v0__dlyd_1
X_5229_ _5243_/I0 _7376_/Q _5232_/S _7376_/D VDD VDD VSS VSS gf180mcu_fd_sc_mcu7t5v0__mux2_2
XTAP_TAPCELL_ROW_27_635 VDD VSS gf180mcu_fd_sc_mcu7t5v0__filltie
XPHY_EDGE_ROW_117_Right_117 VDD VSS gf180mcu_fd_sc_mcu7t5v0__endcap
Xclkbuf_leaf_51_clk_i clkload6/I _7062_/CLK VDD VDD VSS VSS gf180mcu_fd_sc_mcu7t5v0__clkbuf_8
XTAP_TAPCELL_ROW_78_1345 VDD VSS gf180mcu_fd_sc_mcu7t5v0__filltie
XTAP_TAPCELL_ROW_78_1356 VDD VSS gf180mcu_fd_sc_mcu7t5v0__filltie
Xclkbuf_leaf_66_clk_i clkload4/I _7251_/CLK VDD VDD VSS VSS gf180mcu_fd_sc_mcu7t5v0__clkbuf_8
XFILLER_106_472 VDD VDD VSS VSS gf180mcu_fd_sc_mcu7t5v0__fill_1
XTAP_TAPCELL_ROW_91_1534 VDD VSS gf180mcu_fd_sc_mcu7t5v0__filltie
XFILLER_0_750 VDD VDD VSS VSS gf180mcu_fd_sc_mcu7t5v0__fillcap_32
XTAP_TAPCELL_ROW_7_360 VDD VSS gf180mcu_fd_sc_mcu7t5v0__filltie
XTAP_TAPCELL_ROW_46_900 VDD VSS gf180mcu_fd_sc_mcu7t5v0__filltie
XFILLER_31_632 VDD VDD VSS VSS gf180mcu_fd_sc_mcu7t5v0__fillcap_64
XFILLER_43_492 VDD VDD VSS VSS gf180mcu_fd_sc_mcu7t5v0__fill_2
XTAP_TAPCELL_ROW_100_1652 VDD VSS gf180mcu_fd_sc_mcu7t5v0__filltie
X_4600_ _4964_/A1 _4602_/A2 _4600_/B _7014_/D VDD VDD VSS VSS gf180mcu_fd_sc_mcu7t5v0__oai21_1
Xclkbuf_leaf_19_clk_i clkload1/I _7711_/CLK VDD VDD VSS VSS gf180mcu_fd_sc_mcu7t5v0__clkbuf_8
XTAP_TAPCELL_ROW_100_1663 VDD VSS gf180mcu_fd_sc_mcu7t5v0__filltie
X_5580_ _7414_/Q _5596_/A2 _5596_/B1 _7400_/Q _5581_/A3 VDD VDD VSS VSS gf180mcu_fd_sc_mcu7t5v0__oai22_1
X_4531_ _6980_/Q _4532_/A2 _4532_/B VDD VDD VSS VSS gf180mcu_fd_sc_mcu7t5v0__nand2_1
X_4462_ wire292/Z _4462_/A2 _4462_/B _6945_/D VDD VDD VSS VSS gf180mcu_fd_sc_mcu7t5v0__oai21_1
Xwire291 wire292/Z wire291/Z VDD VDD VSS VSS gf180mcu_fd_sc_mcu7t5v0__clkbuf_4
X_7250_ _7250_/D _7250_/CLK _7250_/Q VDD VDD VSS VSS gf180mcu_fd_sc_mcu7t5v0__dffq_1
X_3413_ _7691_/Q _5730_/A2 VDD VDD VSS VSS gf180mcu_fd_sc_mcu7t5v0__clkinv_1
X_6201_ _6741_/Q _6201_/A2 _6201_/B1 _6742_/Q _6201_/C _6202_/A2 VDD VDD VSS VSS gf180mcu_fd_sc_mcu7t5v0__oai221_1
X_4393_ _6911_/Q _4406_/A2 _4394_/B VDD VDD VSS VSS gf180mcu_fd_sc_mcu7t5v0__nand2_1
X_7181_ _7181_/D _7748_/CLK _7181_/Q VDD VDD VSS VSS gf180mcu_fd_sc_mcu7t5v0__dffq_1
XFILLER_113_976 VDD VDD VSS VSS gf180mcu_fd_sc_mcu7t5v0__fillcap_4
X_6132_ _6882_/Q _6132_/A2 wire341/Z _6875_/Q _6861_/Q _6177_/C2 _6136_/A2 VDD VDD
+ VSS VSS gf180mcu_fd_sc_mcu7t5v0__oai222_1
Xload_slew230 _5006_/A1 _4460_/A1 VDD VDD VSS VSS gf180mcu_fd_sc_mcu7t5v0__buf_4
XFILLER_86_849 VDD VDD VSS VSS gf180mcu_fd_sc_mcu7t5v0__fillcap_8
Xload_slew252 _4029_/A1 _4146_/A1 VDD VDD VSS VSS gf180mcu_fd_sc_mcu7t5v0__buf_4
X_6063_ _7547_/Q _6247_/A2 _5677_/I _7554_/Q _6064_/A2 VDD VDD VSS VSS gf180mcu_fd_sc_mcu7t5v0__aoi22_1
X_5014_ _5014_/A1 _5022_/A2 _5014_/B _7221_/D VDD VDD VSS VSS gf180mcu_fd_sc_mcu7t5v0__oai21_1
Xload_slew285 _4336_/A1 _4952_/A1 VDD VDD VSS VSS gf180mcu_fd_sc_mcu7t5v0__buf_4
Xload_slew296 _6239_/B1 _6131_/A2 VDD VDD VSS VSS gf180mcu_fd_sc_mcu7t5v0__buf_2
X_6965_ _6965_/D _7667_/CLK _6965_/Q VDD VDD VSS VSS gf180mcu_fd_sc_mcu7t5v0__dffq_1
X_5916_ _7004_/Q _6162_/A2 _6076_/B1 _6983_/Q _6221_/B _5917_/A2 VDD VDD VSS VSS gf180mcu_fd_sc_mcu7t5v0__oai221_1
X_6896_ _6896_/D _7008_/CLK _6896_/Q VDD VDD VSS VSS gf180mcu_fd_sc_mcu7t5v0__dffq_1
XFILLER_50_941 VDD VDD VSS VSS gf180mcu_fd_sc_mcu7t5v0__fillcap_4
XTAP_TAPCELL_ROW_62_1124 VDD VSS gf180mcu_fd_sc_mcu7t5v0__filltie
X_5847_ _5847_/A1 _5847_/A2 _6184_/C _5847_/C _5848_/B VDD VDD VSS VSS gf180mcu_fd_sc_mcu7t5v0__oai211_1
XFILLER_21_142 VDD VDD VSS VSS gf180mcu_fd_sc_mcu7t5v0__fill_2
XTAP_TAPCELL_ROW_118_1913 VDD VSS gf180mcu_fd_sc_mcu7t5v0__filltie
X_5778_ _6136_/B _5778_/A2 _5778_/B1 _5778_/B2 _6231_/C _5779_/A3 VDD VDD VSS VSS
+ gf180mcu_fd_sc_mcu7t5v0__oai221_1
XTAP_TAPCELL_ROW_118_1924 VDD VSS gf180mcu_fd_sc_mcu7t5v0__filltie
X_4729_ _7079_/Q _4742_/A2 _4730_/B VDD VDD VSS VSS gf180mcu_fd_sc_mcu7t5v0__nand2_1
X_7517_ _7517_/D _7822_/RN _7822_/CLK _7517_/Q VDD VDD VSS VSS gf180mcu_fd_sc_mcu7t5v0__dffrnq_1
XFILLER_108_737 VDD VDD VSS VSS gf180mcu_fd_sc_mcu7t5v0__fillcap_4
X_7448_ _7448_/D _7754_/CLK _7448_/Q VDD VDD VSS VSS gf180mcu_fd_sc_mcu7t5v0__dffq_1
XFILLER_89_632 VDD VDD VSS VSS gf180mcu_fd_sc_mcu7t5v0__fill_1
X_7379_ _7379_/D _7735_/CLK _7379_/Q VDD VDD VSS VSS gf180mcu_fd_sc_mcu7t5v0__dffq_1
XTAP_TAPCELL_ROW_73_1275 VDD VSS gf180mcu_fd_sc_mcu7t5v0__filltie
XFILLER_77_838 VDD VDD VSS VSS gf180mcu_fd_sc_mcu7t5v0__fill_2
XTAP_TAPCELL_ROW_73_1286 VDD VSS gf180mcu_fd_sc_mcu7t5v0__filltie
XFILLER_45_757 VDD VDD VSS VSS gf180mcu_fd_sc_mcu7t5v0__fill_1
XFILLER_13_632 VDD VDD VSS VSS gf180mcu_fd_sc_mcu7t5v0__fillcap_64
XFILLER_5_842 VDD VDD VSS VSS gf180mcu_fd_sc_mcu7t5v0__fillcap_64
XTAP_TAPCELL_ROW_10_398 VDD VSS gf180mcu_fd_sc_mcu7t5v0__filltie
XFILLER_0_580 VDD VDD VSS VSS gf180mcu_fd_sc_mcu7t5v0__fillcap_32
XFILLER_110_979 VDD VDD VSS VSS gf180mcu_fd_sc_mcu7t5v0__fill_2
XFILLER_76_893 VDD VDD VSS VSS gf180mcu_fd_sc_mcu7t5v0__fillcap_4
X_6750_ _6750_/D _6944_/CLK _6750_/Q VDD VDD VSS VSS gf180mcu_fd_sc_mcu7t5v0__dffq_1
XFILLER_32_941 VDD VDD VSS VSS gf180mcu_fd_sc_mcu7t5v0__fillcap_4
X_5701_ input37/Z _5738_/A2 _5701_/B _7565_/D VDD VDD VSS VSS gf180mcu_fd_sc_mcu7t5v0__aoi21_1
XFILLER_50_226 VDD VDD VSS VSS gf180mcu_fd_sc_mcu7t5v0__fill_2
X_3962_ _7719_/Q _3962_/A2 _3966_/A1 _4141_/A2 VDD VDD VSS VSS gf180mcu_fd_sc_mcu7t5v0__nor3_4
X_6681_ _6681_/I _7742_/D VDD VDD VSS VSS gf180mcu_fd_sc_mcu7t5v0__clkinv_1
XFILLER_50_259 VDD VDD VSS VSS gf180mcu_fd_sc_mcu7t5v0__fill_1
X_3893_ _6370_/A2 _3895_/A2 _5689_/B VDD VDD VSS VSS gf180mcu_fd_sc_mcu7t5v0__nand2_1
X_5632_ _5632_/A1 _5632_/A2 _5632_/B _7517_/D VDD VDD VSS VSS gf180mcu_fd_sc_mcu7t5v0__aoi21_1
X_5563_ _5577_/B _5563_/A2 _5563_/A3 _5614_/B _5570_/B2 VDD VDD VSS VSS gf180mcu_fd_sc_mcu7t5v0__oai31_1
X_4514_ _4584_/A1 _4518_/A2 _4514_/B _6971_/D VDD VDD VSS VSS gf180mcu_fd_sc_mcu7t5v0__oai21_1
X_7302_ _7302_/D _7505_/CLK _7302_/Q VDD VDD VSS VSS gf180mcu_fd_sc_mcu7t5v0__dffq_1
X_5494_ _5366_/Z _5493_/Z _5495_/C VDD VDD VSS VSS gf180mcu_fd_sc_mcu7t5v0__nand2_1
XTAP_TAPCELL_ROW_113_1843 VDD VSS gf180mcu_fd_sc_mcu7t5v0__filltie
X_4445_ _6937_/Q _4448_/A2 _4446_/B VDD VDD VSS VSS gf180mcu_fd_sc_mcu7t5v0__nand2_1
X_7233_ _7233_/D _7233_/CLK _7233_/Q VDD VDD VSS VSS gf180mcu_fd_sc_mcu7t5v0__dffq_1
X_4376_ _4880_/A1 _4378_/A2 _4376_/B _6902_/D VDD VDD VSS VSS gf180mcu_fd_sc_mcu7t5v0__oai21_1
X_7164_ _7164_/D _7189_/CLK _7164_/Q VDD VDD VSS VSS gf180mcu_fd_sc_mcu7t5v0__dffq_1
XFILLER_59_838 VDD VDD VSS VSS gf180mcu_fd_sc_mcu7t5v0__fill_2
X_6115_ _6115_/A1 _6115_/A2 _6216_/B _6122_/A2 VDD VDD VSS VSS gf180mcu_fd_sc_mcu7t5v0__oai21_1
XFILLER_100_412 VDD VDD VSS VSS gf180mcu_fd_sc_mcu7t5v0__fill_1
X_7095_ _7095_/D _7101_/CLK _7095_/Q VDD VDD VSS VSS gf180mcu_fd_sc_mcu7t5v0__dffq_1
XFILLER_101_979 VDD VDD VSS VSS gf180mcu_fd_sc_mcu7t5v0__fill_1
X_6046_ _6046_/A1 _6046_/A2 _6046_/B _6224_/B _6047_/B VDD VDD VSS VSS gf180mcu_fd_sc_mcu7t5v0__oai211_1
XFILLER_27_702 VDD VDD VSS VSS gf180mcu_fd_sc_mcu7t5v0__fillcap_64
XFILLER_39_562 VDD VDD VSS VSS gf180mcu_fd_sc_mcu7t5v0__fillcap_64
XTAP_TAPCELL_ROW_37_774 VDD VSS gf180mcu_fd_sc_mcu7t5v0__filltie
X_6948_ _6948_/D _7276_/CLK _6948_/Q VDD VDD VSS VSS gf180mcu_fd_sc_mcu7t5v0__dffq_1
X_6879_ _6879_/D _7724_/CLK _6879_/Q VDD VDD VSS VSS gf180mcu_fd_sc_mcu7t5v0__dffq_1
XFILLER_50_782 VDD VDD VSS VSS gf180mcu_fd_sc_mcu7t5v0__fillcap_8
XFILLER_108_523 VDD VDD VSS VSS gf180mcu_fd_sc_mcu7t5v0__fill_2
XFILLER_108_567 VDD VDD VSS VSS gf180mcu_fd_sc_mcu7t5v0__fill_2
XTAP_TAPCELL_ROW_75_1315 VDD VSS gf180mcu_fd_sc_mcu7t5v0__filltie
XTAP_TAPCELL_ROW_75_1304 VDD VSS gf180mcu_fd_sc_mcu7t5v0__filltie
XFILLER_2_801 VDD VDD VSS VSS gf180mcu_fd_sc_mcu7t5v0__fillcap_4
XFILLER_17_212 VDD VDD VSS VSS gf180mcu_fd_sc_mcu7t5v0__fill_1
XFILLER_58_882 VDD VDD VSS VSS gf180mcu_fd_sc_mcu7t5v0__fillcap_32
XTAP_TAPCELL_ROW_86_1466 VDD VSS gf180mcu_fd_sc_mcu7t5v0__filltie
XFILLER_14_941 VDD VDD VSS VSS gf180mcu_fd_sc_mcu7t5v0__fillcap_4
XFILLER_60_524 VDD VDD VSS VSS gf180mcu_fd_sc_mcu7t5v0__fill_1
XTAP_TAPCELL_ROW_15_468 VDD VSS gf180mcu_fd_sc_mcu7t5v0__filltie
X_4230_ _4234_/I0 _6829_/Q _5330_/S _6829_/D VDD VDD VSS VSS gf180mcu_fd_sc_mcu7t5v0__mux2_2
X_4161_ _7735_/Q _4161_/A2 _4170_/A1 VDD VDD VSS VSS gf180mcu_fd_sc_mcu7t5v0__nand2_1
XFILLER_95_443 VDD VDD VSS VSS gf180mcu_fd_sc_mcu7t5v0__fill_1
X_4092_ _4144_/A1 _4129_/A1 _4868_/A2 VDD VDD VSS VSS gf180mcu_fd_sc_mcu7t5v0__nand2_1
X_6802_ _6802_/D _7483_/CLK _6802_/Q VDD VDD VSS VSS gf180mcu_fd_sc_mcu7t5v0__dffq_1
XFILLER_64_874 VDD VDD VSS VSS gf180mcu_fd_sc_mcu7t5v0__fill_1
XTAP_TAPCELL_ROW_34_733 VDD VSS gf180mcu_fd_sc_mcu7t5v0__filltie
X_7782_ _7782_/D _7782_/RN _7782_/CLK _7782_/Q VDD VDD VSS VSS gf180mcu_fd_sc_mcu7t5v0__dffrnq_1
X_4994_ _5008_/A1 _4994_/A2 _4994_/B _7211_/D VDD VDD VSS VSS gf180mcu_fd_sc_mcu7t5v0__oai21_1
X_3945_ _7723_/Q _7724_/Q _4138_/A1 _4150_/A1 VDD VDD VSS VSS gf180mcu_fd_sc_mcu7t5v0__nor3_1
X_6733_ _7761_/Q _7762_/Q _7763_/Q _6733_/A4 _6735_/A2 VDD VDD VSS VSS gf180mcu_fd_sc_mcu7t5v0__nor4_1
X_6664_ _6574_/S _7738_/Q _7739_/Q _6665_/A3 VDD VDD VSS VSS gf180mcu_fd_sc_mcu7t5v0__aoi21_1
X_5615_ _5397_/B _5615_/A2 _5615_/A3 _5615_/B1 _5615_/B2 _5616_/I0 VDD VDD VSS VSS
+ gf180mcu_fd_sc_mcu7t5v0__oai32_1
X_3876_ _4336_/A1 _4940_/A1 _3877_/A4 VDD VDD VSS VSS gf180mcu_fd_sc_mcu7t5v0__nand2_1
X_6595_ _6585_/Z _6595_/A2 _6595_/B _7714_/D VDD VDD VSS VSS gf180mcu_fd_sc_mcu7t5v0__oai21_1
X_5546_ _5546_/A1 _5546_/A2 _5582_/C _5553_/A2 VDD VDD VSS VSS gf180mcu_fd_sc_mcu7t5v0__oai21_1
X_5477_ _7285_/Q _5607_/B1 _5511_/C2 _7362_/Q _7460_/Q wire428/Z _5478_/A3 VDD VDD
+ VSS VSS gf180mcu_fd_sc_mcu7t5v0__oai222_1
X_4428_ _5086_/A1 _4434_/A2 _4428_/B _6928_/D VDD VDD VSS VSS gf180mcu_fd_sc_mcu7t5v0__oai21_1
X_7216_ _7216_/D _7216_/CLK _7216_/Q VDD VDD VSS VSS gf180mcu_fd_sc_mcu7t5v0__dffq_1
XTAP_TAPCELL_ROW_57_1056 VDD VSS gf180mcu_fd_sc_mcu7t5v0__filltie
X_4359_ _6894_/Q _4364_/A2 _4360_/B VDD VDD VSS VSS gf180mcu_fd_sc_mcu7t5v0__nand2_1
XFILLER_101_732 VDD VDD VSS VSS gf180mcu_fd_sc_mcu7t5v0__fill_1
X_7147_ _7147_/D _7259_/CLK _7147_/Q VDD VDD VSS VSS gf180mcu_fd_sc_mcu7t5v0__dffq_1
Xfanout434 _5579_/A2 _5599_/A2 VDD VDD VSS VSS gf180mcu_fd_sc_mcu7t5v0__dlyd_1
Xfanout445 wire454/I _6238_/B VDD VDD VSS VSS gf180mcu_fd_sc_mcu7t5v0__dlyd_1
XTAP_TAPCELL_ROW_70_1234 VDD VSS gf180mcu_fd_sc_mcu7t5v0__filltie
XTAP_TAPCELL_ROW_70_1245 VDD VSS gf180mcu_fd_sc_mcu7t5v0__filltie
X_7078_ _7078_/D _7097_/CLK _7078_/Q VDD VDD VSS VSS gf180mcu_fd_sc_mcu7t5v0__dffq_1
Xfanout467 _5577_/B _5558_/B VDD VDD VSS VSS gf180mcu_fd_sc_mcu7t5v0__dlyd_1
Xfanout478 _7716_/Q _6184_/C VDD VDD VSS VSS gf180mcu_fd_sc_mcu7t5v0__dlyd_1
XPHY_EDGE_ROW_100_Left_219 VDD VSS gf180mcu_fd_sc_mcu7t5v0__endcap
X_6029_ _6029_/A1 _6029_/A2 _6033_/B1 VDD VDD VSS VSS gf180mcu_fd_sc_mcu7t5v0__nor2_1
XFILLER_27_554 VDD VDD VSS VSS gf180mcu_fd_sc_mcu7t5v0__fillcap_4
XFILLER_55_885 VDD VDD VSS VSS gf180mcu_fd_sc_mcu7t5v0__fillcap_16
XFILLER_82_693 VDD VDD VSS VSS gf180mcu_fd_sc_mcu7t5v0__fill_1
XFILLER_70_877 VDD VDD VSS VSS gf180mcu_fd_sc_mcu7t5v0__fillcap_8
XFILLER_70_866 VDD VDD VSS VSS gf180mcu_fd_sc_mcu7t5v0__fill_2
XTAP_TAPCELL_ROW_12_427 VDD VSS gf180mcu_fd_sc_mcu7t5v0__filltie
XFILLER_22_270 VDD VDD VSS VSS gf180mcu_fd_sc_mcu7t5v0__fill_1
XTAP_TAPCELL_ROW_81_1396 VDD VSS gf180mcu_fd_sc_mcu7t5v0__filltie
XFILLER_13_40 VDD VDD VSS VSS gf180mcu_fd_sc_mcu7t5v0__fill_1
XFILLER_109_821 VDD VDD VSS VSS gf180mcu_fd_sc_mcu7t5v0__fillcap_8
XFILLER_10_476 VDD VDD VSS VSS gf180mcu_fd_sc_mcu7t5v0__fill_2
XFILLER_108_375 VDD VDD VSS VSS gf180mcu_fd_sc_mcu7t5v0__fill_2
XFILLER_33_502 VDD VDD VSS VSS gf180mcu_fd_sc_mcu7t5v0__fill_2
XFILLER_46_874 VDD VDD VSS VSS gf180mcu_fd_sc_mcu7t5v0__fill_1
XFILLER_61_844 VDD VDD VSS VSS gf180mcu_fd_sc_mcu7t5v0__fill_1
XFILLER_20_229 VDD VDD VSS VSS gf180mcu_fd_sc_mcu7t5v0__fill_1
X_3730_ _3730_/A1 _3719_/I _3730_/Z VDD VDD VSS VSS gf180mcu_fd_sc_mcu7t5v0__xor2_1
XTAP_TAPCELL_ROW_99_1646 VDD VSS gf180mcu_fd_sc_mcu7t5v0__filltie
X_3661_ _3568_/Z _3574_/Z _3661_/B _3661_/C _3665_/A3 VDD VDD VSS VSS gf180mcu_fd_sc_mcu7t5v0__oai211_1
Xclkload44 _7695_/CLK clkload44/Z VDD VDD VSS VSS gf180mcu_fd_sc_mcu7t5v0__clkbuf_2
X_6380_ _7655_/Q _7521_/Q _6388_/A1 VDD VDD VSS VSS gf180mcu_fd_sc_mcu7t5v0__nand2_1
X_5400_ _5366_/Z _5399_/Z _5401_/C VDD VDD VSS VSS gf180mcu_fd_sc_mcu7t5v0__nand2_1
Xclkload11 _7804_/CLK clkload11/Z VDD VDD VSS VSS gf180mcu_fd_sc_mcu7t5v0__clkbuf_2
Xclkload22 _7748_/CLK clkload22/ZN VDD VDD VSS VSS gf180mcu_fd_sc_mcu7t5v0__inv_2
X_3592_ input33/Z input74/Z _3592_/A3 _3592_/Z VDD VDD VSS VSS gf180mcu_fd_sc_mcu7t5v0__xor3_1
Xclkload33 _7794_/CLK clkload33/ZN VDD VDD VSS VSS gf180mcu_fd_sc_mcu7t5v0__clkinv_2
Xclkload77 _7261_/CLK clkload77/Z VDD VDD VSS VSS gf180mcu_fd_sc_mcu7t5v0__clkbuf_2
Xclkload66 _7279_/CLK clkload66/Z VDD VDD VSS VSS gf180mcu_fd_sc_mcu7t5v0__clkbuf_2
X_5331_ _5345_/I0 _7478_/Q _5337_/S _7478_/D VDD VDD VSS VSS gf180mcu_fd_sc_mcu7t5v0__mux2_2
Xclkload55 _7505_/CLK clkload55/ZN VDD VDD VSS VSS gf180mcu_fd_sc_mcu7t5v0__inv_2
XFILLER_6_981 VDD VDD VSS VSS gf180mcu_fd_sc_mcu7t5v0__fill_1
XTAP_TAPCELL_ROW_110_1802 VDD VSS gf180mcu_fd_sc_mcu7t5v0__filltie
X_7001_ _7001_/D _7002_/CLK _7001_/Q VDD VDD VSS VSS gf180mcu_fd_sc_mcu7t5v0__dffq_1
X_5262_ _5304_/I0 _7409_/Q _5267_/S _7409_/D VDD VDD VSS VSS gf180mcu_fd_sc_mcu7t5v0__mux2_2
X_5193_ _5235_/I0 _7340_/Q _5197_/S _7340_/D VDD VDD VSS VSS gf180mcu_fd_sc_mcu7t5v0__mux2_2
X_4213_ _4235_/A1 _4219_/A2 _5281_/S VDD VDD VSS VSS gf180mcu_fd_sc_mcu7t5v0__nand2_1
X_4144_ _4144_/A1 _3967_/I _5106_/A2 VDD VDD VSS VSS gf180mcu_fd_sc_mcu7t5v0__nand2_1
XFILLER_84_947 VDD VDD VSS VSS gf180mcu_fd_sc_mcu7t5v0__fillcap_32
XFILLER_84_925 VDD VDD VSS VSS gf180mcu_fd_sc_mcu7t5v0__fillcap_16
XTAP_TAPCELL_ROW_39_803 VDD VSS gf180mcu_fd_sc_mcu7t5v0__filltie
XFILLER_68_487 VDD VDD VSS VSS gf180mcu_fd_sc_mcu7t5v0__fill_2
XFILLER_83_446 VDD VDD VSS VSS gf180mcu_fd_sc_mcu7t5v0__fill_1
X_4075_ _4132_/A1 _4081_/A2 _4798_/A2 VDD VDD VSS VSS gf180mcu_fd_sc_mcu7t5v0__nand2_1
XTAP_TAPCELL_ROW_108_1775 VDD VSS gf180mcu_fd_sc_mcu7t5v0__filltie
XTAP_TAPCELL_ROW_108_1764 VDD VSS gf180mcu_fd_sc_mcu7t5v0__filltie
XFILLER_52_844 VDD VDD VSS VSS gf180mcu_fd_sc_mcu7t5v0__fill_1
X_7765_ _7765_/D _7785_/RN _7765_/CLK _7765_/Q VDD VDD VSS VSS gf180mcu_fd_sc_mcu7t5v0__dffsnq_1
XFILLER_52_877 VDD VDD VSS VSS gf180mcu_fd_sc_mcu7t5v0__fillcap_64
X_6716_ _7756_/Q _6716_/A2 _6717_/B VDD VDD VSS VSS gf180mcu_fd_sc_mcu7t5v0__nand2_1
X_4977_ _7203_/Q _4980_/A2 _4978_/B VDD VDD VSS VSS gf180mcu_fd_sc_mcu7t5v0__nand2_1
Xclkload5 clkload5/I clkload5/ZN VDD VDD VSS VSS gf180mcu_fd_sc_mcu7t5v0__clkinv_8
X_7696_ _7696_/D _7783_/RN _7780_/CLK _7696_/Q VDD VDD VSS VSS gf180mcu_fd_sc_mcu7t5v0__dffrnq_1
X_3928_ _3928_/I _5696_/A1 VDD VDD VSS VSS gf180mcu_fd_sc_mcu7t5v0__clkinv_1
X_6647_ _7732_/Q _6650_/A2 _6649_/B VDD VDD VSS VSS gf180mcu_fd_sc_mcu7t5v0__nand2_1
X_3859_ _7538_/Q _7751_/Q _3859_/B _3859_/ZN VDD VDD VSS VSS gf180mcu_fd_sc_mcu7t5v0__oai21_2
XFILLER_109_139 VDD VDD VSS VSS gf180mcu_fd_sc_mcu7t5v0__fill_1
X_6578_ _7783_/Q _7548_/Q _6622_/B VDD VDD VSS VSS gf180mcu_fd_sc_mcu7t5v0__nand2_1
X_5529_ _7441_/Q _5607_/A2 _5607_/B1 _7287_/Q _5530_/A3 VDD VDD VSS VSS gf180mcu_fd_sc_mcu7t5v0__oai22_1
XFILLER_105_378 VDD VDD VSS VSS gf180mcu_fd_sc_mcu7t5v0__fill_2
XFILLER_101_562 VDD VDD VSS VSS gf180mcu_fd_sc_mcu7t5v0__fill_1
Xfanout286 _4826_/A1 _5078_/A1 VDD VDD VSS VSS gf180mcu_fd_sc_mcu7t5v0__dlyd_1
XTAP_TAPCELL_ROW_83_1425 VDD VSS gf180mcu_fd_sc_mcu7t5v0__filltie
XTAP_TAPCELL_ROW_83_1414 VDD VSS gf180mcu_fd_sc_mcu7t5v0__filltie
XFILLER_42_387 VDD VDD VSS VSS gf180mcu_fd_sc_mcu7t5v0__fill_2
XTAP_TAPCELL_ROW_94_1576 VDD VSS gf180mcu_fd_sc_mcu7t5v0__filltie
XFILLER_66_936 VDD VDD VSS VSS gf180mcu_fd_sc_mcu7t5v0__fillcap_8
XFILLER_66_947 VDD VDD VSS VSS gf180mcu_fd_sc_mcu7t5v0__fillcap_32
XFILLER_37_148 VDD VDD VSS VSS gf180mcu_fd_sc_mcu7t5v0__fill_1
X_5880_ _5880_/A1 _5880_/A2 _5881_/C VDD VDD VSS VSS gf180mcu_fd_sc_mcu7t5v0__nand2_1
X_4900_ _4942_/A1 _4910_/A2 _4900_/B _7164_/D VDD VDD VSS VSS gf180mcu_fd_sc_mcu7t5v0__oai21_1
XFILLER_34_877 VDD VDD VSS VSS gf180mcu_fd_sc_mcu7t5v0__fillcap_64
X_4831_ _7130_/Q _4840_/A2 _4832_/B VDD VDD VSS VSS gf180mcu_fd_sc_mcu7t5v0__nand2_1
XTAP_TAPCELL_ROW_44_872 VDD VSS gf180mcu_fd_sc_mcu7t5v0__filltie
XTAP_TAPCELL_ROW_103_1694 VDD VSS gf180mcu_fd_sc_mcu7t5v0__filltie
X_4762_ _4762_/A1 _4770_/A2 _4762_/B _7095_/D VDD VDD VSS VSS gf180mcu_fd_sc_mcu7t5v0__oai21_1
X_7550_ _7550_/D _7733_/RN _7782_/CLK _7550_/Q VDD VDD VSS VSS gf180mcu_fd_sc_mcu7t5v0__dffrnq_1
X_4693_ _7061_/Q _4700_/A2 _4694_/B VDD VDD VSS VSS gf180mcu_fd_sc_mcu7t5v0__nand2_1
X_6501_ _7675_/Q _7676_/Q _6495_/Z _6505_/A2 VDD VDD VSS VSS gf180mcu_fd_sc_mcu7t5v0__nand3_1
X_7481_ _7481_/D _7483_/CLK _7481_/Q VDD VDD VSS VSS gf180mcu_fd_sc_mcu7t5v0__dffq_1
X_3713_ _4221_/A1 _5493_/S _3713_/Z VDD VDD VSS VSS gf180mcu_fd_sc_mcu7t5v0__xor2_1
X_6432_ _7664_/Q _7530_/Q _6432_/Z VDD VDD VSS VSS gf180mcu_fd_sc_mcu7t5v0__or2_1
X_3644_ input32/Z input46/Z _3602_/Z _3644_/Z VDD VDD VSS VSS gf180mcu_fd_sc_mcu7t5v0__xor3_1
X_3575_ input31/Z input33/Z _3575_/Z VDD VDD VSS VSS gf180mcu_fd_sc_mcu7t5v0__xor2_1
X_6363_ _6363_/A1 _6363_/A2 _6363_/B1 _7540_/Q _7647_/D VDD VDD VSS VSS gf180mcu_fd_sc_mcu7t5v0__aoi22_1
X_6294_ _6294_/A1 _6298_/A2 _6300_/B1 _6294_/B2 _7599_/D VDD VDD VSS VSS gf180mcu_fd_sc_mcu7t5v0__aoi22_1
X_5314_ _5342_/I0 _7461_/Q _5316_/S _7461_/D VDD VDD VSS VSS gf180mcu_fd_sc_mcu7t5v0__mux2_2
XTAP_TAPCELL_ROW_54_1015 VDD VSS gf180mcu_fd_sc_mcu7t5v0__filltie
XFILLER_88_527 VDD VDD VSS VSS gf180mcu_fd_sc_mcu7t5v0__fill_2
X_5245_ _5245_/I0 _7392_/Q _5246_/S _7392_/D VDD VDD VSS VSS gf180mcu_fd_sc_mcu7t5v0__mux2_2
X_5176_ wire513/Z _7323_/Q _5176_/S _7323_/D VDD VDD VSS VSS gf180mcu_fd_sc_mcu7t5v0__mux2_2
X_4127_ _6793_/Q _5022_/A2 _4128_/B VDD VDD VSS VSS gf180mcu_fd_sc_mcu7t5v0__nand2_1
XFILLER_56_457 VDD VDD VSS VSS gf180mcu_fd_sc_mcu7t5v0__fill_1
X_4058_ _4088_/A1 _4714_/A2 _4058_/B _6771_/D VDD VDD VSS VSS gf180mcu_fd_sc_mcu7t5v0__oai21_1
XFILLER_52_663 VDD VDD VSS VSS gf180mcu_fd_sc_mcu7t5v0__fill_2
X_7817_ _7817_/D _7822_/RN _7822_/CLK _7817_/Q VDD VDD VSS VSS gf180mcu_fd_sc_mcu7t5v0__dffsnq_1
XTAP_TAPCELL_ROW_65_1166 VDD VSS gf180mcu_fd_sc_mcu7t5v0__filltie
X_7748_ _7748_/D _7755_/RN _7748_/CLK _7748_/Q VDD VDD VSS VSS gf180mcu_fd_sc_mcu7t5v0__dffrnq_1
X_7679_ _7679_/D _7694_/RN _7802_/CLK _7679_/Q VDD VDD VSS VSS gf180mcu_fd_sc_mcu7t5v0__dffrnq_1
XTAP_TAPCELL_ROW_22_566 VDD VSS gf180mcu_fd_sc_mcu7t5v0__filltie
XFILLER_4_737 VDD VDD VSS VSS gf180mcu_fd_sc_mcu7t5v0__fillcap_64
XFILLER_79_549 VDD VDD VSS VSS gf180mcu_fd_sc_mcu7t5v0__fillcap_8
XFILLER_0_954 VDD VDD VSS VSS gf180mcu_fd_sc_mcu7t5v0__fillcap_16
XFILLER_48_947 VDD VDD VSS VSS gf180mcu_fd_sc_mcu7t5v0__fillcap_32
XFILLER_74_287 VDD VDD VSS VSS gf180mcu_fd_sc_mcu7t5v0__fill_2
XTAP_TAPCELL_ROW_2_280 VDD VSS gf180mcu_fd_sc_mcu7t5v0__filltie
XTAP_TAPCELL_ROW_2_291 VDD VSS gf180mcu_fd_sc_mcu7t5v0__filltie
XFILLER_34_107 VDD VDD VSS VSS gf180mcu_fd_sc_mcu7t5v0__fill_1
XFILLER_16_877 VDD VDD VSS VSS gf180mcu_fd_sc_mcu7t5v0__fillcap_64
XFILLER_31_836 VDD VDD VSS VSS gf180mcu_fd_sc_mcu7t5v0__fillcap_4
XTAP_TAPCELL_ROW_41_831 VDD VSS gf180mcu_fd_sc_mcu7t5v0__filltie
XTAP_TAPCELL_ROW_96_1605 VDD VSS gf180mcu_fd_sc_mcu7t5v0__filltie
X_7793__600 _7793_/D VDD VDD VSS VSS gf180mcu_fd_sc_mcu7t5v0__tiel
X_3360_ _7770_/Q _3512_/A1 VDD VDD VSS VSS gf180mcu_fd_sc_mcu7t5v0__clkinv_1
XFILLER_98_836 VDD VDD VSS VSS gf180mcu_fd_sc_mcu7t5v0__fillcap_8
Xload_slew401 _6198_/A2 _6162_/A2 VDD VDD VSS VSS gf180mcu_fd_sc_mcu7t5v0__clkbuf_4
Xload_slew412 _6151_/C2 _6153_/A2 VDD VDD VSS VSS gf180mcu_fd_sc_mcu7t5v0__buf_4
Xload_slew423 _5442_/A2 _5515_/A2 VDD VDD VSS VSS gf180mcu_fd_sc_mcu7t5v0__clkbuf_4
Xload_slew456 _5616_/S _5584_/S VDD VDD VSS VSS gf180mcu_fd_sc_mcu7t5v0__buf_4
X_5030_ _5072_/A1 _5036_/A2 _5030_/B _7229_/D VDD VDD VSS VSS gf180mcu_fd_sc_mcu7t5v0__oai21_1
XFILLER_38_413 VDD VDD VSS VSS gf180mcu_fd_sc_mcu7t5v0__fill_1
Xload_slew489 _6201_/C _6242_/C VDD VDD VSS VSS gf180mcu_fd_sc_mcu7t5v0__buf_4
XTAP_TAPCELL_ROW_49_942 VDD VSS gf180mcu_fd_sc_mcu7t5v0__filltie
X_6981_ _6981_/D _7003_/CLK _6981_/Q VDD VDD VSS VSS gf180mcu_fd_sc_mcu7t5v0__dffq_1
XTAP_TAPCELL_ROW_105_1723 VDD VSS gf180mcu_fd_sc_mcu7t5v0__filltie
X_5932_ _5932_/A1 _5932_/A2 _6196_/B _5933_/B2 VDD VDD VSS VSS gf180mcu_fd_sc_mcu7t5v0__oai21_1
XTAP_TAPCELL_ROW_0_239 VDD VSS gf180mcu_fd_sc_mcu7t5v0__filltie
XTAP_TAPCELL_ROW_105_1734 VDD VSS gf180mcu_fd_sc_mcu7t5v0__filltie
X_5863_ _7157_/Q _6055_/A2 _6239_/B1 _7136_/Q _6134_/C _5867_/A2 VDD VDD VSS VSS gf180mcu_fd_sc_mcu7t5v0__oai221_1
X_5794_ _6883_/Q wire322/Z _6076_/B1 _6890_/Q _6897_/Q _6076_/A2 _5795_/A2 VDD VDD
+ VSS VSS gf180mcu_fd_sc_mcu7t5v0__oai222_1
X_7602_ _7602_/D _7664_/RN _7671_/CLK _7602_/Q VDD VDD VSS VSS gf180mcu_fd_sc_mcu7t5v0__dffrnq_1
XFILLER_33_173 VDD VDD VSS VSS gf180mcu_fd_sc_mcu7t5v0__fill_1
X_4814_ _4996_/A1 _4826_/A2 _4814_/B _7121_/D VDD VDD VSS VSS gf180mcu_fd_sc_mcu7t5v0__oai21_1
X_7533_ _7533_/D _7668_/RN _7670_/CLK _7533_/Q VDD VDD VSS VSS gf180mcu_fd_sc_mcu7t5v0__dffrnq_1
X_4745_ _7087_/Q _4756_/A2 _4746_/B VDD VDD VSS VSS gf180mcu_fd_sc_mcu7t5v0__nand2_1
X_4676_ _4998_/A1 _4686_/A2 _4676_/B _7052_/D VDD VDD VSS VSS gf180mcu_fd_sc_mcu7t5v0__oai21_1
X_7464_ _7464_/D _7491_/CLK _7464_/Q VDD VDD VSS VSS gf180mcu_fd_sc_mcu7t5v0__dffq_1
XTAP_TAPCELL_ROW_60_1096 VDD VSS gf180mcu_fd_sc_mcu7t5v0__filltie
XFILLER_116_941 VDD VDD VSS VSS gf180mcu_fd_sc_mcu7t5v0__fillcap_4
X_6415_ _6451_/A2 _6415_/A2 _6415_/B _7661_/D VDD VDD VSS VSS gf180mcu_fd_sc_mcu7t5v0__oai21_1
X_3627_ input84/Z input87/Z _3627_/Z VDD VDD VSS VSS gf180mcu_fd_sc_mcu7t5v0__xor2_1
X_7395_ _7395_/D _7451_/CLK _7395_/Q VDD VDD VSS VSS gf180mcu_fd_sc_mcu7t5v0__dffq_1
XTAP_TAPCELL_ROW_116_1885 VDD VSS gf180mcu_fd_sc_mcu7t5v0__filltie
X_6346_ input51/Z _6352_/S _6347_/B VDD VDD VSS VSS gf180mcu_fd_sc_mcu7t5v0__nand2_1
X_3558_ _7880_/I input99/Z input22/Z _3558_/Z VDD VDD VSS VSS gf180mcu_fd_sc_mcu7t5v0__xor3_1
X_6277_ _7634_/Q _6283_/A2 _6283_/B1 _7799_/D _6283_/C1 _7524_/Q _6278_/B2 VDD VDD
+ VSS VSS gf180mcu_fd_sc_mcu7t5v0__aoi222_1
Xinput107 tl_i[9] _3605_/A1 VDD VDD VSS VSS gf180mcu_fd_sc_mcu7t5v0__dlyd_1
X_3489_ _3494_/A1 _3488_/Z _7798_/D VDD VDD VSS VSS gf180mcu_fd_sc_mcu7t5v0__xor2_1
X_5228_ _5228_/I0 _7375_/Q _5232_/S _7375_/D VDD VDD VSS VSS gf180mcu_fd_sc_mcu7t5v0__mux2_2
X_5159_ wire525/Z _7306_/Q _5162_/S _7306_/D VDD VDD VSS VSS gf180mcu_fd_sc_mcu7t5v0__mux2_2
XFILLER_29_424 VDD VDD VSS VSS gf180mcu_fd_sc_mcu7t5v0__fill_1
XFILLER_45_906 VDD VDD VSS VSS gf180mcu_fd_sc_mcu7t5v0__fillcap_4
XFILLER_44_438 VDD VDD VSS VSS gf180mcu_fd_sc_mcu7t5v0__fill_2
XTAP_TAPCELL_ROW_27_636 VDD VSS gf180mcu_fd_sc_mcu7t5v0__filltie
XFILLER_52_471 VDD VDD VSS VSS gf180mcu_fd_sc_mcu7t5v0__fill_2
XFILLER_13_836 VDD VDD VSS VSS gf180mcu_fd_sc_mcu7t5v0__fillcap_4
XFILLER_25_696 VDD VDD VSS VSS gf180mcu_fd_sc_mcu7t5v0__fillcap_4
XTAP_TAPCELL_ROW_78_1357 VDD VSS gf180mcu_fd_sc_mcu7t5v0__filltie
XTAP_TAPCELL_ROW_78_1346 VDD VSS gf180mcu_fd_sc_mcu7t5v0__filltie
XFILLER_4_523 VDD VDD VSS VSS gf180mcu_fd_sc_mcu7t5v0__fill_2
XTAP_TAPCELL_ROW_91_1535 VDD VSS gf180mcu_fd_sc_mcu7t5v0__filltie
XTAP_TAPCELL_ROW_7_350 VDD VSS gf180mcu_fd_sc_mcu7t5v0__filltie
XTAP_TAPCELL_ROW_7_361 VDD VSS gf180mcu_fd_sc_mcu7t5v0__filltie
XFILLER_0_784 VDD VDD VSS VSS gf180mcu_fd_sc_mcu7t5v0__fillcap_32
XTAP_TAPCELL_ROW_46_901 VDD VSS gf180mcu_fd_sc_mcu7t5v0__filltie
XFILLER_47_232 VDD VDD VSS VSS gf180mcu_fd_sc_mcu7t5v0__fill_1
XFILLER_48_777 VDD VDD VSS VSS gf180mcu_fd_sc_mcu7t5v0__fill_2
XFILLER_35_427 VDD VDD VSS VSS gf180mcu_fd_sc_mcu7t5v0__fill_2
XFILLER_90_566 VDD VDD VSS VSS gf180mcu_fd_sc_mcu7t5v0__fill_1
XFILLER_51_909 VDD VDD VSS VSS gf180mcu_fd_sc_mcu7t5v0__fill_1
XFILLER_63_769 VDD VDD VSS VSS gf180mcu_fd_sc_mcu7t5v0__fill_1
XTAP_TAPCELL_ROW_100_1653 VDD VSS gf180mcu_fd_sc_mcu7t5v0__filltie
XTAP_TAPCELL_ROW_100_1664 VDD VSS gf180mcu_fd_sc_mcu7t5v0__filltie
XFILLER_7_20 VDD VDD VSS VSS gf180mcu_fd_sc_mcu7t5v0__fill_2
X_4530_ _5118_/A1 _4532_/A2 _4530_/B _6979_/D VDD VDD VSS VSS gf180mcu_fd_sc_mcu7t5v0__oai21_1
X_4461_ _6945_/Q _4462_/A2 _4462_/B VDD VDD VSS VSS gf180mcu_fd_sc_mcu7t5v0__nand2_1
Xwire292 wire292/I wire292/Z VDD VDD VSS VSS gf180mcu_fd_sc_mcu7t5v0__clkbuf_4
X_3412_ _7690_/Q _5728_/B2 VDD VDD VSS VSS gf180mcu_fd_sc_mcu7t5v0__clkinv_1
X_6200_ _6744_/Q _6229_/A2 wire341/Z _6743_/Q _6202_/A1 VDD VDD VSS VSS gf180mcu_fd_sc_mcu7t5v0__oai22_1
X_7180_ _7180_/D _7719_/CLK _7180_/Q VDD VDD VSS VSS gf180mcu_fd_sc_mcu7t5v0__dffq_1
X_4392_ _4532_/A1 _4392_/A2 _4392_/B _6910_/D VDD VDD VSS VSS gf180mcu_fd_sc_mcu7t5v0__oai21_1
X_6131_ _6868_/Q _6131_/A2 _6201_/C _6136_/A1 VDD VDD VSS VSS gf180mcu_fd_sc_mcu7t5v0__oai21_1
XFILLER_112_465 VDD VDD VSS VSS gf180mcu_fd_sc_mcu7t5v0__fill_2
Xload_slew264 _5012_/A1 _5124_/A1 VDD VDD VSS VSS gf180mcu_fd_sc_mcu7t5v0__clkbuf_4
XFILLER_86_817 VDD VDD VSS VSS gf180mcu_fd_sc_mcu7t5v0__fill_2
Xload_slew253 _3863_/ZN fanout251/I VDD VDD VSS VSS gf180mcu_fd_sc_mcu7t5v0__buf_2
Xload_slew242 _3865_/ZN _4752_/A1 VDD VDD VSS VSS gf180mcu_fd_sc_mcu7t5v0__clkbuf_4
X_6062_ _7563_/Q _5691_/I _6271_/B1 _7619_/Q _7543_/Q _6256_/A2 _6064_/A1 VDD VDD
+ VSS VSS gf180mcu_fd_sc_mcu7t5v0__aoi222_1
X_5013_ _7221_/Q _5022_/A2 _5014_/B VDD VDD VSS VSS gf180mcu_fd_sc_mcu7t5v0__nand2_1
Xload_slew275 _5066_/A1 _4996_/A1 VDD VDD VSS VSS gf180mcu_fd_sc_mcu7t5v0__clkbuf_4
Xload_slew297 _6241_/B1 _6239_/B1 VDD VDD VSS VSS gf180mcu_fd_sc_mcu7t5v0__buf_4
XFILLER_27_906 VDD VDD VSS VSS gf180mcu_fd_sc_mcu7t5v0__fillcap_4
XFILLER_39_766 VDD VDD VSS VSS gf180mcu_fd_sc_mcu7t5v0__fillcap_4
XFILLER_26_18 VDD VDD VSS VSS gf180mcu_fd_sc_mcu7t5v0__fill_1
X_6964_ _6964_/D _7667_/CLK _6964_/Q VDD VDD VSS VSS gf180mcu_fd_sc_mcu7t5v0__dffq_1
XPHY_EDGE_ROW_5_Right_5 VDD VSS gf180mcu_fd_sc_mcu7t5v0__endcap
X_6895_ _6895_/D _7008_/CLK _6895_/Q VDD VDD VSS VSS gf180mcu_fd_sc_mcu7t5v0__dffq_1
X_5915_ _6997_/Q _6198_/B1 _6198_/C2 _6976_/Q _5917_/A1 VDD VDD VSS VSS gf180mcu_fd_sc_mcu7t5v0__oai22_1
X_5846_ _5846_/A1 _5846_/A2 _6196_/B _5847_/A2 VDD VDD VSS VSS gf180mcu_fd_sc_mcu7t5v0__oai21_1
XTAP_TAPCELL_ROW_62_1125 VDD VSS gf180mcu_fd_sc_mcu7t5v0__filltie
X_5777_ _5777_/A1 _5777_/A2 _6136_/B _5778_/B2 VDD VDD VSS VSS gf180mcu_fd_sc_mcu7t5v0__oai21_1
XTAP_TAPCELL_ROW_118_1925 VDD VSS gf180mcu_fd_sc_mcu7t5v0__filltie
XTAP_TAPCELL_ROW_118_1914 VDD VSS gf180mcu_fd_sc_mcu7t5v0__filltie
X_7516_ _7516_/D _7612_/RN _7710_/CLK _7516_/Q VDD VDD VSS VSS gf180mcu_fd_sc_mcu7t5v0__dffrnq_1
X_4728_ wire291/Z _4728_/A2 _4728_/B _7078_/D VDD VDD VSS VSS gf180mcu_fd_sc_mcu7t5v0__oai21_1
X_4659_ _7044_/Q _4672_/A2 _4660_/B VDD VDD VSS VSS gf180mcu_fd_sc_mcu7t5v0__nand2_1
X_7447_ _7447_/D _7754_/CLK _7447_/Q VDD VDD VSS VSS gf180mcu_fd_sc_mcu7t5v0__dffq_1
X_7378_ _7378_/D _7378_/CLK _7378_/Q VDD VDD VSS VSS gf180mcu_fd_sc_mcu7t5v0__dffq_1
XFILLER_104_944 VDD VDD VSS VSS gf180mcu_fd_sc_mcu7t5v0__fill_1
XFILLER_1_548 VDD VDD VSS VSS gf180mcu_fd_sc_mcu7t5v0__fillcap_8
X_6329_ input38/Z _6331_/S _6330_/B VDD VDD VSS VSS gf180mcu_fd_sc_mcu7t5v0__nand2_1
XFILLER_77_828 VDD VDD VSS VSS gf180mcu_fd_sc_mcu7t5v0__fill_1
XTAP_TAPCELL_ROW_73_1287 VDD VSS gf180mcu_fd_sc_mcu7t5v0__filltie
XTAP_TAPCELL_ROW_73_1276 VDD VSS gf180mcu_fd_sc_mcu7t5v0__filltie
XTAP_TAPCELL_ROW_4_320 VDD VSS gf180mcu_fd_sc_mcu7t5v0__filltie
XFILLER_45_769 VDD VDD VSS VSS gf180mcu_fd_sc_mcu7t5v0__fill_1
XFILLER_9_626 VDD VDD VSS VSS gf180mcu_fd_sc_mcu7t5v0__fillcap_4
XTAP_TAPCELL_ROW_51_970 VDD VSS gf180mcu_fd_sc_mcu7t5v0__filltie
XTAP_TAPCELL_ROW_10_399 VDD VSS gf180mcu_fd_sc_mcu7t5v0__filltie
XFILLER_68_828 VDD VDD VSS VSS gf180mcu_fd_sc_mcu7t5v0__fill_1
XFILLER_110_947 VDD VDD VSS VSS gf180mcu_fd_sc_mcu7t5v0__fillcap_32
XFILLER_91_820 VDD VDD VSS VSS gf180mcu_fd_sc_mcu7t5v0__fillcap_4
XFILLER_82_319 VDD VDD VSS VSS gf180mcu_fd_sc_mcu7t5v0__fill_1
XFILLER_91_842 VDD VDD VSS VSS gf180mcu_fd_sc_mcu7t5v0__fillcap_8
XFILLER_63_533 VDD VDD VSS VSS gf180mcu_fd_sc_mcu7t5v0__fill_1
X_3961_ wire248/I _4308_/A2 _3961_/B _6742_/D VDD VDD VSS VSS gf180mcu_fd_sc_mcu7t5v0__oai21_1
XFILLER_23_419 VDD VDD VSS VSS gf180mcu_fd_sc_mcu7t5v0__fill_1
X_5700_ input37/Z _6373_/S _5700_/B _5701_/B VDD VDD VSS VSS gf180mcu_fd_sc_mcu7t5v0__aoi21_1
X_6680_ _7742_/Q _6694_/A2 _6678_/I _6679_/Z _6681_/I VDD VDD VSS VSS gf180mcu_fd_sc_mcu7t5v0__aoi22_1
X_3892_ _6368_/I1 _3892_/A2 _3892_/B1 _3892_/B2 _3895_/A2 VDD VDD VSS VSS gf180mcu_fd_sc_mcu7t5v0__aoi22_1
X_5631_ _7769_/Q _7769_/D _5631_/B _5632_/B VDD VDD VSS VSS gf180mcu_fd_sc_mcu7t5v0__aoi21_1
X_5562_ _7295_/Q _5562_/A2 _5596_/B1 _7498_/Q _5563_/A3 VDD VDD VSS VSS gf180mcu_fd_sc_mcu7t5v0__oai22_1
X_4513_ _6971_/Q _4518_/A2 _4514_/B VDD VDD VSS VSS gf180mcu_fd_sc_mcu7t5v0__nand2_1
X_7301_ _7301_/D _7505_/CLK _7301_/Q VDD VDD VSS VSS gf180mcu_fd_sc_mcu7t5v0__dffq_1
X_5493_ _5493_/I0 _5493_/I1 _5493_/S _5493_/Z VDD VDD VSS VSS gf180mcu_fd_sc_mcu7t5v0__mux2_2
X_7232_ _7232_/D _7247_/CLK _7232_/Q VDD VDD VSS VSS gf180mcu_fd_sc_mcu7t5v0__dffq_1
X_4444_ wire240/Z _4448_/A2 _4444_/B _6936_/D VDD VDD VSS VSS gf180mcu_fd_sc_mcu7t5v0__oai21_1
X_4375_ _6902_/Q _4378_/A2 _4376_/B VDD VDD VSS VSS gf180mcu_fd_sc_mcu7t5v0__nand2_1
XTAP_TAPCELL_ROW_113_1844 VDD VSS gf180mcu_fd_sc_mcu7t5v0__filltie
X_7163_ _7163_/D _7453_/CLK _7163_/Q VDD VDD VSS VSS gf180mcu_fd_sc_mcu7t5v0__dffq_1
X_7094_ _7094_/D _7101_/CLK _7094_/Q VDD VDD VSS VSS gf180mcu_fd_sc_mcu7t5v0__dffq_1
X_6114_ _6114_/A1 _6114_/A2 _6122_/A1 VDD VDD VSS VSS gf180mcu_fd_sc_mcu7t5v0__nor2_1
XPHY_EDGE_ROW_13_Left_132 VDD VSS gf180mcu_fd_sc_mcu7t5v0__endcap
X_6045_ _6045_/A1 _6045_/A2 _6046_/B VDD VDD VSS VSS gf180mcu_fd_sc_mcu7t5v0__or2_1
Xclkbuf_leaf_50_clk_i clkload6/I _7060_/CLK VDD VDD VSS VSS gf180mcu_fd_sc_mcu7t5v0__clkbuf_8
XFILLER_100_479 VDD VDD VSS VSS gf180mcu_fd_sc_mcu7t5v0__fill_1
XFILLER_67_883 VDD VDD VSS VSS gf180mcu_fd_sc_mcu7t5v0__fill_1
XFILLER_94_691 VDD VDD VSS VSS gf180mcu_fd_sc_mcu7t5v0__fill_1
XFILLER_81_352 VDD VDD VSS VSS gf180mcu_fd_sc_mcu7t5v0__fill_2
XTAP_TAPCELL_ROW_37_775 VDD VSS gf180mcu_fd_sc_mcu7t5v0__filltie
X_6947_ _6947_/D _7667_/CLK _6947_/Q VDD VDD VSS VSS gf180mcu_fd_sc_mcu7t5v0__dffq_1
Xclkbuf_leaf_65_clk_i clkload3/I _7253_/CLK VDD VDD VSS VSS gf180mcu_fd_sc_mcu7t5v0__clkbuf_8
X_6878_ _6878_/D _6882_/CLK _6878_/Q VDD VDD VSS VSS gf180mcu_fd_sc_mcu7t5v0__dffq_1
XPHY_EDGE_ROW_22_Left_141 VDD VSS gf180mcu_fd_sc_mcu7t5v0__endcap
X_5829_ _6849_/Q _6198_/A2 _6198_/B1 _6842_/Q _7276_/Q _6089_/B1 _5830_/A2 VDD VDD
+ VSS VSS gf180mcu_fd_sc_mcu7t5v0__oai222_1
XTAP_TAPCELL_ROW_75_1305 VDD VSS gf180mcu_fd_sc_mcu7t5v0__filltie
XFILLER_104_730 VDD VDD VSS VSS gf180mcu_fd_sc_mcu7t5v0__fillcap_4
XPHY_EDGE_ROW_31_Left_150 VDD VSS gf180mcu_fd_sc_mcu7t5v0__endcap
Xclkbuf_leaf_18_clk_i clkload1/I _7781_/CLK VDD VDD VSS VSS gf180mcu_fd_sc_mcu7t5v0__clkbuf_8
XFILLER_45_500 VDD VDD VSS VSS gf180mcu_fd_sc_mcu7t5v0__fillcap_8
XFILLER_58_872 VDD VDD VSS VSS gf180mcu_fd_sc_mcu7t5v0__fill_2
XTAP_TAPCELL_ROW_86_1456 VDD VSS gf180mcu_fd_sc_mcu7t5v0__filltie
XFILLER_73_842 VDD VDD VSS VSS gf180mcu_fd_sc_mcu7t5v0__fillcap_8
XTAP_TAPCELL_ROW_86_1467 VDD VSS gf180mcu_fd_sc_mcu7t5v0__filltie
XTAP_TAPCELL_ROW_15_469 VDD VSS gf180mcu_fd_sc_mcu7t5v0__filltie
XFILLER_41_772 VDD VDD VSS VSS gf180mcu_fd_sc_mcu7t5v0__fillcap_64
X_4160_ _7732_/Q _4165_/A2 _6651_/A1 VDD VDD VSS VSS gf180mcu_fd_sc_mcu7t5v0__nor2_2
X_4091_ _4112_/A1 _4854_/A2 _4091_/B _6781_/D VDD VDD VSS VSS gf180mcu_fd_sc_mcu7t5v0__oai21_1
XFILLER_110_799 VDD VDD VSS VSS gf180mcu_fd_sc_mcu7t5v0__fillcap_4
X_6801_ _6801_/D _7683_/CLK _6801_/Q VDD VDD VSS VSS gf180mcu_fd_sc_mcu7t5v0__dffq_1
XFILLER_63_352 VDD VDD VSS VSS gf180mcu_fd_sc_mcu7t5v0__fill_1
XTAP_TAPCELL_ROW_34_734 VDD VSS gf180mcu_fd_sc_mcu7t5v0__filltie
X_4993_ _7211_/Q _4994_/A2 _4994_/B VDD VDD VSS VSS gf180mcu_fd_sc_mcu7t5v0__nand2_1
XFILLER_51_525 VDD VDD VSS VSS gf180mcu_fd_sc_mcu7t5v0__fill_1
X_7781_ _7781_/D _7560_/RN _7781_/CLK _7781_/Q VDD VDD VSS VSS gf180mcu_fd_sc_mcu7t5v0__dffsnq_1
X_3944_ _7722_/Q _6608_/A2 _4138_/A1 VDD VDD VSS VSS gf180mcu_fd_sc_mcu7t5v0__nand2_1
X_6732_ _6732_/A1 _6731_/Z _7763_/D VDD VDD VSS VSS gf180mcu_fd_sc_mcu7t5v0__nor2_1
X_6663_ _6697_/A1 _6663_/A2 _7738_/D VDD VDD VSS VSS gf180mcu_fd_sc_mcu7t5v0__nor2_1
X_3875_ _4942_/A1 _4948_/A1 _5112_/A1 _3877_/A3 VDD VDD VSS VSS gf180mcu_fd_sc_mcu7t5v0__nand3_1
X_5614_ _5609_/B _5614_/A2 _5614_/A3 _5614_/B _5615_/B2 VDD VDD VSS VSS gf180mcu_fd_sc_mcu7t5v0__oai31_1
XFILLER_31_282 VDD VDD VSS VSS gf180mcu_fd_sc_mcu7t5v0__fill_2
X_6594_ _6597_/A2 _6594_/A2 _6595_/A2 VDD VDD VSS VSS gf180mcu_fd_sc_mcu7t5v0__nand2_1
X_5545_ _7427_/Q _5578_/A2 _5597_/B1 _7434_/Q _7455_/Q _5599_/A2 _5546_/A2 VDD VDD
+ VSS VSS gf180mcu_fd_sc_mcu7t5v0__oai222_1
X_5476_ _7439_/Q _5511_/B1 _5478_/A2 VDD VDD VSS VSS gf180mcu_fd_sc_mcu7t5v0__nor2_1
X_4427_ _6928_/Q _4434_/A2 _4428_/B VDD VDD VSS VSS gf180mcu_fd_sc_mcu7t5v0__nand2_1
XTAP_TAPCELL_ROW_57_1057 VDD VSS gf180mcu_fd_sc_mcu7t5v0__filltie
X_7215_ _7215_/D _7250_/CLK _7215_/Q VDD VDD VSS VSS gf180mcu_fd_sc_mcu7t5v0__dffq_1
X_7146_ _7146_/D _7267_/CLK _7146_/Q VDD VDD VSS VSS gf180mcu_fd_sc_mcu7t5v0__dffq_1
X_4358_ _5086_/A1 _4364_/A2 _4358_/B _6893_/D VDD VDD VSS VSS gf180mcu_fd_sc_mcu7t5v0__oai21_1
Xfanout424 _5596_/B1 _5578_/A2 VDD VDD VSS VSS gf180mcu_fd_sc_mcu7t5v0__dlyd_1
XTAP_TAPCELL_ROW_70_1235 VDD VSS gf180mcu_fd_sc_mcu7t5v0__filltie
X_4289_ _6859_/Q _4294_/A2 _4290_/B VDD VDD VSS VSS gf180mcu_fd_sc_mcu7t5v0__nand2_1
X_7077_ _7077_/D _7101_/CLK _7077_/Q VDD VDD VSS VSS gf180mcu_fd_sc_mcu7t5v0__dffq_1
Xfanout479 wire487/I wire481/I VDD VDD VSS VSS gf180mcu_fd_sc_mcu7t5v0__dlyd_1
X_6028_ _7090_/Q _6144_/A2 _6151_/A2 _7076_/Q _6084_/C _6029_/A2 VDD VDD VSS VSS gf180mcu_fd_sc_mcu7t5v0__oai221_1
XTAP_TAPCELL_ROW_81_1386 VDD VSS gf180mcu_fd_sc_mcu7t5v0__filltie
XFILLER_11_912 VDD VDD VSS VSS gf180mcu_fd_sc_mcu7t5v0__fillcap_64
XFILLER_23_772 VDD VDD VSS VSS gf180mcu_fd_sc_mcu7t5v0__fillcap_64
XTAP_TAPCELL_ROW_81_1397 VDD VSS gf180mcu_fd_sc_mcu7t5v0__filltie
XTAP_TAPCELL_ROW_12_428 VDD VSS gf180mcu_fd_sc_mcu7t5v0__filltie
XFILLER_109_888 VDD VDD VSS VSS gf180mcu_fd_sc_mcu7t5v0__fillcap_16
XFILLER_89_282 VDD VDD VSS VSS gf180mcu_fd_sc_mcu7t5v0__fill_2
XFILLER_46_820 VDD VDD VSS VSS gf180mcu_fd_sc_mcu7t5v0__fill_1
XFILLER_46_864 VDD VDD VSS VSS gf180mcu_fd_sc_mcu7t5v0__fillcap_8
XFILLER_60_344 VDD VDD VSS VSS gf180mcu_fd_sc_mcu7t5v0__fill_2
XFILLER_13_282 VDD VDD VSS VSS gf180mcu_fd_sc_mcu7t5v0__fill_2
XTAP_TAPCELL_ROW_99_1647 VDD VSS gf180mcu_fd_sc_mcu7t5v0__filltie
X_3660_ _3568_/Z _3574_/Z _3660_/B _3660_/C _3661_/C VDD VDD VSS VSS gf180mcu_fd_sc_mcu7t5v0__aoi211_1
Xclkload12 _7765_/CLK clkload12/ZN VDD VDD VSS VSS gf180mcu_fd_sc_mcu7t5v0__clkinv_1
Xclkload23 _7754_/CLK clkload23/Z VDD VDD VSS VSS gf180mcu_fd_sc_mcu7t5v0__clkbuf_2
Xclkload34 _7780_/CLK clkload34/ZN VDD VDD VSS VSS gf180mcu_fd_sc_mcu7t5v0__clkinv_2
X_3591_ _3591_/A1 _3588_/Z _3590_/Z _3660_/B VDD VDD VSS VSS gf180mcu_fd_sc_mcu7t5v0__xor3_1
Xclkload78 _7055_/CLK clkload78/Z VDD VDD VSS VSS gf180mcu_fd_sc_mcu7t5v0__clkbuf_4
Xclkload45 _7668_/CLK clkload45/ZN VDD VDD VSS VSS gf180mcu_fd_sc_mcu7t5v0__clkinv_2
Xclkload67 _7683_/CLK clkload67/ZN VDD VDD VSS VSS gf180mcu_fd_sc_mcu7t5v0__inv_2
X_5330_ _5344_/I0 _7477_/Q _5330_/S _7477_/D VDD VDD VSS VSS gf180mcu_fd_sc_mcu7t5v0__mux2_2
Xclkload56 _7451_/CLK clkload56/Z VDD VDD VSS VSS gf180mcu_fd_sc_mcu7t5v0__clkbuf_4
XFILLER_115_836 VDD VDD VSS VSS gf180mcu_fd_sc_mcu7t5v0__fillcap_4
X_5261_ _5303_/I0 _7408_/Q _5267_/S _7408_/D VDD VDD VSS VSS gf180mcu_fd_sc_mcu7t5v0__mux2_2
XTAP_TAPCELL_ROW_110_1803 VDD VSS gf180mcu_fd_sc_mcu7t5v0__filltie
X_7000_ _7000_/D _7276_/CLK _7000_/Q VDD VDD VSS VSS gf180mcu_fd_sc_mcu7t5v0__dffq_1
XFILLER_87_208 VDD VDD VSS VSS gf180mcu_fd_sc_mcu7t5v0__fill_2
X_4212_ _4226_/A3 _4212_/A2 _4219_/A2 VDD VDD VSS VSS gf180mcu_fd_sc_mcu7t5v0__nor2_1
XFILLER_48_2 VDD VDD VSS VSS gf180mcu_fd_sc_mcu7t5v0__fill_2
X_5192_ _6354_/I0 _7339_/Q _5197_/S _7339_/D VDD VDD VSS VSS gf180mcu_fd_sc_mcu7t5v0__mux2_2
X_4143_ _4143_/A1 _5092_/A2 _4143_/B _6798_/D VDD VDD VSS VSS gf180mcu_fd_sc_mcu7t5v0__oai21_1
XTAP_TAPCELL_ROW_39_804 VDD VSS gf180mcu_fd_sc_mcu7t5v0__filltie
X_4074_ _4088_/A1 _4784_/A2 _4074_/B _6776_/D VDD VDD VSS VSS gf180mcu_fd_sc_mcu7t5v0__oai21_1
XFILLER_37_842 VDD VDD VSS VSS gf180mcu_fd_sc_mcu7t5v0__fillcap_64
XTAP_TAPCELL_ROW_108_1765 VDD VSS gf180mcu_fd_sc_mcu7t5v0__filltie
XFILLER_92_981 VDD VDD VSS VSS gf180mcu_fd_sc_mcu7t5v0__fill_1
XTAP_TAPCELL_ROW_108_1776 VDD VSS gf180mcu_fd_sc_mcu7t5v0__filltie
X_7764_ _7764_/D _7764_/RN _7804_/CLK _7764_/Q VDD VDD VSS VSS gf180mcu_fd_sc_mcu7t5v0__dffrnq_1
X_6715_ _6715_/I _7755_/D VDD VDD VSS VSS gf180mcu_fd_sc_mcu7t5v0__clkinv_1
X_4976_ wire241/Z _4980_/A2 _4976_/B _7202_/D VDD VDD VSS VSS gf180mcu_fd_sc_mcu7t5v0__oai21_1
X_7695_ _7695_/D _7695_/RN _7695_/CLK _7695_/Q VDD VDD VSS VSS gf180mcu_fd_sc_mcu7t5v0__dffrnq_1
XFILLER_20_731 VDD VDD VSS VSS gf180mcu_fd_sc_mcu7t5v0__fillcap_4
X_3927_ _7793_/Q _3927_/A2 _3928_/I VDD VDD VSS VSS gf180mcu_fd_sc_mcu7t5v0__or2_1
Xclkload6 clkload6/I clkload6/ZN VDD VDD VSS VSS gf180mcu_fd_sc_mcu7t5v0__clkinv_8
X_6646_ _4155_/Z _6654_/B _6650_/A2 VDD VDD VSS VSS gf180mcu_fd_sc_mcu7t5v0__nor2_1
X_3858_ _7538_/Q _3932_/A1 _3859_/B VDD VDD VSS VSS gf180mcu_fd_sc_mcu7t5v0__nand2_1
X_3789_ _6697_/A1 _6670_/A2 _7791_/D VDD VDD VSS VSS gf180mcu_fd_sc_mcu7t5v0__nor2_1
X_6577_ _7783_/Q _7548_/Q _6621_/B VDD VDD VSS VSS gf180mcu_fd_sc_mcu7t5v0__and2_1
X_5528_ _7462_/Q wire428/Z _5606_/B1 _7364_/Q _5530_/A2 VDD VDD VSS VSS gf180mcu_fd_sc_mcu7t5v0__oai22_1
XFILLER_106_858 VDD VDD VSS VSS gf180mcu_fd_sc_mcu7t5v0__fillcap_16
X_5459_ _5459_/A1 _5459_/A2 _5614_/B _5460_/B2 VDD VDD VSS VSS gf180mcu_fd_sc_mcu7t5v0__oai21_1
Xfanout232 _4948_/A1 _5130_/A1 VDD VDD VSS VSS gf180mcu_fd_sc_mcu7t5v0__dlyd_1
Xfanout221 _4950_/A1 _5132_/A1 VDD VDD VSS VSS gf180mcu_fd_sc_mcu7t5v0__dlyd_1
XFILLER_87_731 VDD VDD VSS VSS gf180mcu_fd_sc_mcu7t5v0__fillcap_8
Xfanout210 fanout214/Z _5112_/A1 VDD VDD VSS VSS gf180mcu_fd_sc_mcu7t5v0__dlyd_1
Xfanout243 fanout251/I _4112_/A1 VDD VDD VSS VSS gf180mcu_fd_sc_mcu7t5v0__dlyd_1
Xfanout254 _5128_/A1 _4946_/A1 VDD VDD VSS VSS gf180mcu_fd_sc_mcu7t5v0__dlyd_1
Xfanout265 _5110_/A1 _4942_/A1 VDD VDD VSS VSS gf180mcu_fd_sc_mcu7t5v0__dlyd_1
X_7129_ _7129_/D _7189_/CLK _7129_/Q VDD VDD VSS VSS gf180mcu_fd_sc_mcu7t5v0__dffq_1
Xfanout298 _6074_/B1 _6089_/B1 VDD VDD VSS VSS gf180mcu_fd_sc_mcu7t5v0__dlyd_1
Xfanout276 _4324_/A1 _4786_/A1 VDD VDD VSS VSS gf180mcu_fd_sc_mcu7t5v0__dlyd_1
XFILLER_27_352 VDD VDD VSS VSS gf180mcu_fd_sc_mcu7t5v0__fill_2
XFILLER_55_661 VDD VDD VSS VSS gf180mcu_fd_sc_mcu7t5v0__fill_1
XTAP_TAPCELL_ROW_83_1426 VDD VSS gf180mcu_fd_sc_mcu7t5v0__filltie
XTAP_TAPCELL_ROW_83_1415 VDD VSS gf180mcu_fd_sc_mcu7t5v0__filltie
XFILLER_15_547 VDD VDD VSS VSS gf180mcu_fd_sc_mcu7t5v0__fillcap_8
XFILLER_7_702 VDD VDD VSS VSS gf180mcu_fd_sc_mcu7t5v0__fillcap_64
XTAP_TAPCELL_ROW_94_1577 VDD VSS gf180mcu_fd_sc_mcu7t5v0__filltie
XFILLER_2_462 VDD VDD VSS VSS gf180mcu_fd_sc_mcu7t5v0__fill_1
XFILLER_66_904 VDD VDD VSS VSS gf180mcu_fd_sc_mcu7t5v0__fillcap_32
XFILLER_19_842 VDD VDD VSS VSS gf180mcu_fd_sc_mcu7t5v0__fillcap_64
XFILLER_92_244 VDD VDD VSS VSS gf180mcu_fd_sc_mcu7t5v0__fill_1
XFILLER_81_907 VDD VDD VSS VSS gf180mcu_fd_sc_mcu7t5v0__fill_2
XFILLER_34_801 VDD VDD VSS VSS gf180mcu_fd_sc_mcu7t5v0__fillcap_4
XFILLER_74_981 VDD VDD VSS VSS gf180mcu_fd_sc_mcu7t5v0__fill_1
X_4830_ _4942_/A1 _4840_/A2 _4830_/B _7129_/D VDD VDD VSS VSS gf180mcu_fd_sc_mcu7t5v0__oai21_1
XTAP_TAPCELL_ROW_44_873 VDD VSS gf180mcu_fd_sc_mcu7t5v0__filltie
XTAP_TAPCELL_ROW_103_1695 VDD VSS gf180mcu_fd_sc_mcu7t5v0__filltie
X_4761_ _7095_/Q _4770_/A2 _4762_/B VDD VDD VSS VSS gf180mcu_fd_sc_mcu7t5v0__nand2_1
X_4692_ _4748_/A1 _4700_/A2 _4692_/B _7060_/D VDD VDD VSS VSS gf180mcu_fd_sc_mcu7t5v0__oai21_1
X_6500_ _6538_/A1 _6499_/Z _7675_/D VDD VDD VSS VSS gf180mcu_fd_sc_mcu7t5v0__nor2_1
X_7480_ _7480_/D _7490_/CLK _7480_/Q VDD VDD VSS VSS gf180mcu_fd_sc_mcu7t5v0__dffq_1
X_3712_ _6641_/A1 _4161_/A2 _3712_/Z VDD VDD VSS VSS gf180mcu_fd_sc_mcu7t5v0__xor2_1
X_6431_ _7664_/Q _7530_/Q _6438_/B VDD VDD VSS VSS gf180mcu_fd_sc_mcu7t5v0__nand2_1
X_3643_ _3640_/Z _3642_/Z _3643_/Z VDD VDD VSS VSS gf180mcu_fd_sc_mcu7t5v0__xor2_1
X_6362_ _6363_/A1 _3877_/Z _6362_/B _6363_/B1 VDD VDD VSS VSS gf180mcu_fd_sc_mcu7t5v0__oai21_1
X_3574_ _3574_/A1 _3570_/Z _3573_/Z _3574_/Z VDD VDD VSS VSS gf180mcu_fd_sc_mcu7t5v0__xor3_1
X_5313_ _5341_/I0 _7460_/Q _5316_/S _7460_/D VDD VDD VSS VSS gf180mcu_fd_sc_mcu7t5v0__mux2_2
X_6293_ _7532_/Q _6301_/B1 _6294_/B2 VDD VDD VSS VSS gf180mcu_fd_sc_mcu7t5v0__nand2_1
XTAP_TAPCELL_ROW_54_1016 VDD VSS gf180mcu_fd_sc_mcu7t5v0__filltie
XFILLER_103_839 VDD VDD VSS VSS gf180mcu_fd_sc_mcu7t5v0__fill_1
X_5244_ _5244_/I0 _7391_/Q _5246_/S _7391_/D VDD VDD VSS VSS gf180mcu_fd_sc_mcu7t5v0__mux2_2
X_5175_ wire517/Z _7322_/Q _5176_/S _7322_/D VDD VDD VSS VSS gf180mcu_fd_sc_mcu7t5v0__mux2_2
XFILLER_57_904 VDD VDD VSS VSS gf180mcu_fd_sc_mcu7t5v0__fillcap_4
X_4126_ _4126_/A1 _4132_/A1 _5022_/A2 VDD VDD VSS VSS gf180mcu_fd_sc_mcu7t5v0__nand2_1
XFILLER_96_594 VDD VDD VSS VSS gf180mcu_fd_sc_mcu7t5v0__fill_1
X_4057_ _6771_/Q _4714_/A2 _4058_/B VDD VDD VSS VSS gf180mcu_fd_sc_mcu7t5v0__nand2_1
X_7816_ _7816_/D _7827_/RN _7823_/CLK _7816_/Q VDD VDD VSS VSS gf180mcu_fd_sc_mcu7t5v0__dffrnq_1
XFILLER_51_152 VDD VDD VSS VSS gf180mcu_fd_sc_mcu7t5v0__fill_2
XTAP_TAPCELL_ROW_65_1167 VDD VSS gf180mcu_fd_sc_mcu7t5v0__filltie
X_7747_ _7747_/D _7755_/RN _7748_/CLK _7747_/Q VDD VDD VSS VSS gf180mcu_fd_sc_mcu7t5v0__dffrnq_1
X_4959_ _7194_/Q _4966_/A2 _4960_/B VDD VDD VSS VSS gf180mcu_fd_sc_mcu7t5v0__nand2_1
X_7678_ _7678_/D _7693_/RN _7693_/CLK _7678_/Q VDD VDD VSS VSS gf180mcu_fd_sc_mcu7t5v0__dffrnq_1
XTAP_TAPCELL_ROW_22_567 VDD VSS gf180mcu_fd_sc_mcu7t5v0__filltie
XFILLER_20_583 VDD VDD VSS VSS gf180mcu_fd_sc_mcu7t5v0__fillcap_8
X_6629_ _7726_/Q _6631_/A2 _6630_/B VDD VDD VSS VSS gf180mcu_fd_sc_mcu7t5v0__nand2_1
XPHY_EDGE_ROW_5_Left_124 VDD VSS gf180mcu_fd_sc_mcu7t5v0__endcap
XFILLER_102_872 VDD VDD VSS VSS gf180mcu_fd_sc_mcu7t5v0__fill_2
XFILLER_16_801 VDD VDD VSS VSS gf180mcu_fd_sc_mcu7t5v0__fillcap_4
XFILLER_28_661 VDD VDD VSS VSS gf180mcu_fd_sc_mcu7t5v0__fillcap_4
XFILLER_63_907 VDD VDD VSS VSS gf180mcu_fd_sc_mcu7t5v0__fill_2
XFILLER_90_737 VDD VDD VSS VSS gf180mcu_fd_sc_mcu7t5v0__fill_1
XTAP_TAPCELL_ROW_2_281 VDD VSS gf180mcu_fd_sc_mcu7t5v0__filltie
XTAP_TAPCELL_ROW_2_292 VDD VSS gf180mcu_fd_sc_mcu7t5v0__filltie
XFILLER_56_981 VDD VDD VSS VSS gf180mcu_fd_sc_mcu7t5v0__fill_1
XFILLER_43_642 VDD VDD VSS VSS gf180mcu_fd_sc_mcu7t5v0__fill_1
XFILLER_71_973 VDD VDD VSS VSS gf180mcu_fd_sc_mcu7t5v0__fillcap_4
XTAP_TAPCELL_ROW_41_832 VDD VSS gf180mcu_fd_sc_mcu7t5v0__filltie
XFILLER_42_174 VDD VDD VSS VSS gf180mcu_fd_sc_mcu7t5v0__fill_1
XFILLER_70_483 VDD VDD VSS VSS gf180mcu_fd_sc_mcu7t5v0__fill_2
XTAP_TAPCELL_ROW_96_1606 VDD VSS gf180mcu_fd_sc_mcu7t5v0__filltie
XFILLER_51_60 VDD VDD VSS VSS gf180mcu_fd_sc_mcu7t5v0__fill_2
Xwire496 _6195_/C _6227_/C VDD VDD VSS VSS gf180mcu_fd_sc_mcu7t5v0__clkbuf_4
XFILLER_98_804 VDD VDD VSS VSS gf180mcu_fd_sc_mcu7t5v0__fill_1
Xload_slew413 _6207_/A2 _6151_/C2 VDD VDD VSS VSS gf180mcu_fd_sc_mcu7t5v0__buf_2
Xload_slew402 _5776_/A2 _6198_/A2 VDD VDD VSS VSS gf180mcu_fd_sc_mcu7t5v0__buf_3
XFILLER_100_809 VDD VDD VSS VSS gf180mcu_fd_sc_mcu7t5v0__fill_1
Xload_slew435 _5599_/A2 _5597_/A2 VDD VDD VSS VSS gf180mcu_fd_sc_mcu7t5v0__buf_4
Xload_slew446 _6134_/C _6229_/C VDD VDD VSS VSS gf180mcu_fd_sc_mcu7t5v0__buf_4
Xload_slew468 _5514_/C _5609_/B VDD VDD VSS VSS gf180mcu_fd_sc_mcu7t5v0__buf_4
Xload_slew457 _6641_/A1 _5616_/S VDD VDD VSS VSS gf180mcu_fd_sc_mcu7t5v0__buf_4
XFILLER_78_594 VDD VDD VSS VSS gf180mcu_fd_sc_mcu7t5v0__fill_1
XTAP_TAPCELL_ROW_49_943 VDD VSS gf180mcu_fd_sc_mcu7t5v0__filltie
X_6980_ _6980_/D _7002_/CLK _6980_/Q VDD VDD VSS VSS gf180mcu_fd_sc_mcu7t5v0__dffq_1
XFILLER_65_266 VDD VDD VSS VSS gf180mcu_fd_sc_mcu7t5v0__fill_1
XFILLER_93_597 VDD VDD VSS VSS gf180mcu_fd_sc_mcu7t5v0__fill_2
X_5931_ _7263_/Q _6198_/A2 _6141_/A2 _7256_/Q _6221_/B _5932_/A2 VDD VDD VSS VSS gf180mcu_fd_sc_mcu7t5v0__oai221_1
XPHY_EDGE_ROW_69_Left_188 VDD VSS gf180mcu_fd_sc_mcu7t5v0__endcap
XTAP_TAPCELL_ROW_105_1735 VDD VSS gf180mcu_fd_sc_mcu7t5v0__filltie
XTAP_TAPCELL_ROW_105_1724 VDD VSS gf180mcu_fd_sc_mcu7t5v0__filltie
X_5862_ _7150_/Q wire341/Z _6241_/A2 _7129_/Q _5867_/A1 VDD VDD VSS VSS gf180mcu_fd_sc_mcu7t5v0__oai22_1
X_5793_ _6904_/Q _6162_/A2 _6162_/C _5795_/A1 VDD VDD VSS VSS gf180mcu_fd_sc_mcu7t5v0__oai21_1
X_7601_ _7601_/D _7601_/RN _7669_/CLK _7601_/Q VDD VDD VSS VSS gf180mcu_fd_sc_mcu7t5v0__dffrnq_1
X_4813_ _7121_/Q _4826_/A2 _4814_/B VDD VDD VSS VSS gf180mcu_fd_sc_mcu7t5v0__nand2_1
X_7532_ _7532_/D _7599_/RN _7669_/CLK _7532_/Q VDD VDD VSS VSS gf180mcu_fd_sc_mcu7t5v0__dffrnq_1
X_4744_ _4786_/A1 _4756_/A2 _4744_/B _7086_/D VDD VDD VSS VSS gf180mcu_fd_sc_mcu7t5v0__oai21_1
XFILLER_107_419 VDD VDD VSS VSS gf180mcu_fd_sc_mcu7t5v0__fill_1
X_4675_ _7052_/Q _4686_/A2 _4676_/B VDD VDD VSS VSS gf180mcu_fd_sc_mcu7t5v0__nand2_1
XPHY_EDGE_ROW_78_Left_197 VDD VSS gf180mcu_fd_sc_mcu7t5v0__endcap
X_7463_ _7463_/D _7822_/CLK _7463_/Q VDD VDD VSS VSS gf180mcu_fd_sc_mcu7t5v0__dffq_1
XTAP_TAPCELL_ROW_60_1097 VDD VSS gf180mcu_fd_sc_mcu7t5v0__filltie
X_6414_ _7661_/Q _6451_/A2 _6415_/B VDD VDD VSS VSS gf180mcu_fd_sc_mcu7t5v0__nand2_1
X_7394_ _7394_/D _7499_/CLK _7394_/Q VDD VDD VSS VSS gf180mcu_fd_sc_mcu7t5v0__dffq_1
X_3626_ input46/Z _3626_/A2 _3625_/Z _3626_/Z VDD VDD VSS VSS gf180mcu_fd_sc_mcu7t5v0__xor3_1
XTAP_TAPCELL_ROW_116_1886 VDD VSS gf180mcu_fd_sc_mcu7t5v0__filltie
XFILLER_89_815 VDD VDD VSS VSS gf180mcu_fd_sc_mcu7t5v0__fill_1
X_6345_ _7634_/Q input50/Z _6352_/S _7634_/D VDD VDD VSS VSS gf180mcu_fd_sc_mcu7t5v0__mux2_2
X_3557_ input83/Z input86/Z input98/Z _3557_/Z VDD VDD VSS VSS gf180mcu_fd_sc_mcu7t5v0__xor3_1
X_6276_ _6276_/A1 _6284_/A2 _6284_/B1 _6276_/B2 _7590_/D VDD VDD VSS VSS gf180mcu_fd_sc_mcu7t5v0__aoi22_1
XFILLER_103_669 VDD VDD VSS VSS gf180mcu_fd_sc_mcu7t5v0__fill_2
X_5227_ _5332_/I0 _7374_/Q _5232_/S _7374_/D VDD VDD VSS VSS gf180mcu_fd_sc_mcu7t5v0__mux2_2
X_3488_ _3488_/A1 _3488_/A2 _3488_/Z VDD VDD VSS VSS gf180mcu_fd_sc_mcu7t5v0__and2_1
X_5158_ _5228_/I0 _7305_/Q _5162_/S _7305_/D VDD VDD VSS VSS gf180mcu_fd_sc_mcu7t5v0__mux2_2
X_5089_ _7259_/Q _5092_/A2 _5090_/B VDD VDD VSS VSS gf180mcu_fd_sc_mcu7t5v0__nand2_1
X_4109_ _4112_/A1 _4938_/A2 _4109_/B _6787_/D VDD VDD VSS VSS gf180mcu_fd_sc_mcu7t5v0__oai21_1
XFILLER_38_981 VDD VDD VSS VSS gf180mcu_fd_sc_mcu7t5v0__fill_1
XTAP_TAPCELL_ROW_27_637 VDD VSS gf180mcu_fd_sc_mcu7t5v0__filltie
XFILLER_71_236 VDD VDD VSS VSS gf180mcu_fd_sc_mcu7t5v0__fill_2
XFILLER_40_667 VDD VDD VSS VSS gf180mcu_fd_sc_mcu7t5v0__fillcap_64
XTAP_TAPCELL_ROW_78_1347 VDD VSS gf180mcu_fd_sc_mcu7t5v0__filltie
XFILLER_106_463 VDD VDD VSS VSS gf180mcu_fd_sc_mcu7t5v0__fill_1
XTAP_TAPCELL_ROW_91_1536 VDD VSS gf180mcu_fd_sc_mcu7t5v0__filltie
XFILLER_79_347 VDD VDD VSS VSS gf180mcu_fd_sc_mcu7t5v0__fill_2
XFILLER_94_317 VDD VDD VSS VSS gf180mcu_fd_sc_mcu7t5v0__fill_2
XTAP_TAPCELL_ROW_7_362 VDD VSS gf180mcu_fd_sc_mcu7t5v0__filltie
XTAP_TAPCELL_ROW_7_351 VDD VSS gf180mcu_fd_sc_mcu7t5v0__filltie
XFILLER_88_892 VDD VDD VSS VSS gf180mcu_fd_sc_mcu7t5v0__fillcap_4
XFILLER_48_756 VDD VDD VSS VSS gf180mcu_fd_sc_mcu7t5v0__fill_2
XTAP_TAPCELL_ROW_89_1498 VDD VSS gf180mcu_fd_sc_mcu7t5v0__filltie
XFILLER_75_575 VDD VDD VSS VSS gf180mcu_fd_sc_mcu7t5v0__fillcap_8
XTAP_TAPCELL_ROW_46_902 VDD VSS gf180mcu_fd_sc_mcu7t5v0__filltie
XFILLER_47_277 VDD VDD VSS VSS gf180mcu_fd_sc_mcu7t5v0__fill_2
XFILLER_62_247 VDD VDD VSS VSS gf180mcu_fd_sc_mcu7t5v0__fill_2
XFILLER_43_494 VDD VDD VSS VSS gf180mcu_fd_sc_mcu7t5v0__fill_1
XTAP_TAPCELL_ROW_100_1665 VDD VSS gf180mcu_fd_sc_mcu7t5v0__filltie
XTAP_TAPCELL_ROW_100_1654 VDD VSS gf180mcu_fd_sc_mcu7t5v0__filltie
XFILLER_30_166 VDD VDD VSS VSS gf180mcu_fd_sc_mcu7t5v0__fill_1
XFILLER_30_177 VDD VDD VSS VSS gf180mcu_fd_sc_mcu7t5v0__fill_2
X_4460_ _4460_/A1 _4462_/A2 _4460_/B _6944_/D VDD VDD VSS VSS gf180mcu_fd_sc_mcu7t5v0__oai21_1
X_4391_ _6910_/Q _4392_/A2 _4392_/B VDD VDD VSS VSS gf180mcu_fd_sc_mcu7t5v0__nand2_1
X_3411_ _7632_/Q _6343_/A1 VDD VDD VSS VSS gf180mcu_fd_sc_mcu7t5v0__clkinv_1
XFILLER_113_912 VDD VDD VSS VSS gf180mcu_fd_sc_mcu7t5v0__fillcap_64
X_6130_ _6130_/A1 _6300_/A2 _6300_/B1 _6129_/Z _7577_/D VDD VDD VSS VSS gf180mcu_fd_sc_mcu7t5v0__aoi22_1
XFILLER_30_2 VDD VDD VSS VSS gf180mcu_fd_sc_mcu7t5v0__fill_2
X_6061_ _6184_/C _6061_/A2 _6061_/B _6246_/C _6067_/A2 VDD VDD VSS VSS gf180mcu_fd_sc_mcu7t5v0__oai211_1
X_5012_ _5012_/A1 _5022_/A2 _5012_/B _7220_/D VDD VDD VSS VSS gf180mcu_fd_sc_mcu7t5v0__oai21_1
Xload_slew287 _5078_/A1 _5008_/A1 VDD VDD VSS VSS gf180mcu_fd_sc_mcu7t5v0__buf_4
XFILLER_38_244 VDD VDD VSS VSS gf180mcu_fd_sc_mcu7t5v0__fill_1
X_6963_ _6963_/D _7668_/CLK _6963_/Q VDD VDD VSS VSS gf180mcu_fd_sc_mcu7t5v0__dffq_1
X_6894_ _6894_/D _7148_/CLK _6894_/Q VDD VDD VSS VSS gf180mcu_fd_sc_mcu7t5v0__dffq_1
X_5914_ _5914_/A1 _5914_/A2 _6196_/B _5936_/A2 VDD VDD VSS VSS gf180mcu_fd_sc_mcu7t5v0__oai21_1
XFILLER_81_567 VDD VDD VSS VSS gf180mcu_fd_sc_mcu7t5v0__fillcap_4
X_5845_ _5845_/A1 _5845_/A2 _5847_/A1 VDD VDD VSS VSS gf180mcu_fd_sc_mcu7t5v0__nor2_1
XTAP_TAPCELL_ROW_62_1126 VDD VSS gf180mcu_fd_sc_mcu7t5v0__filltie
XFILLER_10_807 VDD VDD VSS VSS gf180mcu_fd_sc_mcu7t5v0__fillcap_64
XFILLER_21_144 VDD VDD VSS VSS gf180mcu_fd_sc_mcu7t5v0__fill_1
XFILLER_22_667 VDD VDD VSS VSS gf180mcu_fd_sc_mcu7t5v0__fillcap_64
XTAP_TAPCELL_ROW_118_1904 VDD VSS gf180mcu_fd_sc_mcu7t5v0__filltie
XPHY_EDGE_ROW_86_Left_205 VDD VSS gf180mcu_fd_sc_mcu7t5v0__endcap
X_5776_ _6876_/Q _5776_/A2 _6076_/A2 _6869_/Q _6855_/Q wire322/I _5777_/A2 VDD VDD
+ VSS VSS gf180mcu_fd_sc_mcu7t5v0__oai222_1
XTAP_TAPCELL_ROW_118_1926 VDD VSS gf180mcu_fd_sc_mcu7t5v0__filltie
XTAP_TAPCELL_ROW_118_1915 VDD VSS gf180mcu_fd_sc_mcu7t5v0__filltie
X_4727_ _7078_/Q _4728_/A2 _4728_/B VDD VDD VSS VSS gf180mcu_fd_sc_mcu7t5v0__nand2_1
X_7515_ _7515_/D _7652_/RN _7765_/CLK _7515_/Q VDD VDD VSS VSS gf180mcu_fd_sc_mcu7t5v0__dffsnq_1
X_4658_ wire291/Z _4658_/A2 _4658_/B _7043_/D VDD VDD VSS VSS gf180mcu_fd_sc_mcu7t5v0__oai21_1
X_7446_ _7446_/D _7451_/CLK _7446_/Q VDD VDD VSS VSS gf180mcu_fd_sc_mcu7t5v0__dffq_1
Xinput90 tl_i[84] input90/Z VDD VDD VSS VSS gf180mcu_fd_sc_mcu7t5v0__dlyd_1
X_3609_ _3535_/Z _3537_/Z _3608_/Z _3609_/Z VDD VDD VSS VSS gf180mcu_fd_sc_mcu7t5v0__xor3_1
XFILLER_104_912 VDD VDD VSS VSS gf180mcu_fd_sc_mcu7t5v0__fillcap_32
XFILLER_89_612 VDD VDD VSS VSS gf180mcu_fd_sc_mcu7t5v0__fill_2
X_4589_ _7009_/Q _4602_/A2 _4590_/B VDD VDD VSS VSS gf180mcu_fd_sc_mcu7t5v0__nand2_1
XFILLER_1_516 VDD VDD VSS VSS gf180mcu_fd_sc_mcu7t5v0__fillcap_32
X_7377_ _7377_/D _7472_/CLK _7377_/Q VDD VDD VSS VSS gf180mcu_fd_sc_mcu7t5v0__dffq_1
XFILLER_103_411 VDD VDD VSS VSS gf180mcu_fd_sc_mcu7t5v0__fill_1
X_6328_ _7622_/Q input37/Z _6331_/S _7622_/D VDD VDD VSS VSS gf180mcu_fd_sc_mcu7t5v0__mux2_2
XPHY_EDGE_ROW_95_Left_214 VDD VSS gf180mcu_fd_sc_mcu7t5v0__endcap
X_6259_ _6259_/A1 _6300_/A2 _6302_/B1 _6259_/B2 _7582_/D VDD VDD VSS VSS gf180mcu_fd_sc_mcu7t5v0__aoi22_1
XTAP_TAPCELL_ROW_73_1277 VDD VSS gf180mcu_fd_sc_mcu7t5v0__filltie
XTAP_TAPCELL_ROW_4_310 VDD VSS gf180mcu_fd_sc_mcu7t5v0__filltie
XTAP_TAPCELL_ROW_4_321 VDD VSS gf180mcu_fd_sc_mcu7t5v0__filltie
XFILLER_57_553 VDD VDD VSS VSS gf180mcu_fd_sc_mcu7t5v0__fill_2
XFILLER_45_748 VDD VDD VSS VSS gf180mcu_fd_sc_mcu7t5v0__fill_1
XFILLER_72_567 VDD VDD VSS VSS gf180mcu_fd_sc_mcu7t5v0__fillcap_4
XPHY_EDGE_ROW_11_Right_11 VDD VSS gf180mcu_fd_sc_mcu7t5v0__endcap
XFILLER_25_472 VDD VDD VSS VSS gf180mcu_fd_sc_mcu7t5v0__fill_2
XFILLER_41_976 VDD VDD VSS VSS gf180mcu_fd_sc_mcu7t5v0__fillcap_4
XTAP_TAPCELL_ROW_51_971 VDD VSS gf180mcu_fd_sc_mcu7t5v0__filltie
XFILLER_4_332 VDD VDD VSS VSS gf180mcu_fd_sc_mcu7t5v0__fill_2
XFILLER_107_772 VDD VDD VSS VSS gf180mcu_fd_sc_mcu7t5v0__fillcap_8
XFILLER_107_794 VDD VDD VSS VSS gf180mcu_fd_sc_mcu7t5v0__fillcap_4
XFILLER_4_387 VDD VDD VSS VSS gf180mcu_fd_sc_mcu7t5v0__fill_2
XPHY_EDGE_ROW_20_Right_20 VDD VSS gf180mcu_fd_sc_mcu7t5v0__endcap
XFILLER_68_807 VDD VDD VSS VSS gf180mcu_fd_sc_mcu7t5v0__fill_2
XFILLER_76_873 VDD VDD VSS VSS gf180mcu_fd_sc_mcu7t5v0__fill_2
XFILLER_36_737 VDD VDD VSS VSS gf180mcu_fd_sc_mcu7t5v0__fillcap_64
XFILLER_48_586 VDD VDD VSS VSS gf180mcu_fd_sc_mcu7t5v0__fill_1
XFILLER_48_597 VDD VDD VSS VSS gf180mcu_fd_sc_mcu7t5v0__fill_2
XFILLER_91_854 VDD VDD VSS VSS gf180mcu_fd_sc_mcu7t5v0__fill_1
X_3960_ _6742_/Q _4308_/A2 _3961_/B VDD VDD VSS VSS gf180mcu_fd_sc_mcu7t5v0__nand2_1
XFILLER_35_258 VDD VDD VSS VSS gf180mcu_fd_sc_mcu7t5v0__fill_1
XFILLER_63_578 VDD VDD VSS VSS gf180mcu_fd_sc_mcu7t5v0__fill_2
XFILLER_50_228 VDD VDD VSS VSS gf180mcu_fd_sc_mcu7t5v0__fill_1
X_3891_ _7541_/Q _6365_/A2 _3891_/B _3892_/B1 VDD VDD VSS VSS gf180mcu_fd_sc_mcu7t5v0__oai21_1
X_5630_ _5630_/A1 _6303_/S _5630_/B _7516_/D VDD VDD VSS VSS gf180mcu_fd_sc_mcu7t5v0__oai21_1
X_5561_ _7302_/Q _5579_/A2 _5612_/B1 _7505_/Q _5563_/A2 VDD VDD VSS VSS gf180mcu_fd_sc_mcu7t5v0__oai22_1
X_4512_ _4540_/A1 _4518_/A2 _4512_/B _6970_/D VDD VDD VSS VSS gf180mcu_fd_sc_mcu7t5v0__oai21_1
X_7300_ _7300_/D _7505_/CLK _7300_/Q VDD VDD VSS VSS gf180mcu_fd_sc_mcu7t5v0__dffq_1
X_5492_ _7730_/Q _5492_/A2 _5492_/A3 _5492_/B1 _5492_/B2 _5493_/I1 VDD VDD VSS VSS
+ gf180mcu_fd_sc_mcu7t5v0__oai32_1
X_7231_ _7231_/D _7252_/CLK _7231_/Q VDD VDD VSS VSS gf180mcu_fd_sc_mcu7t5v0__dffq_1
XTAP_TAPCELL_ROW_113_1834 VDD VSS gf180mcu_fd_sc_mcu7t5v0__filltie
X_4443_ _6936_/Q _4448_/A2 _4444_/B VDD VDD VSS VSS gf180mcu_fd_sc_mcu7t5v0__nand2_1
XTAP_TAPCELL_ROW_113_1845 VDD VSS gf180mcu_fd_sc_mcu7t5v0__filltie
X_4374_ _5102_/A1 _4378_/A2 _4374_/B _6901_/D VDD VDD VSS VSS gf180mcu_fd_sc_mcu7t5v0__oai21_1
X_7162_ _7162_/D _7233_/CLK _7162_/Q VDD VDD VSS VSS gf180mcu_fd_sc_mcu7t5v0__dffq_1
XFILLER_101_904 VDD VDD VSS VSS gf180mcu_fd_sc_mcu7t5v0__fillcap_4
XFILLER_99_976 VDD VDD VSS VSS gf180mcu_fd_sc_mcu7t5v0__fillcap_4
X_6113_ _7098_/Q _6214_/A2 _6174_/A2 _7091_/Q _7077_/Q _6175_/A2 _6114_/A2 VDD VDD
+ VSS VSS gf180mcu_fd_sc_mcu7t5v0__oai222_1
X_7093_ _7093_/D _7217_/CLK _7093_/Q VDD VDD VSS VSS gf180mcu_fd_sc_mcu7t5v0__dffq_1
X_6044_ _6971_/Q _6073_/A2 _6092_/A2 _6950_/Q _6162_/C _6045_/A2 VDD VDD VSS VSS gf180mcu_fd_sc_mcu7t5v0__oai221_1
XFILLER_86_659 VDD VDD VSS VSS gf180mcu_fd_sc_mcu7t5v0__fill_1
XFILLER_54_523 VDD VDD VSS VSS gf180mcu_fd_sc_mcu7t5v0__fill_2
X_6946_ _6946_/D _7003_/CLK _6946_/Q VDD VDD VSS VSS gf180mcu_fd_sc_mcu7t5v0__dffq_1
XTAP_TAPCELL_ROW_37_776 VDD VSS gf180mcu_fd_sc_mcu7t5v0__filltie
XFILLER_54_589 VDD VDD VSS VSS gf180mcu_fd_sc_mcu7t5v0__fillcap_4
X_6877_ _6877_/D _6915_/CLK _6877_/Q VDD VDD VSS VSS gf180mcu_fd_sc_mcu7t5v0__dffq_1
XFILLER_23_976 VDD VDD VSS VSS gf180mcu_fd_sc_mcu7t5v0__fillcap_4
X_5828_ _7269_/Q wire322/Z _6197_/B _5830_/A1 VDD VDD VSS VSS gf180mcu_fd_sc_mcu7t5v0__oai21_1
X_5759_ _7051_/Q _6154_/A2 _6227_/C _5761_/A1 VDD VDD VSS VSS gf180mcu_fd_sc_mcu7t5v0__oai21_1
XTAP_TAPCELL_ROW_75_1306 VDD VSS gf180mcu_fd_sc_mcu7t5v0__filltie
X_7429_ _7429_/D _7736_/CLK _7429_/Q VDD VDD VSS VSS gf180mcu_fd_sc_mcu7t5v0__dffq_1
XFILLER_100_981 VDD VDD VSS VSS gf180mcu_fd_sc_mcu7t5v0__fill_1
XFILLER_18_737 VDD VDD VSS VSS gf180mcu_fd_sc_mcu7t5v0__fillcap_64
XTAP_TAPCELL_ROW_86_1468 VDD VSS gf180mcu_fd_sc_mcu7t5v0__filltie
XTAP_TAPCELL_ROW_86_1457 VDD VSS gf180mcu_fd_sc_mcu7t5v0__filltie
XFILLER_5_696 VDD VDD VSS VSS gf180mcu_fd_sc_mcu7t5v0__fillcap_4
XFILLER_110_734 VDD VDD VSS VSS gf180mcu_fd_sc_mcu7t5v0__fill_1
XFILLER_110_767 VDD VDD VSS VSS gf180mcu_fd_sc_mcu7t5v0__fillcap_32
XFILLER_96_979 VDD VDD VSS VSS gf180mcu_fd_sc_mcu7t5v0__fill_2
X_4090_ _6781_/Q _4854_/A2 _4091_/B VDD VDD VSS VSS gf180mcu_fd_sc_mcu7t5v0__nand2_1
XFILLER_83_629 VDD VDD VSS VSS gf180mcu_fd_sc_mcu7t5v0__fill_1
XFILLER_82_117 VDD VDD VSS VSS gf180mcu_fd_sc_mcu7t5v0__fill_1
X_6800_ _6800_/D _7279_/CLK _6800_/Q VDD VDD VSS VSS gf180mcu_fd_sc_mcu7t5v0__dffq_1
X_7780_ _7780_/D _7780_/RN _7780_/CLK _7780_/Q VDD VDD VSS VSS gf180mcu_fd_sc_mcu7t5v0__dffrnq_1
X_4992_ _5006_/A1 _4994_/A2 _4992_/B _7210_/D VDD VDD VSS VSS gf180mcu_fd_sc_mcu7t5v0__oai21_1
XTAP_TAPCELL_ROW_34_735 VDD VSS gf180mcu_fd_sc_mcu7t5v0__filltie
X_6731_ _7763_/Q _6731_/A2 _6731_/Z VDD VDD VSS VSS gf180mcu_fd_sc_mcu7t5v0__xor2_1
X_3943_ _7719_/Q _3962_/A2 _7721_/Q _4120_/A1 VDD VDD VSS VSS gf180mcu_fd_sc_mcu7t5v0__nor3_4
X_6662_ _6574_/S _7738_/Q _6663_/A2 VDD VDD VSS VSS gf180mcu_fd_sc_mcu7t5v0__xnor2_1
X_3874_ _4112_/A1 _3874_/A2 _3877_/A2 VDD VDD VSS VSS gf180mcu_fd_sc_mcu7t5v0__nand2_1
X_5613_ _6803_/Q _5613_/A2 _5613_/B1 _6832_/Q _5614_/A3 VDD VDD VSS VSS gf180mcu_fd_sc_mcu7t5v0__oai22_1
XFILLER_20_979 VDD VDD VSS VSS gf180mcu_fd_sc_mcu7t5v0__fill_2
X_6593_ _6134_/C _6593_/A2 _6594_/A2 VDD VDD VSS VSS gf180mcu_fd_sc_mcu7t5v0__nand2_1
XFILLER_117_333 VDD VDD VSS VSS gf180mcu_fd_sc_mcu7t5v0__fill_1
X_5544_ _7448_/Q _5544_/A2 _5599_/B _5546_/A1 VDD VDD VSS VSS gf180mcu_fd_sc_mcu7t5v0__oai21_1
X_5475_ _5475_/A1 _5475_/A2 _5479_/A2 VDD VDD VSS VSS gf180mcu_fd_sc_mcu7t5v0__nor2_1
X_4426_ _5056_/A1 _4434_/A2 _4426_/B _6927_/D VDD VDD VSS VSS gf180mcu_fd_sc_mcu7t5v0__oai21_1
X_7214_ _7214_/D _7216_/CLK _7214_/Q VDD VDD VSS VSS gf180mcu_fd_sc_mcu7t5v0__dffq_1
XTAP_TAPCELL_ROW_57_1058 VDD VSS gf180mcu_fd_sc_mcu7t5v0__filltie
X_7145_ _7145_/D _7266_/CLK _7145_/Q VDD VDD VSS VSS gf180mcu_fd_sc_mcu7t5v0__dffq_1
Xfanout414 wire416/Z _6225_/A2 VDD VDD VSS VSS gf180mcu_fd_sc_mcu7t5v0__dlyd_1
Xfanout403 wire416/I _6242_/A2 VDD VDD VSS VSS gf180mcu_fd_sc_mcu7t5v0__dlyd_1
X_4357_ _6893_/Q _4364_/A2 _4358_/B VDD VDD VSS VSS gf180mcu_fd_sc_mcu7t5v0__nand2_1
XFILLER_101_712 VDD VDD VSS VSS gf180mcu_fd_sc_mcu7t5v0__fillcap_4
XFILLER_58_103 VDD VDD VSS VSS gf180mcu_fd_sc_mcu7t5v0__fill_2
XTAP_TAPCELL_ROW_70_1236 VDD VSS gf180mcu_fd_sc_mcu7t5v0__filltie
XFILLER_87_968 VDD VDD VSS VSS gf180mcu_fd_sc_mcu7t5v0__fillcap_8
X_7076_ _7076_/D _7097_/CLK _7076_/Q VDD VDD VSS VSS gf180mcu_fd_sc_mcu7t5v0__dffq_1
X_4288_ _4946_/A1 _4294_/A2 _4288_/B _6858_/D VDD VDD VSS VSS gf180mcu_fd_sc_mcu7t5v0__oai21_1
Xfanout458 _7729_/Q _6637_/A1 VDD VDD VSS VSS gf180mcu_fd_sc_mcu7t5v0__dlyd_1
X_6027_ _7097_/Q _6214_/A2 _6112_/A2 _7083_/Q _6029_/A1 VDD VDD VSS VSS gf180mcu_fd_sc_mcu7t5v0__oai22_1
X_6929_ _6929_/D _6944_/CLK _6929_/Q VDD VDD VSS VSS gf180mcu_fd_sc_mcu7t5v0__dffq_1
XFILLER_70_868 VDD VDD VSS VSS gf180mcu_fd_sc_mcu7t5v0__fill_1
XTAP_TAPCELL_ROW_81_1398 VDD VSS gf180mcu_fd_sc_mcu7t5v0__filltie
XTAP_TAPCELL_ROW_81_1387 VDD VSS gf180mcu_fd_sc_mcu7t5v0__filltie
XTAP_TAPCELL_ROW_12_429 VDD VSS gf180mcu_fd_sc_mcu7t5v0__filltie
XFILLER_7_906 VDD VDD VSS VSS gf180mcu_fd_sc_mcu7t5v0__fillcap_4
XFILLER_109_856 VDD VDD VSS VSS gf180mcu_fd_sc_mcu7t5v0__fillcap_32
XFILLER_78_979 VDD VDD VSS VSS gf180mcu_fd_sc_mcu7t5v0__fill_2
XFILLER_38_61 VDD VDD VSS VSS gf180mcu_fd_sc_mcu7t5v0__fill_1
XFILLER_33_504 VDD VDD VSS VSS gf180mcu_fd_sc_mcu7t5v0__fill_1
XFILLER_13_250 VDD VDD VSS VSS gf180mcu_fd_sc_mcu7t5v0__fill_1
XTAP_TAPCELL_ROW_99_1648 VDD VSS gf180mcu_fd_sc_mcu7t5v0__filltie
Xclkload35 _7693_/CLK clkload35/ZN VDD VDD VSS VSS gf180mcu_fd_sc_mcu7t5v0__inv_2
Xclkload24 _7456_/CLK clkload24/Z VDD VDD VSS VSS gf180mcu_fd_sc_mcu7t5v0__clkbuf_4
Xclkload13 _7790_/CLK clkload13/Z VDD VDD VSS VSS gf180mcu_fd_sc_mcu7t5v0__clkbuf_8
X_3590_ input45/Z input54/Z _3589_/Z _3590_/Z VDD VDD VSS VSS gf180mcu_fd_sc_mcu7t5v0__xor3_1
Xclkload46 _7667_/CLK clkload46/Z VDD VDD VSS VSS gf180mcu_fd_sc_mcu7t5v0__clkbuf_2
Xclkload68 _7724_/CLK clkload68/Z VDD VDD VSS VSS gf180mcu_fd_sc_mcu7t5v0__clkbuf_4
Xclkload57 _7453_/CLK clkload57/Z VDD VDD VSS VSS gf180mcu_fd_sc_mcu7t5v0__clkbuf_2
Xclkload79 _7064_/CLK clkload79/Z VDD VDD VSS VSS gf180mcu_fd_sc_mcu7t5v0__clkbuf_2
XFILLER_5_460 VDD VDD VSS VSS gf180mcu_fd_sc_mcu7t5v0__fill_1
X_5260_ _5309_/I0 _7407_/Q _5260_/S _7407_/D VDD VDD VSS VSS gf180mcu_fd_sc_mcu7t5v0__mux2_2
XTAP_TAPCELL_ROW_110_1804 VDD VSS gf180mcu_fd_sc_mcu7t5v0__filltie
X_4211_ _4223_/I0 _6821_/Q _5274_/S _6821_/D VDD VDD VSS VSS gf180mcu_fd_sc_mcu7t5v0__mux2_2
Xclkbuf_leaf_64_clk_i clkload3/I _7247_/CLK VDD VDD VSS VSS gf180mcu_fd_sc_mcu7t5v0__clkbuf_8
X_5191_ _6353_/I0 _7338_/Q _5197_/S _7338_/D VDD VDD VSS VSS gf180mcu_fd_sc_mcu7t5v0__mux2_2
X_4142_ _6798_/Q _5092_/A2 _4143_/B VDD VDD VSS VSS gf180mcu_fd_sc_mcu7t5v0__nand2_1
XFILLER_69_979 VDD VDD VSS VSS gf180mcu_fd_sc_mcu7t5v0__fill_1
XTAP_TAPCELL_ROW_39_805 VDD VSS gf180mcu_fd_sc_mcu7t5v0__filltie
XFILLER_68_489 VDD VDD VSS VSS gf180mcu_fd_sc_mcu7t5v0__fill_1
X_4073_ _6776_/Q _4784_/A2 _4074_/B VDD VDD VSS VSS gf180mcu_fd_sc_mcu7t5v0__nand2_1
Xclkbuf_leaf_79_clk_i clkbuf_3_1__f_clk_i/Z _7418_/CLK VDD VDD VSS VSS gf180mcu_fd_sc_mcu7t5v0__clkbuf_8
XPHY_EDGE_ROW_50_Left_169 VDD VSS gf180mcu_fd_sc_mcu7t5v0__endcap
XFILLER_55_139 VDD VDD VSS VSS gf180mcu_fd_sc_mcu7t5v0__fill_1
XTAP_TAPCELL_ROW_108_1766 VDD VSS gf180mcu_fd_sc_mcu7t5v0__filltie
XFILLER_52_802 VDD VDD VSS VSS gf180mcu_fd_sc_mcu7t5v0__fill_2
XTAP_TAPCELL_ROW_108_1777 VDD VSS gf180mcu_fd_sc_mcu7t5v0__filltie
XFILLER_63_150 VDD VDD VSS VSS gf180mcu_fd_sc_mcu7t5v0__fill_1
X_7763_ _7763_/D _7810_/RN clkload8/I _7763_/Q VDD VDD VSS VSS gf180mcu_fd_sc_mcu7t5v0__dffrnq_1
X_4975_ _7202_/Q _4980_/A2 _4976_/B VDD VDD VSS VSS gf180mcu_fd_sc_mcu7t5v0__nand2_1
X_6714_ _7755_/Q _6716_/A2 _6714_/B1 _7756_/Q _6715_/I VDD VDD VSS VSS gf180mcu_fd_sc_mcu7t5v0__aoi22_1
X_3926_ _7796_/D _5746_/A2 _3926_/A3 _5746_/A4 _3927_/A2 VDD VDD VSS VSS gf180mcu_fd_sc_mcu7t5v0__nor4_1
X_7694_ _7694_/D _7694_/RN _7711_/CLK _7694_/Q VDD VDD VSS VSS gf180mcu_fd_sc_mcu7t5v0__dffrnq_1
Xclkload7 clkload7/I clkload7/Z VDD VDD VSS VSS gf180mcu_fd_sc_mcu7t5v0__clkbuf_2
X_6645_ _6654_/B _6644_/Z _7731_/D VDD VDD VSS VSS gf180mcu_fd_sc_mcu7t5v0__nor2_1
X_3857_ _4336_/A1 _4940_/A1 _4942_/A1 _3871_/A1 VDD VDD VSS VSS gf180mcu_fd_sc_mcu7t5v0__nand3_1
Xclkbuf_leaf_17_clk_i clkload1/I _7703_/CLK VDD VDD VSS VSS gf180mcu_fd_sc_mcu7t5v0__clkbuf_8
X_6576_ _7711_/Q _7710_/Q _6576_/S _7711_/D VDD VDD VSS VSS gf180mcu_fd_sc_mcu7t5v0__mux2_2
X_3788_ _7741_/Q _3787_/Z _6670_/A2 VDD VDD VSS VSS gf180mcu_fd_sc_mcu7t5v0__nand2_1
X_5527_ _7512_/Q _6733_/A4 _5557_/A1 VDD VDD VSS VSS gf180mcu_fd_sc_mcu7t5v0__nand2_1
X_5458_ _5614_/B _5458_/A2 _5458_/A3 _5458_/B1 _5458_/B2 _5461_/I1 VDD VDD VSS VSS
+ gf180mcu_fd_sc_mcu7t5v0__oai32_1
X_4409_ _6919_/Q _4420_/A2 _4410_/B VDD VDD VSS VSS gf180mcu_fd_sc_mcu7t5v0__nand2_1
Xfanout200 _5883_/ZN _6302_/B1 VDD VDD VSS VSS gf180mcu_fd_sc_mcu7t5v0__dlyd_1
X_5389_ _7345_/Q _5593_/A2 wire420/Z _7331_/Q _5391_/A2 VDD VDD VSS VSS gf180mcu_fd_sc_mcu7t5v0__oai22_1
XFILLER_87_743 VDD VDD VSS VSS gf180mcu_fd_sc_mcu7t5v0__fill_1
X_7128_ _7128_/D _7233_/CLK _7128_/Q VDD VDD VSS VSS gf180mcu_fd_sc_mcu7t5v0__dffq_1
X_7059_ _7059_/D _7064_/CLK _7059_/Q VDD VDD VSS VSS gf180mcu_fd_sc_mcu7t5v0__dffq_1
Xfanout288 wire292/I _5134_/A1 VDD VDD VSS VSS gf180mcu_fd_sc_mcu7t5v0__dlyd_1
Xfanout277 wire283/I _4940_/A1 VDD VDD VSS VSS gf180mcu_fd_sc_mcu7t5v0__dlyd_1
XFILLER_90_919 VDD VDD VSS VSS gf180mcu_fd_sc_mcu7t5v0__fillcap_16
XFILLER_90_908 VDD VDD VSS VSS gf180mcu_fd_sc_mcu7t5v0__fill_2
XTAP_TAPCELL_ROW_83_1427 VDD VSS gf180mcu_fd_sc_mcu7t5v0__filltie
XTAP_TAPCELL_ROW_83_1416 VDD VSS gf180mcu_fd_sc_mcu7t5v0__filltie
XFILLER_15_559 VDD VDD VSS VSS gf180mcu_fd_sc_mcu7t5v0__fill_1
XFILLER_30_507 VDD VDD VSS VSS gf180mcu_fd_sc_mcu7t5v0__fill_2
XFILLER_112_807 VDD VDD VSS VSS gf180mcu_fd_sc_mcu7t5v0__fillcap_64
XTAP_TAPCELL_ROW_94_1578 VDD VSS gf180mcu_fd_sc_mcu7t5v0__filltie
XFILLER_78_798 VDD VDD VSS VSS gf180mcu_fd_sc_mcu7t5v0__fill_1
XFILLER_61_632 VDD VDD VSS VSS gf180mcu_fd_sc_mcu7t5v0__fill_2
XTAP_TAPCELL_ROW_44_874 VDD VSS gf180mcu_fd_sc_mcu7t5v0__filltie
XTAP_TAPCELL_ROW_103_1696 VDD VSS gf180mcu_fd_sc_mcu7t5v0__filltie
X_4760_ wire268/Z _4770_/A2 _4760_/B _7094_/D VDD VDD VSS VSS gf180mcu_fd_sc_mcu7t5v0__oai21_1
XFILLER_14_592 VDD VDD VSS VSS gf180mcu_fd_sc_mcu7t5v0__fill_2
XPHY_EDGE_ROW_112_Right_112 VDD VSS gf180mcu_fd_sc_mcu7t5v0__endcap
X_4691_ _7060_/Q _4700_/A2 _4692_/B VDD VDD VSS VSS gf180mcu_fd_sc_mcu7t5v0__nand2_1
X_3711_ _7791_/Q _6693_/A1 _7792_/D VDD VDD VSS VSS gf180mcu_fd_sc_mcu7t5v0__and2_1
X_6430_ _6438_/A1 _6438_/A2 _6438_/C _6434_/A1 VDD VDD VSS VSS gf180mcu_fd_sc_mcu7t5v0__oai21_1
X_3642_ input20/Z _3616_/Z _3641_/Z _3642_/Z VDD VDD VSS VSS gf180mcu_fd_sc_mcu7t5v0__xor3_1
X_6361_ _7540_/Q _6361_/A2 _6363_/A2 VDD VDD VSS VSS gf180mcu_fd_sc_mcu7t5v0__nand2_1
XFILLER_60_2 VDD VDD VSS VSS gf180mcu_fd_sc_mcu7t5v0__fill_2
X_3573_ _3543_/Z _3611_/A1 _3572_/Z _3573_/Z VDD VDD VSS VSS gf180mcu_fd_sc_mcu7t5v0__xor3_1
X_5312_ _5347_/I0 _7459_/Q _5316_/S _7459_/D VDD VDD VSS VSS gf180mcu_fd_sc_mcu7t5v0__mux2_2
XPHY_EDGE_ROW_49_Right_49 VDD VSS gf180mcu_fd_sc_mcu7t5v0__endcap
XFILLER_114_133 VDD VDD VSS VSS gf180mcu_fd_sc_mcu7t5v0__fill_2
X_6292_ _6292_/A1 _6298_/A2 _6300_/B1 _6292_/B2 _7598_/D VDD VDD VSS VSS gf180mcu_fd_sc_mcu7t5v0__aoi22_1
XTAP_TAPCELL_ROW_54_1017 VDD VSS gf180mcu_fd_sc_mcu7t5v0__filltie
X_5243_ _5243_/I0 _7390_/Q _5246_/S _7390_/D VDD VDD VSS VSS gf180mcu_fd_sc_mcu7t5v0__mux2_2
X_5174_ wire521/Z _7321_/Q _5176_/S _7321_/D VDD VDD VSS VSS gf180mcu_fd_sc_mcu7t5v0__mux2_2
XFILLER_96_573 VDD VDD VSS VSS gf180mcu_fd_sc_mcu7t5v0__fill_1
X_4125_ _4125_/A1 _5008_/A2 _4125_/B _6792_/D VDD VDD VSS VSS gf180mcu_fd_sc_mcu7t5v0__oai21_1
XFILLER_68_297 VDD VDD VSS VSS gf180mcu_fd_sc_mcu7t5v0__fill_2
X_4056_ _4144_/A1 _4123_/A1 _4714_/A2 VDD VDD VSS VSS gf180mcu_fd_sc_mcu7t5v0__nand2_1
XPHY_EDGE_ROW_58_Right_58 VDD VSS gf180mcu_fd_sc_mcu7t5v0__endcap
X_7815_ _7815_/D _7822_/RN clkload7/I _7817_/D VDD VDD VSS VSS gf180mcu_fd_sc_mcu7t5v0__dffsnq_1
XTAP_TAPCELL_ROW_65_1168 VDD VSS gf180mcu_fd_sc_mcu7t5v0__filltie
X_7746_ _7746_/D _7791_/RN _7792_/CLK _7746_/Q VDD VDD VSS VSS gf180mcu_fd_sc_mcu7t5v0__dffsnq_1
X_4958_ _5070_/A1 _4966_/A2 _4958_/B _7193_/D VDD VDD VSS VSS gf180mcu_fd_sc_mcu7t5v0__oai21_1
X_3909_ _3906_/Z _3907_/Z _3908_/Z _3909_/Z VDD VDD VSS VSS gf180mcu_fd_sc_mcu7t5v0__xor3_1
XTAP_TAPCELL_ROW_22_568 VDD VSS gf180mcu_fd_sc_mcu7t5v0__filltie
X_4889_ _7159_/Q _4896_/A2 _4890_/B VDD VDD VSS VSS gf180mcu_fd_sc_mcu7t5v0__nand2_1
X_7677_ _7677_/D _7701_/RN _7703_/CLK _7677_/Q VDD VDD VSS VSS gf180mcu_fd_sc_mcu7t5v0__dffrnq_1
X_6628_ _6635_/A3 _6658_/A2 _6633_/A1 VDD VDD VSS VSS gf180mcu_fd_sc_mcu7t5v0__nand2_1
XPHY_EDGE_ROW_67_Right_67 VDD VSS gf180mcu_fd_sc_mcu7t5v0__endcap
X_6559_ _6559_/A1 _6559_/A2 _6558_/Z _7695_/D VDD VDD VSS VSS gf180mcu_fd_sc_mcu7t5v0__nor3_1
XFILLER_105_133 VDD VDD VSS VSS gf180mcu_fd_sc_mcu7t5v0__fill_1
XFILLER_75_702 VDD VDD VSS VSS gf180mcu_fd_sc_mcu7t5v0__fill_2
XFILLER_0_978 VDD VDD VSS VSS gf180mcu_fd_sc_mcu7t5v0__fillcap_4
XPHY_EDGE_ROW_76_Right_76 VDD VSS gf180mcu_fd_sc_mcu7t5v0__endcap
XTAP_TAPCELL_ROW_2_282 VDD VSS gf180mcu_fd_sc_mcu7t5v0__filltie
XPHY_EDGE_ROW_106_Left_225 VDD VSS gf180mcu_fd_sc_mcu7t5v0__endcap
XFILLER_71_941 VDD VDD VSS VSS gf180mcu_fd_sc_mcu7t5v0__fillcap_32
XTAP_TAPCELL_ROW_2_293 VDD VSS gf180mcu_fd_sc_mcu7t5v0__filltie
XFILLER_43_632 VDD VDD VSS VSS gf180mcu_fd_sc_mcu7t5v0__fillcap_8
XTAP_TAPCELL_ROW_41_833 VDD VSS gf180mcu_fd_sc_mcu7t5v0__filltie
XTAP_TAPCELL_ROW_96_1607 VDD VSS gf180mcu_fd_sc_mcu7t5v0__filltie
XPHY_EDGE_ROW_85_Right_85 VDD VSS gf180mcu_fd_sc_mcu7t5v0__endcap
XFILLER_11_562 VDD VDD VSS VSS gf180mcu_fd_sc_mcu7t5v0__fillcap_64
Xwire420 wire420/I wire420/Z VDD VDD VSS VSS gf180mcu_fd_sc_mcu7t5v0__clkbuf_4
Xwire453 _6232_/B _6084_/C VDD VDD VSS VSS gf180mcu_fd_sc_mcu7t5v0__buf_4
XPHY_EDGE_ROW_115_Left_234 VDD VSS gf180mcu_fd_sc_mcu7t5v0__endcap
XFILLER_3_772 VDD VDD VSS VSS gf180mcu_fd_sc_mcu7t5v0__fillcap_64
Xload_slew425 _5578_/A2 _5600_/A2 VDD VDD VSS VSS gf180mcu_fd_sc_mcu7t5v0__buf_4
Xload_slew436 _5369_/ZN _5579_/A2 VDD VDD VSS VSS gf180mcu_fd_sc_mcu7t5v0__buf_3
Xload_slew447 _6238_/B _6134_/C VDD VDD VSS VSS gf180mcu_fd_sc_mcu7t5v0__clkbuf_4
XPHY_EDGE_ROW_94_Right_94 VDD VSS gf180mcu_fd_sc_mcu7t5v0__endcap
Xload_slew469 _5558_/B _5514_/C VDD VDD VSS VSS gf180mcu_fd_sc_mcu7t5v0__clkbuf_4
XFILLER_78_584 VDD VDD VSS VSS gf180mcu_fd_sc_mcu7t5v0__fillcap_8
XTAP_TAPCELL_ROW_49_944 VDD VSS gf180mcu_fd_sc_mcu7t5v0__filltie
X_5930_ _7144_/Q wire322/Z _6140_/B1 _7221_/Q _5932_/A1 VDD VDD VSS VSS gf180mcu_fd_sc_mcu7t5v0__oai22_1
XTAP_TAPCELL_ROW_105_1725 VDD VSS gf180mcu_fd_sc_mcu7t5v0__filltie
X_7600_ _7600_/D _7671_/RN _7669_/CLK _7600_/Q VDD VDD VSS VSS gf180mcu_fd_sc_mcu7t5v0__dffrnq_1
X_5861_ _5861_/A1 _5861_/A2 _6122_/C _5861_/C _5875_/A2 VDD VDD VSS VSS gf180mcu_fd_sc_mcu7t5v0__oai211_1
X_5792_ _5792_/A1 _5792_/A2 _5792_/B1 _6237_/B _6244_/C _5806_/B VDD VDD VSS VSS gf180mcu_fd_sc_mcu7t5v0__oai221_1
X_4812_ _4826_/A1 _4812_/A2 _4812_/B _7120_/D VDD VDD VSS VSS gf180mcu_fd_sc_mcu7t5v0__oai21_1
X_7531_ _7531_/D _7668_/RN _7668_/CLK _7531_/Q VDD VDD VSS VSS gf180mcu_fd_sc_mcu7t5v0__dffrnq_1
X_4743_ _7086_/Q _4756_/A2 _4744_/B VDD VDD VSS VSS gf180mcu_fd_sc_mcu7t5v0__nand2_1
XFILLER_21_348 VDD VDD VSS VSS gf180mcu_fd_sc_mcu7t5v0__fill_2
X_7462_ _7462_/D _7483_/CLK _7462_/Q VDD VDD VSS VSS gf180mcu_fd_sc_mcu7t5v0__dffq_1
XFILLER_30_871 VDD VDD VSS VSS gf180mcu_fd_sc_mcu7t5v0__fillcap_4
X_6413_ _7661_/Q _7527_/Q _6413_/A3 _6415_/A2 VDD VDD VSS VSS gf180mcu_fd_sc_mcu7t5v0__xnor3_1
X_4674_ _5094_/A1 _4686_/A2 _4674_/B _7051_/D VDD VDD VSS VSS gf180mcu_fd_sc_mcu7t5v0__oai21_1
XTAP_TAPCELL_ROW_60_1098 VDD VSS gf180mcu_fd_sc_mcu7t5v0__filltie
X_7393_ _7393_/D _7735_/CLK _7393_/Q VDD VDD VSS VSS gf180mcu_fd_sc_mcu7t5v0__dffq_1
X_3625_ input62/Z _3595_/Z _3624_/Z _3625_/Z VDD VDD VSS VSS gf180mcu_fd_sc_mcu7t5v0__xor3_1
XTAP_TAPCELL_ROW_116_1876 VDD VSS gf180mcu_fd_sc_mcu7t5v0__filltie
X_6344_ _7633_/Q input49/Z _6344_/S _7633_/D VDD VDD VSS VSS gf180mcu_fd_sc_mcu7t5v0__mux2_2
X_3556_ _3553_/Z _3554_/Z _3555_/Z _3556_/Z VDD VDD VSS VSS gf180mcu_fd_sc_mcu7t5v0__xor3_1
XTAP_TAPCELL_ROW_116_1887 VDD VSS gf180mcu_fd_sc_mcu7t5v0__filltie
X_6275_ _7633_/Q _6285_/A2 _6283_/B1 _7798_/D _6283_/C1 _7523_/Q _6276_/B2 VDD VDD
+ VSS VSS gf180mcu_fd_sc_mcu7t5v0__aoi222_1
XFILLER_89_849 VDD VDD VSS VSS gf180mcu_fd_sc_mcu7t5v0__fillcap_8
X_5226_ _5352_/I0 _7373_/Q _5232_/S _7373_/D VDD VDD VSS VSS gf180mcu_fd_sc_mcu7t5v0__mux2_2
X_3487_ _3487_/I _3494_/A1 VDD VDD VSS VSS gf180mcu_fd_sc_mcu7t5v0__clkinv_1
X_5157_ _5339_/I0 _7304_/Q _5162_/S _7304_/D VDD VDD VSS VSS gf180mcu_fd_sc_mcu7t5v0__mux2_2
X_5088_ _5102_/A1 _5092_/A2 _5088_/B _7258_/D VDD VDD VSS VSS gf180mcu_fd_sc_mcu7t5v0__oai21_1
X_4108_ _6787_/Q _4938_/A2 _4109_/B VDD VDD VSS VSS gf180mcu_fd_sc_mcu7t5v0__nand2_1
X_4039_ _6765_/Q _4630_/A2 _4040_/B VDD VDD VSS VSS gf180mcu_fd_sc_mcu7t5v0__nand2_1
XFILLER_25_632 VDD VDD VSS VSS gf180mcu_fd_sc_mcu7t5v0__fillcap_64
XTAP_TAPCELL_ROW_27_638 VDD VSS gf180mcu_fd_sc_mcu7t5v0__filltie
XFILLER_52_473 VDD VDD VSS VSS gf180mcu_fd_sc_mcu7t5v0__fill_1
X_7729_ _7729_/D _7736_/RN _7734_/CLK _7729_/Q VDD VDD VSS VSS gf180mcu_fd_sc_mcu7t5v0__dffrnq_1
XTAP_TAPCELL_ROW_78_1348 VDD VSS gf180mcu_fd_sc_mcu7t5v0__filltie
XFILLER_108_2 VDD VDD VSS VSS gf180mcu_fd_sc_mcu7t5v0__fill_1
XFILLER_107_976 VDD VDD VSS VSS gf180mcu_fd_sc_mcu7t5v0__fillcap_4
XTAP_TAPCELL_ROW_91_1537 VDD VSS gf180mcu_fd_sc_mcu7t5v0__filltie
XTAP_TAPCELL_ROW_91_1526 VDD VSS gf180mcu_fd_sc_mcu7t5v0__filltie
XTAP_TAPCELL_ROW_7_363 VDD VSS gf180mcu_fd_sc_mcu7t5v0__filltie
XTAP_TAPCELL_ROW_7_352 VDD VSS gf180mcu_fd_sc_mcu7t5v0__filltie
XTAP_TAPCELL_ROW_89_1499 VDD VSS gf180mcu_fd_sc_mcu7t5v0__filltie
XFILLER_75_587 VDD VDD VSS VSS gf180mcu_fd_sc_mcu7t5v0__fill_1
XTAP_TAPCELL_ROW_46_903 VDD VSS gf180mcu_fd_sc_mcu7t5v0__filltie
XFILLER_44_941 VDD VDD VSS VSS gf180mcu_fd_sc_mcu7t5v0__fillcap_4
XFILLER_43_473 VDD VDD VSS VSS gf180mcu_fd_sc_mcu7t5v0__fill_2
XTAP_TAPCELL_ROW_100_1655 VDD VSS gf180mcu_fd_sc_mcu7t5v0__filltie
XFILLER_12_871 VDD VDD VSS VSS gf180mcu_fd_sc_mcu7t5v0__fillcap_4
Xwire283 wire283/I wire283/Z VDD VDD VSS VSS gf180mcu_fd_sc_mcu7t5v0__buf_2
X_4390_ _4880_/A1 _4392_/A2 _4390_/B _6909_/D VDD VDD VSS VSS gf180mcu_fd_sc_mcu7t5v0__oai21_1
X_3410_ _7688_/Q _5731_/A2 VDD VDD VSS VSS gf180mcu_fd_sc_mcu7t5v0__clkinv_1
Xload_slew222 _5132_/A1 _5118_/A1 VDD VDD VSS VSS gf180mcu_fd_sc_mcu7t5v0__buf_3
Xload_slew211 _5112_/A1 _4832_/A1 VDD VDD VSS VSS gf180mcu_fd_sc_mcu7t5v0__clkbuf_4
XFILLER_112_467 VDD VDD VSS VSS gf180mcu_fd_sc_mcu7t5v0__fill_1
Xload_slew233 _5130_/A1 _4584_/A1 VDD VDD VSS VSS gf180mcu_fd_sc_mcu7t5v0__clkbuf_4
XFILLER_86_819 VDD VDD VSS VSS gf180mcu_fd_sc_mcu7t5v0__fill_1
X_6060_ _6184_/C _6060_/A2 _6060_/A3 _6061_/B VDD VDD VSS VSS gf180mcu_fd_sc_mcu7t5v0__nand3_1
Xload_slew255 _4946_/A1 _4540_/A1 VDD VDD VSS VSS gf180mcu_fd_sc_mcu7t5v0__clkbuf_4
XFILLER_39_702 VDD VDD VSS VSS gf180mcu_fd_sc_mcu7t5v0__fillcap_64
Xload_slew244 _4112_/A1 _4088_/A1 VDD VDD VSS VSS gf180mcu_fd_sc_mcu7t5v0__buf_3
X_5011_ _7220_/Q _5022_/A2 _5012_/B VDD VDD VSS VSS gf180mcu_fd_sc_mcu7t5v0__nand2_1
Xload_slew266 _4942_/A1 _4396_/A1 VDD VDD VSS VSS gf180mcu_fd_sc_mcu7t5v0__clkbuf_4
Xload_slew299 _6089_/B1 _6092_/B1 VDD VDD VSS VSS gf180mcu_fd_sc_mcu7t5v0__clkbuf_4
X_6962_ _6962_/D _7687_/CLK _6962_/Q VDD VDD VSS VSS gf180mcu_fd_sc_mcu7t5v0__dffq_1
X_6893_ _6893_/D _7148_/CLK _6893_/Q VDD VDD VSS VSS gf180mcu_fd_sc_mcu7t5v0__dffq_1
X_5913_ _5913_/A1 _5913_/A2 _5936_/A1 VDD VDD VSS VSS gf180mcu_fd_sc_mcu7t5v0__nor2_1
X_5844_ _6884_/Q wire322/I _6140_/B1 _6891_/Q _6898_/Q _6141_/A2 _5845_/A2 VDD VDD
+ VSS VSS gf180mcu_fd_sc_mcu7t5v0__oai222_1
XTAP_TAPCELL_ROW_62_1127 VDD VSS gf180mcu_fd_sc_mcu7t5v0__filltie
X_5775_ _6862_/Q _6197_/A2 _6201_/C _5777_/A1 VDD VDD VSS VSS gf180mcu_fd_sc_mcu7t5v0__oai21_1
X_7514_ _7514_/D _7764_/RN _7765_/CLK _7514_/Q VDD VDD VSS VSS gf180mcu_fd_sc_mcu7t5v0__dffsnq_1
XTAP_TAPCELL_ROW_118_1927 VDD VSS gf180mcu_fd_sc_mcu7t5v0__filltie
XTAP_TAPCELL_ROW_118_1916 VDD VSS gf180mcu_fd_sc_mcu7t5v0__filltie
XTAP_TAPCELL_ROW_118_1905 VDD VSS gf180mcu_fd_sc_mcu7t5v0__filltie
X_4726_ _4824_/A1 _4728_/A2 _4726_/B _7077_/D VDD VDD VSS VSS gf180mcu_fd_sc_mcu7t5v0__oai21_1
X_4657_ _7043_/Q _4658_/A2 _4658_/B VDD VDD VSS VSS gf180mcu_fd_sc_mcu7t5v0__nand2_1
X_7445_ _7445_/D _7754_/CLK _7445_/Q VDD VDD VSS VSS gf180mcu_fd_sc_mcu7t5v0__dffq_1
X_3608_ input16/Z input78/Z input88/Z _3608_/Z VDD VDD VSS VSS gf180mcu_fd_sc_mcu7t5v0__xor3_1
Xinput80 tl_i[75] input80/Z VDD VDD VSS VSS gf180mcu_fd_sc_mcu7t5v0__dlyd_1
Xinput91 tl_i[85] input91/Z VDD VDD VSS VSS gf180mcu_fd_sc_mcu7t5v0__dlyd_1
X_7376_ _7376_/D _7489_/CLK _7376_/Q VDD VDD VSS VSS gf180mcu_fd_sc_mcu7t5v0__dffq_1
X_4588_ wire292/Z _4588_/A2 _4588_/B _7008_/D VDD VDD VSS VSS gf180mcu_fd_sc_mcu7t5v0__oai21_1
X_6327_ _6327_/A1 _6325_/S _6327_/B _7621_/D VDD VDD VSS VSS gf180mcu_fd_sc_mcu7t5v0__oai21_1
X_3539_ _7879_/I _3668_/A2 _5813_/A1 VDD VDD VSS VSS gf180mcu_fd_sc_mcu7t5v0__nand2_1
XFILLER_104_979 VDD VDD VSS VSS gf180mcu_fd_sc_mcu7t5v0__fill_2
X_6258_ _7625_/Q _6262_/A2 _6268_/B1 _7706_/Q _6259_/B2 VDD VDD VSS VSS gf180mcu_fd_sc_mcu7t5v0__aoi22_1
XTAP_TAPCELL_ROW_73_1278 VDD VSS gf180mcu_fd_sc_mcu7t5v0__filltie
X_6189_ _6189_/A1 _6189_/A2 _6189_/A3 _6189_/A4 _6189_/Z VDD VDD VSS VSS gf180mcu_fd_sc_mcu7t5v0__and4_1
XTAP_TAPCELL_ROW_4_311 VDD VSS gf180mcu_fd_sc_mcu7t5v0__filltie
X_5209_ _5342_/I0 _7356_/Q _5211_/S _7356_/D VDD VDD VSS VSS gf180mcu_fd_sc_mcu7t5v0__mux2_2
XFILLER_69_392 VDD VDD VSS VSS gf180mcu_fd_sc_mcu7t5v0__fill_2
XFILLER_85_896 VDD VDD VSS VSS gf180mcu_fd_sc_mcu7t5v0__fill_1
XFILLER_26_941 VDD VDD VSS VSS gf180mcu_fd_sc_mcu7t5v0__fillcap_4
XTAP_TAPCELL_ROW_51_972 VDD VSS gf180mcu_fd_sc_mcu7t5v0__filltie
XFILLER_107_784 VDD VDD VSS VSS gf180mcu_fd_sc_mcu7t5v0__fill_2
XFILLER_48_510 VDD VDD VSS VSS gf180mcu_fd_sc_mcu7t5v0__fillcap_4
XFILLER_67_329 VDD VDD VSS VSS gf180mcu_fd_sc_mcu7t5v0__fill_1
XFILLER_48_543 VDD VDD VSS VSS gf180mcu_fd_sc_mcu7t5v0__fill_1
XFILLER_75_362 VDD VDD VSS VSS gf180mcu_fd_sc_mcu7t5v0__fill_2
XFILLER_91_888 VDD VDD VSS VSS gf180mcu_fd_sc_mcu7t5v0__fill_2
XFILLER_91_899 VDD VDD VSS VSS gf180mcu_fd_sc_mcu7t5v0__fill_1
X_3890_ _7648_/Q _3890_/A2 _3890_/B _6365_/A2 VDD VDD VSS VSS gf180mcu_fd_sc_mcu7t5v0__oai21_1
X_5560_ _5560_/A1 _5560_/A2 _5570_/B1 VDD VDD VSS VSS gf180mcu_fd_sc_mcu7t5v0__nor2_1
X_4511_ _6970_/Q _4518_/A2 _4512_/B VDD VDD VSS VSS gf180mcu_fd_sc_mcu7t5v0__nand2_1
XFILLER_8_661 VDD VDD VSS VSS gf180mcu_fd_sc_mcu7t5v0__fillcap_4
X_5491_ _5590_/B _5491_/A2 _5491_/A3 _7730_/Q _5492_/B2 VDD VDD VSS VSS gf180mcu_fd_sc_mcu7t5v0__oai31_1
XFILLER_117_559 VDD VDD VSS VSS gf180mcu_fd_sc_mcu7t5v0__fill_1
X_4442_ _5086_/A1 _4448_/A2 _4442_/B _6935_/D VDD VDD VSS VSS gf180mcu_fd_sc_mcu7t5v0__oai21_1
X_7230_ _7230_/D _7251_/CLK _7230_/Q VDD VDD VSS VSS gf180mcu_fd_sc_mcu7t5v0__dffq_1
XTAP_TAPCELL_ROW_113_1846 VDD VSS gf180mcu_fd_sc_mcu7t5v0__filltie
XFILLER_113_710 VDD VDD VSS VSS gf180mcu_fd_sc_mcu7t5v0__fill_2
XTAP_TAPCELL_ROW_113_1835 VDD VSS gf180mcu_fd_sc_mcu7t5v0__filltie
X_4373_ _6901_/Q _4378_/A2 _4374_/B VDD VDD VSS VSS gf180mcu_fd_sc_mcu7t5v0__nand2_1
X_7161_ _7161_/D _7233_/CLK _7161_/Q VDD VDD VSS VSS gf180mcu_fd_sc_mcu7t5v0__dffq_1
XFILLER_113_765 VDD VDD VSS VSS gf180mcu_fd_sc_mcu7t5v0__fillcap_4
X_7092_ _7092_/D _7099_/CLK _7092_/Q VDD VDD VSS VSS gf180mcu_fd_sc_mcu7t5v0__dffq_1
X_6112_ _7084_/Q _6112_/A2 _6191_/B _6114_/A1 VDD VDD VSS VSS gf180mcu_fd_sc_mcu7t5v0__oai21_1
X_6043_ _6964_/Q _6222_/B1 _6092_/B1 _6957_/Q _6045_/A1 VDD VDD VSS VSS gf180mcu_fd_sc_mcu7t5v0__oai22_1
XFILLER_101_949 VDD VDD VSS VSS gf180mcu_fd_sc_mcu7t5v0__fillcap_16
XFILLER_54_535 VDD VDD VSS VSS gf180mcu_fd_sc_mcu7t5v0__fill_1
X_6945_ _6945_/D _7055_/CLK _6945_/Q VDD VDD VSS VSS gf180mcu_fd_sc_mcu7t5v0__dffq_1
XFILLER_82_877 VDD VDD VSS VSS gf180mcu_fd_sc_mcu7t5v0__fill_2
XFILLER_81_354 VDD VDD VSS VSS gf180mcu_fd_sc_mcu7t5v0__fill_1
XTAP_TAPCELL_ROW_37_777 VDD VSS gf180mcu_fd_sc_mcu7t5v0__filltie
X_6876_ _6876_/D _6882_/CLK _6876_/Q VDD VDD VSS VSS gf180mcu_fd_sc_mcu7t5v0__dffq_1
XTAP_TAPCELL_ROW_17_490 VDD VSS gf180mcu_fd_sc_mcu7t5v0__filltie
XFILLER_50_752 VDD VDD VSS VSS gf180mcu_fd_sc_mcu7t5v0__fill_1
X_5827_ _5827_/A1 _5827_/A2 _6196_/B _5834_/A2 VDD VDD VSS VSS gf180mcu_fd_sc_mcu7t5v0__oai21_1
X_5758_ _5758_/A1 _5758_/A2 _5758_/B1 _5758_/B2 _6216_/B _5765_/A2 VDD VDD VSS VSS
+ gf180mcu_fd_sc_mcu7t5v0__oai221_1
X_4709_ _7069_/Q _4714_/A2 _4710_/B VDD VDD VSS VSS gf180mcu_fd_sc_mcu7t5v0__nand2_1
XTAP_TAPCELL_ROW_75_1307 VDD VSS gf180mcu_fd_sc_mcu7t5v0__filltie
X_7428_ _7428_/D _7456_/CLK _7428_/Q VDD VDD VSS VSS gf180mcu_fd_sc_mcu7t5v0__dffq_1
X_5689_ input35/Z _6373_/S _5689_/B _7562_/Q _5693_/B VDD VDD VSS VSS gf180mcu_fd_sc_mcu7t5v0__aoi211_1
X_7359_ _7359_/D _7482_/CLK _7359_/Q VDD VDD VSS VSS gf180mcu_fd_sc_mcu7t5v0__dffq_1
XFILLER_89_487 VDD VDD VSS VSS gf180mcu_fd_sc_mcu7t5v0__fill_2
XFILLER_58_874 VDD VDD VSS VSS gf180mcu_fd_sc_mcu7t5v0__fill_1
XTAP_TAPCELL_ROW_86_1469 VDD VSS gf180mcu_fd_sc_mcu7t5v0__filltie
XTAP_TAPCELL_ROW_86_1458 VDD VSS gf180mcu_fd_sc_mcu7t5v0__filltie
XFILLER_17_248 VDD VDD VSS VSS gf180mcu_fd_sc_mcu7t5v0__fill_2
XFILLER_32_207 VDD VDD VSS VSS gf180mcu_fd_sc_mcu7t5v0__fill_1
XFILLER_72_387 VDD VDD VSS VSS gf180mcu_fd_sc_mcu7t5v0__fill_2
XFILLER_53_590 VDD VDD VSS VSS gf180mcu_fd_sc_mcu7t5v0__fill_2
XFILLER_9_458 VDD VDD VSS VSS gf180mcu_fd_sc_mcu7t5v0__fill_2
XFILLER_96_947 VDD VDD VSS VSS gf180mcu_fd_sc_mcu7t5v0__fillcap_32
XFILLER_48_384 VDD VDD VSS VSS gf180mcu_fd_sc_mcu7t5v0__fill_1
XFILLER_64_833 VDD VDD VSS VSS gf180mcu_fd_sc_mcu7t5v0__fill_2
X_6730_ _6730_/A1 _5359_/Z _6731_/A2 VDD VDD VSS VSS gf180mcu_fd_sc_mcu7t5v0__nand2_1
X_4991_ _7210_/Q _4994_/A2 _4992_/B VDD VDD VSS VSS gf180mcu_fd_sc_mcu7t5v0__nand2_1
X_3942_ _4088_/A1 _4252_/A2 _3942_/B _6738_/D VDD VDD VSS VSS gf180mcu_fd_sc_mcu7t5v0__oai21_1
XTAP_TAPCELL_ROW_34_736 VDD VSS gf180mcu_fd_sc_mcu7t5v0__filltie
X_6661_ _6654_/B _6660_/Z _7737_/D VDD VDD VSS VSS gf180mcu_fd_sc_mcu7t5v0__nor2_1
X_3873_ _7649_/Q _3872_/Z _3873_/Z VDD VDD VSS VSS gf180mcu_fd_sc_mcu7t5v0__and2_1
XTAP_TAPCELL_ROW_14_460 VDD VSS gf180mcu_fd_sc_mcu7t5v0__filltie
X_5612_ _6804_/Q _5612_/A2 _5612_/B1 _6833_/Q _5614_/A2 VDD VDD VSS VSS gf180mcu_fd_sc_mcu7t5v0__oai22_1
XFILLER_20_947 VDD VDD VSS VSS gf180mcu_fd_sc_mcu7t5v0__fillcap_32
XFILLER_31_284 VDD VDD VSS VSS gf180mcu_fd_sc_mcu7t5v0__fill_1
X_6592_ _6201_/C _6603_/A2 _6595_/B VDD VDD VSS VSS gf180mcu_fd_sc_mcu7t5v0__nand2_1
X_5543_ _5577_/B _5543_/A2 _5543_/A3 _5553_/A1 VDD VDD VSS VSS gf180mcu_fd_sc_mcu7t5v0__nor3_1
X_5474_ _7488_/Q wire428/I _5507_/B1 _7467_/Q _5531_/B _5475_/A2 VDD VDD VSS VSS gf180mcu_fd_sc_mcu7t5v0__oai221_1
X_4425_ _6927_/Q _4434_/A2 _4426_/B VDD VDD VSS VSS gf180mcu_fd_sc_mcu7t5v0__nand2_1
XTAP_TAPCELL_ROW_57_1059 VDD VSS gf180mcu_fd_sc_mcu7t5v0__filltie
X_7213_ _7213_/D _7216_/CLK _7213_/Q VDD VDD VSS VSS gf180mcu_fd_sc_mcu7t5v0__dffq_1
X_4356_ _5014_/A1 _4364_/A2 _4356_/B _6892_/D VDD VDD VSS VSS gf180mcu_fd_sc_mcu7t5v0__oai21_1
X_7144_ _7144_/D _7267_/CLK _7144_/Q VDD VDD VSS VSS gf180mcu_fd_sc_mcu7t5v0__dffq_1
XFILLER_101_702 VDD VDD VSS VSS gf180mcu_fd_sc_mcu7t5v0__fill_2
Xfanout448 _6232_/B wire449/I VDD VDD VSS VSS gf180mcu_fd_sc_mcu7t5v0__dlyd_1
XTAP_TAPCELL_ROW_70_1237 VDD VSS gf180mcu_fd_sc_mcu7t5v0__filltie
X_4287_ _6858_/Q _4294_/A2 _4288_/B VDD VDD VSS VSS gf180mcu_fd_sc_mcu7t5v0__nand2_1
X_7075_ _7075_/D _7118_/CLK _7075_/Q VDD VDD VSS VSS gf180mcu_fd_sc_mcu7t5v0__dffq_1
X_6026_ _6026_/A1 _6026_/A2 _6026_/B _6033_/A2 VDD VDD VSS VSS gf180mcu_fd_sc_mcu7t5v0__oai21_1
XFILLER_27_546 VDD VDD VSS VSS gf180mcu_fd_sc_mcu7t5v0__fillcap_8
XFILLER_42_527 VDD VDD VSS VSS gf180mcu_fd_sc_mcu7t5v0__fillcap_64
XFILLER_54_387 VDD VDD VSS VSS gf180mcu_fd_sc_mcu7t5v0__fill_1
X_6928_ _6928_/D _7259_/CLK _6928_/Q VDD VDD VSS VSS gf180mcu_fd_sc_mcu7t5v0__dffq_1
X_6859_ _6859_/D _6915_/CLK _6859_/Q VDD VDD VSS VSS gf180mcu_fd_sc_mcu7t5v0__dffq_1
XFILLER_50_560 VDD VDD VSS VSS gf180mcu_fd_sc_mcu7t5v0__fill_2
XTAP_TAPCELL_ROW_81_1399 VDD VSS gf180mcu_fd_sc_mcu7t5v0__filltie
XTAP_TAPCELL_ROW_81_1388 VDD VSS gf180mcu_fd_sc_mcu7t5v0__filltie
XFILLER_109_846 VDD VDD VSS VSS gf180mcu_fd_sc_mcu7t5v0__fill_2
XFILLER_2_667 VDD VDD VSS VSS gf180mcu_fd_sc_mcu7t5v0__fillcap_64
XFILLER_78_947 VDD VDD VSS VSS gf180mcu_fd_sc_mcu7t5v0__fillcap_32
XFILLER_89_284 VDD VDD VSS VSS gf180mcu_fd_sc_mcu7t5v0__fill_1
XFILLER_100_790 VDD VDD VSS VSS gf180mcu_fd_sc_mcu7t5v0__fill_2
XFILLER_18_524 VDD VDD VSS VSS gf180mcu_fd_sc_mcu7t5v0__fill_1
XFILLER_46_855 VDD VDD VSS VSS gf180mcu_fd_sc_mcu7t5v0__fillcap_4
XFILLER_46_877 VDD VDD VSS VSS gf180mcu_fd_sc_mcu7t5v0__fillcap_64
XFILLER_60_313 VDD VDD VSS VSS gf180mcu_fd_sc_mcu7t5v0__fill_2
XFILLER_13_284 VDD VDD VSS VSS gf180mcu_fd_sc_mcu7t5v0__fill_1
XTAP_TAPCELL_ROW_99_1649 VDD VSS gf180mcu_fd_sc_mcu7t5v0__filltie
XTAP_TAPCELL_ROW_99_1638 VDD VSS gf180mcu_fd_sc_mcu7t5v0__filltie
XFILLER_9_277 VDD VDD VSS VSS gf180mcu_fd_sc_mcu7t5v0__fill_2
Xclkload25 _7736_/CLK clkload25/Z VDD VDD VSS VSS gf180mcu_fd_sc_mcu7t5v0__clkbuf_2
Xclkload14 _7782_/CLK clkload14/Z VDD VDD VSS VSS gf180mcu_fd_sc_mcu7t5v0__clkbuf_8
Xclkload47 _7003_/CLK clkload47/Z VDD VDD VSS VSS gf180mcu_fd_sc_mcu7t5v0__clkbuf_2
Xclkload36 _7781_/CLK clkload36/ZN VDD VDD VSS VSS gf180mcu_fd_sc_mcu7t5v0__inv_4
Xclkload69 _6882_/CLK clkload69/ZN VDD VDD VSS VSS gf180mcu_fd_sc_mcu7t5v0__inv_3
Xclkload58 _7196_/CLK clkload58/Z VDD VDD VSS VSS gf180mcu_fd_sc_mcu7t5v0__clkbuf_4
XFILLER_108_890 VDD VDD VSS VSS gf180mcu_fd_sc_mcu7t5v0__fillcap_32
XTAP_TAPCELL_ROW_110_1805 VDD VSS gf180mcu_fd_sc_mcu7t5v0__filltie
X_4210_ _6653_/A2 _4210_/A2 _5274_/S VDD VDD VSS VSS gf180mcu_fd_sc_mcu7t5v0__nand2_1
X_5190_ _5239_/I0 _7337_/Q _5190_/S _7337_/D VDD VDD VSS VSS gf180mcu_fd_sc_mcu7t5v0__mux2_2
XFILLER_96_733 VDD VDD VSS VSS gf180mcu_fd_sc_mcu7t5v0__fill_2
X_4141_ _4144_/A1 _4141_/A2 _5092_/A2 VDD VDD VSS VSS gf180mcu_fd_sc_mcu7t5v0__nand2_1
Xclkbuf_0_clk_i clk_i clkbuf_0_clk_i/Z VDD VDD VSS VSS gf180mcu_fd_sc_mcu7t5v0__clkbuf_16
XTAP_TAPCELL_ROW_39_806 VDD VSS gf180mcu_fd_sc_mcu7t5v0__filltie
X_4072_ _4129_/A1 _4081_/A2 _4784_/A2 VDD VDD VSS VSS gf180mcu_fd_sc_mcu7t5v0__nand2_1
XTAP_TAPCELL_ROW_19_530 VDD VSS gf180mcu_fd_sc_mcu7t5v0__filltie
XTAP_TAPCELL_ROW_108_1767 VDD VSS gf180mcu_fd_sc_mcu7t5v0__filltie
XFILLER_52_836 VDD VDD VSS VSS gf180mcu_fd_sc_mcu7t5v0__fillcap_8
X_7762_ _7762_/D _7810_/RN _7804_/CLK _7762_/Q VDD VDD VSS VSS gf180mcu_fd_sc_mcu7t5v0__dffrnq_1
XFILLER_51_335 VDD VDD VSS VSS gf180mcu_fd_sc_mcu7t5v0__fill_1
XFILLER_52_869 VDD VDD VSS VSS gf180mcu_fd_sc_mcu7t5v0__fillcap_4
X_4974_ _4988_/A1 _4980_/A2 _4974_/B _7201_/D VDD VDD VSS VSS gf180mcu_fd_sc_mcu7t5v0__oai21_1
X_7693_ _7693_/D _7693_/RN _7693_/CLK _7693_/Q VDD VDD VSS VSS gf180mcu_fd_sc_mcu7t5v0__dffrnq_1
X_6713_ _6713_/I _7754_/D VDD VDD VSS VSS gf180mcu_fd_sc_mcu7t5v0__clkinv_1
X_3925_ _3487_/I _3925_/A2 _3925_/A3 _3504_/Z _5746_/A4 VDD VDD VSS VSS gf180mcu_fd_sc_mcu7t5v0__nand4_1
X_6644_ _7731_/Q _6644_/A2 _6644_/Z VDD VDD VSS VSS gf180mcu_fd_sc_mcu7t5v0__xor2_1
Xclkload8 clkload8/I clkload8/ZN VDD VDD VSS VSS gf180mcu_fd_sc_mcu7t5v0__clkinv_2
X_3856_ _6679_/I0 _7749_/Q _3856_/B _3856_/ZN VDD VDD VSS VSS gf180mcu_fd_sc_mcu7t5v0__oai21_2
X_6575_ _7710_/Q _7709_/Q _6576_/S _7710_/D VDD VDD VSS VSS gf180mcu_fd_sc_mcu7t5v0__mux2_2
X_3787_ _7740_/Q _3786_/Z _3787_/Z VDD VDD VSS VSS gf180mcu_fd_sc_mcu7t5v0__and2_1
X_5526_ _5526_/A1 _5526_/A2 _7511_/D VDD VDD VSS VSS gf180mcu_fd_sc_mcu7t5v0__nand2_1
X_5457_ _5457_/A1 _5457_/A2 _5582_/C _5458_/B2 VDD VDD VSS VSS gf180mcu_fd_sc_mcu7t5v0__oai21_1
X_4408_ _4506_/A1 _4420_/A2 _4408_/B _6918_/D VDD VDD VSS VSS gf180mcu_fd_sc_mcu7t5v0__oai21_1
XFILLER_114_871 VDD VDD VSS VSS gf180mcu_fd_sc_mcu7t5v0__fillcap_4
Xfanout212 fanout214/Z _5126_/A1 VDD VDD VSS VSS gf180mcu_fd_sc_mcu7t5v0__dlyd_1
X_5388_ _5388_/A1 _5388_/A2 _5398_/A2 VDD VDD VSS VSS gf180mcu_fd_sc_mcu7t5v0__nor2_1
Xfanout223 wire231/I _3874_/A2 VDD VDD VSS VSS gf180mcu_fd_sc_mcu7t5v0__dlyd_1
X_4339_ _6884_/Q _4350_/A2 _4340_/B VDD VDD VSS VSS gf180mcu_fd_sc_mcu7t5v0__nand2_1
Xfanout234 _4948_/A1 _5102_/A1 VDD VDD VSS VSS gf180mcu_fd_sc_mcu7t5v0__dlyd_1
Xfanout245 _3863_/ZN _4140_/A1 VDD VDD VSS VSS gf180mcu_fd_sc_mcu7t5v0__dlyd_1
X_7127_ _7127_/D _7217_/CLK _7127_/Q VDD VDD VSS VSS gf180mcu_fd_sc_mcu7t5v0__dffq_1
Xfanout256 _5072_/A1 _4918_/A1 VDD VDD VSS VSS gf180mcu_fd_sc_mcu7t5v0__dlyd_1
X_7058_ _7058_/D _7064_/CLK _7058_/Q VDD VDD VSS VSS gf180mcu_fd_sc_mcu7t5v0__dffq_1
Xfanout267 _4550_/A1 wire268/I VDD VDD VSS VSS gf180mcu_fd_sc_mcu7t5v0__dlyd_1
X_6009_ _6992_/Q wire353/I _6131_/A2 _6915_/Q _6229_/C _6010_/A2 VDD VDD VSS VSS gf180mcu_fd_sc_mcu7t5v0__oai221_1
XFILLER_28_877 VDD VDD VSS VSS gf180mcu_fd_sc_mcu7t5v0__fillcap_64
XTAP_TAPCELL_ROW_83_1417 VDD VSS gf180mcu_fd_sc_mcu7t5v0__filltie
XFILLER_27_354 VDD VDD VSS VSS gf180mcu_fd_sc_mcu7t5v0__fill_1
XFILLER_43_836 VDD VDD VSS VSS gf180mcu_fd_sc_mcu7t5v0__fillcap_4
XFILLER_91_59 VDD VDD VSS VSS gf180mcu_fd_sc_mcu7t5v0__fill_1
XFILLER_11_766 VDD VDD VSS VSS gf180mcu_fd_sc_mcu7t5v0__fillcap_4
XFILLER_109_632 VDD VDD VSS VSS gf180mcu_fd_sc_mcu7t5v0__fill_1
XTAP_TAPCELL_ROW_94_1579 VDD VSS gf180mcu_fd_sc_mcu7t5v0__filltie
XTAP_TAPCELL_ROW_94_1568 VDD VSS gf180mcu_fd_sc_mcu7t5v0__filltie
XFILLER_3_976 VDD VDD VSS VSS gf180mcu_fd_sc_mcu7t5v0__fillcap_4
XFILLER_111_329 VDD VDD VSS VSS gf180mcu_fd_sc_mcu7t5v0__fillcap_4
XFILLER_78_733 VDD VDD VSS VSS gf180mcu_fd_sc_mcu7t5v0__fill_2
XFILLER_81_909 VDD VDD VSS VSS gf180mcu_fd_sc_mcu7t5v0__fill_1
XTAP_TAPCELL_ROW_44_875 VDD VSS gf180mcu_fd_sc_mcu7t5v0__filltie
X_3710_ _7743_/Q _6679_/I1 _7745_/Q _7744_/Q _6693_/A1 VDD VDD VSS VSS gf180mcu_fd_sc_mcu7t5v0__nor4_1
XFILLER_61_699 VDD VDD VSS VSS gf180mcu_fd_sc_mcu7t5v0__fill_1
XTAP_TAPCELL_ROW_103_1697 VDD VSS gf180mcu_fd_sc_mcu7t5v0__filltie
X_4690_ _4998_/A1 _4700_/A2 _4690_/B _7059_/D VDD VDD VSS VSS gf180mcu_fd_sc_mcu7t5v0__oai21_1
X_3641_ _3695_/C _3385_/I _3541_/Z _3641_/Z VDD VDD VSS VSS gf180mcu_fd_sc_mcu7t5v0__xor3_1
X_3572_ input79/Z input82/Z _3572_/Z VDD VDD VSS VSS gf180mcu_fd_sc_mcu7t5v0__xor2_1
X_6360_ wire507/I input37/Z _7782_/D _7646_/D VDD VDD VSS VSS gf180mcu_fd_sc_mcu7t5v0__mux2_2
X_5311_ _6354_/I0 _7458_/Q _5316_/S _7458_/D VDD VDD VSS VSS gf180mcu_fd_sc_mcu7t5v0__mux2_2
X_6291_ _7531_/Q _6301_/B1 _6292_/B2 VDD VDD VSS VSS gf180mcu_fd_sc_mcu7t5v0__nand2_1
XTAP_TAPCELL_ROW_54_1018 VDD VSS gf180mcu_fd_sc_mcu7t5v0__filltie
X_5242_ _5354_/I0 _7389_/Q _5246_/S _7389_/D VDD VDD VSS VSS gf180mcu_fd_sc_mcu7t5v0__mux2_2
X_5173_ wire525/Z _7320_/Q _5176_/S _7320_/D VDD VDD VSS VSS gf180mcu_fd_sc_mcu7t5v0__mux2_2
X_4124_ _6792_/Q _5008_/A2 _4125_/B VDD VDD VSS VSS gf180mcu_fd_sc_mcu7t5v0__nand2_1
XFILLER_69_766 VDD VDD VSS VSS gf180mcu_fd_sc_mcu7t5v0__fillcap_4
Xinput1 alert_rx_i[0] input1/Z VDD VDD VSS VSS gf180mcu_fd_sc_mcu7t5v0__dlyd_1
X_4055_ _4146_/A1 _4700_/A2 _4055_/B _6770_/D VDD VDD VSS VSS gf180mcu_fd_sc_mcu7t5v0__oai21_1
X_7814_ input3/Z _7823_/RN clkload7/I _7815_/D VDD VDD VSS VSS gf180mcu_fd_sc_mcu7t5v0__dffsnq_1
XFILLER_25_836 VDD VDD VSS VSS gf180mcu_fd_sc_mcu7t5v0__fillcap_4
XFILLER_37_696 VDD VDD VSS VSS gf180mcu_fd_sc_mcu7t5v0__fillcap_4
XTAP_TAPCELL_ROW_65_1169 VDD VSS gf180mcu_fd_sc_mcu7t5v0__filltie
X_7745_ _7745_/D wire565/Z _7755_/CLK _7745_/Q VDD VDD VSS VSS gf180mcu_fd_sc_mcu7t5v0__dffrnq_1
X_4957_ _7193_/Q _4966_/A2 _4958_/B VDD VDD VSS VSS gf180mcu_fd_sc_mcu7t5v0__nand2_1
X_3908_ _7576_/Q _7578_/Q _3908_/Z VDD VDD VSS VSS gf180mcu_fd_sc_mcu7t5v0__xor2_1
X_7676_ _7676_/D _7693_/RN _7693_/CLK _7676_/Q VDD VDD VSS VSS gf180mcu_fd_sc_mcu7t5v0__dffrnq_1
X_4888_ _5098_/A1 _4896_/A2 _4888_/B _7158_/D VDD VDD VSS VSS gf180mcu_fd_sc_mcu7t5v0__oai21_1
X_3839_ _7594_/Q _7595_/Q _3839_/Z VDD VDD VSS VSS gf180mcu_fd_sc_mcu7t5v0__xor2_1
XTAP_TAPCELL_ROW_22_569 VDD VSS gf180mcu_fd_sc_mcu7t5v0__filltie
X_6627_ _6635_/A3 _6654_/B _6631_/A2 VDD VDD VSS VSS gf180mcu_fd_sc_mcu7t5v0__nor2_1
X_6558_ _7695_/Q _6555_/Z _6558_/Z VDD VDD VSS VSS gf180mcu_fd_sc_mcu7t5v0__and2_1
XFILLER_118_473 VDD VDD VSS VSS gf180mcu_fd_sc_mcu7t5v0__fill_2
X_6489_ _6521_/A1 _6521_/A2 _6559_/A1 VDD VDD VSS VSS gf180mcu_fd_sc_mcu7t5v0__nand2_1
X_5509_ _5509_/A1 _5509_/A2 _5519_/A2 VDD VDD VSS VSS gf180mcu_fd_sc_mcu7t5v0__nor2_1
XFILLER_102_874 VDD VDD VSS VSS gf180mcu_fd_sc_mcu7t5v0__fill_1
XFILLER_102_863 VDD VDD VSS VSS gf180mcu_fd_sc_mcu7t5v0__fill_1
XFILLER_59_232 VDD VDD VSS VSS gf180mcu_fd_sc_mcu7t5v0__fill_2
XFILLER_63_909 VDD VDD VSS VSS gf180mcu_fd_sc_mcu7t5v0__fill_1
XFILLER_90_717 VDD VDD VSS VSS gf180mcu_fd_sc_mcu7t5v0__fillcap_4
XTAP_TAPCELL_ROW_2_283 VDD VSS gf180mcu_fd_sc_mcu7t5v0__filltie
XTAP_TAPCELL_ROW_41_834 VDD VSS gf180mcu_fd_sc_mcu7t5v0__filltie
Xclkbuf_leaf_63_clk_i clkload3/I _7233_/CLK VDD VDD VSS VSS gf180mcu_fd_sc_mcu7t5v0__clkbuf_8
XFILLER_70_485 VDD VDD VSS VSS gf180mcu_fd_sc_mcu7t5v0__fill_1
XTAP_TAPCELL_ROW_96_1608 VDD VSS gf180mcu_fd_sc_mcu7t5v0__filltie
Xwire443 _5823_/C _6197_/B VDD VDD VSS VSS gf180mcu_fd_sc_mcu7t5v0__clkbuf_4
XFILLER_7_534 VDD VDD VSS VSS gf180mcu_fd_sc_mcu7t5v0__fillcap_16
Xclkbuf_leaf_78_clk_i clkbuf_3_1__f_clk_i/Z _7499_/CLK VDD VDD VSS VSS gf180mcu_fd_sc_mcu7t5v0__clkbuf_8
Xwire454 wire454/I _6212_/C VDD VDD VSS VSS gf180mcu_fd_sc_mcu7t5v0__clkbuf_4
Xwire498 _6147_/B _6204_/B VDD VDD VSS VSS gf180mcu_fd_sc_mcu7t5v0__buf_4
Xwire487 wire487/I _6176_/B VDD VDD VSS VSS gf180mcu_fd_sc_mcu7t5v0__clkbuf_4
Xload_slew404 _6242_/A2 _6229_/A2 VDD VDD VSS VSS gf180mcu_fd_sc_mcu7t5v0__clkbuf_4
Xload_slew415 _6225_/A2 _6087_/A2 VDD VDD VSS VSS gf180mcu_fd_sc_mcu7t5v0__buf_4
Xload_slew426 _5372_/Z _5596_/B1 VDD VDD VSS VSS gf180mcu_fd_sc_mcu7t5v0__clkbuf_4
Xload_slew437 _4147_/A1 _4114_/A1 VDD VDD VSS VSS gf180mcu_fd_sc_mcu7t5v0__buf_2
XFILLER_78_541 VDD VDD VSS VSS gf180mcu_fd_sc_mcu7t5v0__fillcap_4
XFILLER_39_906 VDD VDD VSS VSS gf180mcu_fd_sc_mcu7t5v0__fillcap_4
Xload_slew459 _6637_/A1 _5493_/S VDD VDD VSS VSS gf180mcu_fd_sc_mcu7t5v0__clkbuf_4
XFILLER_66_747 VDD VDD VSS VSS gf180mcu_fd_sc_mcu7t5v0__fill_1
Xclkbuf_leaf_16_clk_i clkload1/I _7693_/CLK VDD VDD VSS VSS gf180mcu_fd_sc_mcu7t5v0__clkbuf_8
XTAP_TAPCELL_ROW_49_945 VDD VSS gf180mcu_fd_sc_mcu7t5v0__filltie
XFILLER_93_599 VDD VDD VSS VSS gf180mcu_fd_sc_mcu7t5v0__fill_1
XFILLER_81_728 VDD VDD VSS VSS gf180mcu_fd_sc_mcu7t5v0__fill_2
XTAP_TAPCELL_ROW_105_1726 VDD VSS gf180mcu_fd_sc_mcu7t5v0__filltie
X_5860_ _5860_/A1 _5860_/A2 _6196_/B _5861_/A2 VDD VDD VSS VSS gf180mcu_fd_sc_mcu7t5v0__oai21_1
XFILLER_74_780 VDD VDD VSS VSS gf180mcu_fd_sc_mcu7t5v0__fillcap_8
XFILLER_19_696 VDD VDD VSS VSS gf180mcu_fd_sc_mcu7t5v0__fillcap_4
XFILLER_62_942 VDD VDD VSS VSS gf180mcu_fd_sc_mcu7t5v0__fill_2
X_4811_ _7120_/Q _4812_/A2 _4812_/B VDD VDD VSS VSS gf180mcu_fd_sc_mcu7t5v0__nand2_1
X_5791_ _5791_/A1 _5791_/A2 _5791_/B _5792_/B1 VDD VDD VSS VSS gf180mcu_fd_sc_mcu7t5v0__oai21_1
X_7530_ _7530_/D _7668_/RN _7670_/CLK _7530_/Q VDD VDD VSS VSS gf180mcu_fd_sc_mcu7t5v0__dffrnq_1
X_4742_ _5008_/A1 _4742_/A2 _4742_/B _7085_/D VDD VDD VSS VSS gf180mcu_fd_sc_mcu7t5v0__oai21_1
X_4673_ _7051_/Q _4686_/A2 _4674_/B VDD VDD VSS VSS gf180mcu_fd_sc_mcu7t5v0__nand2_1
X_7461_ _7461_/D _7482_/CLK _7461_/Q VDD VDD VSS VSS gf180mcu_fd_sc_mcu7t5v0__dffq_1
X_6412_ _6421_/A1 _6421_/A3 _6413_/A3 VDD VDD VSS VSS gf180mcu_fd_sc_mcu7t5v0__nor2_1
XTAP_TAPCELL_ROW_60_1099 VDD VSS gf180mcu_fd_sc_mcu7t5v0__filltie
X_3624_ _3550_/Z _3575_/Z _3623_/Z _3624_/Z VDD VDD VSS VSS gf180mcu_fd_sc_mcu7t5v0__xor3_1
X_7392_ _7392_/D _7735_/CLK _7392_/Q VDD VDD VSS VSS gf180mcu_fd_sc_mcu7t5v0__dffq_1
X_6343_ _6343_/A1 _6344_/S _6343_/B _7632_/D VDD VDD VSS VSS gf180mcu_fd_sc_mcu7t5v0__oai21_1
XTAP_TAPCELL_ROW_116_1877 VDD VSS gf180mcu_fd_sc_mcu7t5v0__filltie
X_3555_ input42/Z input37/Z input52/Z _3555_/Z VDD VDD VSS VSS gf180mcu_fd_sc_mcu7t5v0__xor3_1
XTAP_TAPCELL_ROW_116_1888 VDD VSS gf180mcu_fd_sc_mcu7t5v0__filltie
X_6274_ _6274_/A1 _6298_/A2 _6274_/B1 _6274_/B2 _7589_/D VDD VDD VSS VSS gf180mcu_fd_sc_mcu7t5v0__aoi22_1
X_3486_ _6134_/C _7721_/Q _3487_/I VDD VDD VSS VSS gf180mcu_fd_sc_mcu7t5v0__xor2_1
XFILLER_115_487 VDD VDD VSS VSS gf180mcu_fd_sc_mcu7t5v0__fill_2
X_5225_ _5239_/I0 _7372_/Q _5225_/S _7372_/D VDD VDD VSS VSS gf180mcu_fd_sc_mcu7t5v0__mux2_2
XFILLER_111_660 VDD VDD VSS VSS gf180mcu_fd_sc_mcu7t5v0__fill_2
X_5156_ _5345_/I0 _7303_/Q _5162_/S _7303_/D VDD VDD VSS VSS gf180mcu_fd_sc_mcu7t5v0__mux2_2
X_5087_ _7258_/Q _5092_/A2 _5088_/B VDD VDD VSS VSS gf180mcu_fd_sc_mcu7t5v0__nand2_1
X_4107_ _4141_/A2 _4110_/A2 _4938_/A2 VDD VDD VSS VSS gf180mcu_fd_sc_mcu7t5v0__nand2_1
X_4038_ _4120_/A1 _4053_/A2 _4630_/A2 VDD VDD VSS VSS gf180mcu_fd_sc_mcu7t5v0__nand2_1
XFILLER_84_588 VDD VDD VSS VSS gf180mcu_fd_sc_mcu7t5v0__fill_2
XTAP_TAPCELL_ROW_27_639 VDD VSS gf180mcu_fd_sc_mcu7t5v0__filltie
XFILLER_71_238 VDD VDD VSS VSS gf180mcu_fd_sc_mcu7t5v0__fill_1
X_5989_ _7215_/Q _6233_/A2 _6174_/B _5993_/A1 VDD VDD VSS VSS gf180mcu_fd_sc_mcu7t5v0__oai21_1
X_7728_ _7728_/D _7736_/RN _7734_/CLK _7728_/Q VDD VDD VSS VSS gf180mcu_fd_sc_mcu7t5v0__dffrnq_1
X_7659_ _7659_/D _7661_/RN _7670_/CLK _7659_/Q VDD VDD VSS VSS gf180mcu_fd_sc_mcu7t5v0__dffrnq_1
XFILLER_107_900 VDD VDD VSS VSS gf180mcu_fd_sc_mcu7t5v0__fillcap_8
XTAP_TAPCELL_ROW_78_1349 VDD VSS gf180mcu_fd_sc_mcu7t5v0__filltie
XTAP_TAPCELL_ROW_91_1538 VDD VSS gf180mcu_fd_sc_mcu7t5v0__filltie
XTAP_TAPCELL_ROW_91_1527 VDD VSS gf180mcu_fd_sc_mcu7t5v0__filltie
XFILLER_79_349 VDD VDD VSS VSS gf180mcu_fd_sc_mcu7t5v0__fill_1
XTAP_TAPCELL_ROW_7_353 VDD VSS gf180mcu_fd_sc_mcu7t5v0__filltie
XFILLER_102_693 VDD VDD VSS VSS gf180mcu_fd_sc_mcu7t5v0__fill_2
XTAP_TAPCELL_ROW_46_904 VDD VSS gf180mcu_fd_sc_mcu7t5v0__filltie
XFILLER_47_279 VDD VDD VSS VSS gf180mcu_fd_sc_mcu7t5v0__fill_1
XFILLER_62_249 VDD VDD VSS VSS gf180mcu_fd_sc_mcu7t5v0__fill_1
XFILLER_71_772 VDD VDD VSS VSS gf180mcu_fd_sc_mcu7t5v0__fillcap_4
XTAP_TAPCELL_ROW_100_1656 VDD VSS gf180mcu_fd_sc_mcu7t5v0__filltie
Xwire240 wire241/Z wire240/Z VDD VDD VSS VSS gf180mcu_fd_sc_mcu7t5v0__buf_4
Xload_slew201 _6302_/B1 _6284_/B1 VDD VDD VSS VSS gf180mcu_fd_sc_mcu7t5v0__buf_4
X_5010_ _5080_/A1 _5022_/A2 _5010_/B _7219_/D VDD VDD VSS VSS gf180mcu_fd_sc_mcu7t5v0__oai21_1
XFILLER_30_4 VDD VDD VSS VSS gf180mcu_fd_sc_mcu7t5v0__fill_1
Xload_slew289 _5134_/A1 _4532_/A1 VDD VDD VSS VSS gf180mcu_fd_sc_mcu7t5v0__buf_3
Xload_slew278 _4940_/A1 _4324_/A1 VDD VDD VSS VSS gf180mcu_fd_sc_mcu7t5v0__buf_4
XFILLER_78_382 VDD VDD VSS VSS gf180mcu_fd_sc_mcu7t5v0__fill_2
XFILLER_16_2 VDD VDD VSS VSS gf180mcu_fd_sc_mcu7t5v0__fill_2
XFILLER_66_522 VDD VDD VSS VSS gf180mcu_fd_sc_mcu7t5v0__fill_2
X_6961_ _6961_/D _7667_/CLK _6961_/Q VDD VDD VSS VSS gf180mcu_fd_sc_mcu7t5v0__dffq_1
X_5912_ _6906_/Q _6162_/A2 _6076_/A2 _6899_/Q _6885_/Q wire322/Z _5913_/A2 VDD VDD
+ VSS VSS gf180mcu_fd_sc_mcu7t5v0__oai222_1
X_6892_ _6892_/D _7267_/CLK _6892_/Q VDD VDD VSS VSS gf180mcu_fd_sc_mcu7t5v0__dffq_1
XFILLER_81_558 VDD VDD VSS VSS gf180mcu_fd_sc_mcu7t5v0__fill_2
XFILLER_62_761 VDD VDD VSS VSS gf180mcu_fd_sc_mcu7t5v0__fill_2
X_5843_ _6905_/Q _6087_/A2 _6162_/C _5845_/A1 VDD VDD VSS VSS gf180mcu_fd_sc_mcu7t5v0__oai21_1
XTAP_TAPCELL_ROW_62_1128 VDD VSS gf180mcu_fd_sc_mcu7t5v0__filltie
X_5774_ _5774_/A1 _5774_/A2 _5778_/B1 VDD VDD VSS VSS gf180mcu_fd_sc_mcu7t5v0__nor2_1
X_7513_ _7513_/D _7764_/RN _7765_/CLK _7513_/Q VDD VDD VSS VSS gf180mcu_fd_sc_mcu7t5v0__dffsnq_1
XTAP_TAPCELL_ROW_118_1928 VDD VSS gf180mcu_fd_sc_mcu7t5v0__filltie
XTAP_TAPCELL_ROW_118_1917 VDD VSS gf180mcu_fd_sc_mcu7t5v0__filltie
XTAP_TAPCELL_ROW_118_1906 VDD VSS gf180mcu_fd_sc_mcu7t5v0__filltie
X_4725_ _7077_/Q _4728_/A2 _4726_/B VDD VDD VSS VSS gf180mcu_fd_sc_mcu7t5v0__nand2_1
XFILLER_108_719 VDD VDD VSS VSS gf180mcu_fd_sc_mcu7t5v0__fill_1
X_4656_ _4964_/A1 _4658_/A2 _4656_/B _7042_/D VDD VDD VSS VSS gf180mcu_fd_sc_mcu7t5v0__oai21_1
X_7444_ _7444_/D _7451_/CLK _7444_/Q VDD VDD VSS VSS gf180mcu_fd_sc_mcu7t5v0__dffq_1
X_4587_ _7008_/Q _4588_/A2 _4588_/B VDD VDD VSS VSS gf180mcu_fd_sc_mcu7t5v0__nand2_1
Xinput81 tl_i[76] input81/Z VDD VDD VSS VSS gf180mcu_fd_sc_mcu7t5v0__dlyd_1
Xinput70 tl_i[66] _3682_/C VDD VDD VSS VSS gf180mcu_fd_sc_mcu7t5v0__dlyd_1
X_3607_ input82/Z _3606_/Z _3607_/Z VDD VDD VSS VSS gf180mcu_fd_sc_mcu7t5v0__xor2_1
X_7375_ _7375_/D _7489_/CLK _7375_/Q VDD VDD VSS VSS gf180mcu_fd_sc_mcu7t5v0__dffq_1
XFILLER_104_903 VDD VDD VSS VSS gf180mcu_fd_sc_mcu7t5v0__fill_1
X_3538_ input96/Z _3535_/Z _3537_/Z _3538_/Z VDD VDD VSS VSS gf180mcu_fd_sc_mcu7t5v0__xor3_1
Xinput92 tl_i[86] input92/Z VDD VDD VSS VSS gf180mcu_fd_sc_mcu7t5v0__dlyd_1
X_6326_ input36/Z _6326_/A2 _6327_/B VDD VDD VSS VSS gf180mcu_fd_sc_mcu7t5v0__nand2_1
XFILLER_104_947 VDD VDD VSS VSS gf180mcu_fd_sc_mcu7t5v0__fillcap_32
X_6257_ _6257_/A1 _6298_/A2 _6274_/B1 _6257_/B2 _7581_/D VDD VDD VSS VSS gf180mcu_fd_sc_mcu7t5v0__aoi22_1
XTAP_TAPCELL_ROW_73_1279 VDD VSS gf180mcu_fd_sc_mcu7t5v0__filltie
X_3469_ _7771_/Q _7770_/Q _7769_/Q _3469_/Z VDD VDD VSS VSS gf180mcu_fd_sc_mcu7t5v0__or3_1
XFILLER_88_168 VDD VDD VSS VSS gf180mcu_fd_sc_mcu7t5v0__fill_1
XFILLER_85_820 VDD VDD VSS VSS gf180mcu_fd_sc_mcu7t5v0__fill_2
X_5208_ _5243_/I0 _7355_/Q _5211_/S _7355_/D VDD VDD VSS VSS gf180mcu_fd_sc_mcu7t5v0__mux2_2
XTAP_TAPCELL_ROW_4_312 VDD VSS gf180mcu_fd_sc_mcu7t5v0__filltie
XFILLER_57_500 VDD VDD VSS VSS gf180mcu_fd_sc_mcu7t5v0__fill_2
X_6188_ _7566_/Q _5691_/I _6254_/B1 _7702_/Q _6189_/A4 VDD VDD VSS VSS gf180mcu_fd_sc_mcu7t5v0__aoi22_1
XFILLER_85_842 VDD VDD VSS VSS gf180mcu_fd_sc_mcu7t5v0__fill_2
X_5139_ _5342_/I0 _7286_/Q _5141_/S _7286_/D VDD VDD VSS VSS gf180mcu_fd_sc_mcu7t5v0__mux2_2
XFILLER_25_474 VDD VDD VSS VSS gf180mcu_fd_sc_mcu7t5v0__fill_1
XFILLER_41_912 VDD VDD VSS VSS gf180mcu_fd_sc_mcu7t5v0__fillcap_64
XFILLER_53_772 VDD VDD VSS VSS gf180mcu_fd_sc_mcu7t5v0__fillcap_4
XTAP_TAPCELL_ROW_51_973 VDD VSS gf180mcu_fd_sc_mcu7t5v0__filltie
XFILLER_68_809 VDD VDD VSS VSS gf180mcu_fd_sc_mcu7t5v0__fill_1
XFILLER_95_628 VDD VDD VSS VSS gf180mcu_fd_sc_mcu7t5v0__fill_2
XFILLER_48_522 VDD VDD VSS VSS gf180mcu_fd_sc_mcu7t5v0__fill_2
XFILLER_76_897 VDD VDD VSS VSS gf180mcu_fd_sc_mcu7t5v0__fill_2
XFILLER_57_72 VDD VDD VSS VSS gf180mcu_fd_sc_mcu7t5v0__fill_2
XFILLER_43_282 VDD VDD VSS VSS gf180mcu_fd_sc_mcu7t5v0__fill_2
X_4510_ _5126_/A1 _4518_/A2 _4510_/B _6969_/D VDD VDD VSS VSS gf180mcu_fd_sc_mcu7t5v0__oai21_1
X_5490_ _7418_/Q _5597_/A2 _5542_/A2 _7411_/Q _7404_/Q _5597_/B1 _5491_/A3 VDD VDD
+ VSS VSS gf180mcu_fd_sc_mcu7t5v0__oai222_1
X_4441_ _6935_/Q _4448_/A2 _4442_/B VDD VDD VSS VSS gf180mcu_fd_sc_mcu7t5v0__nand2_1
XFILLER_99_912 VDD VDD VSS VSS gf180mcu_fd_sc_mcu7t5v0__fillcap_64
XPHY_EDGE_ROW_9_Right_9 VDD VSS gf180mcu_fd_sc_mcu7t5v0__endcap
X_7160_ _7160_/D _7233_/CLK _7160_/Q VDD VDD VSS VSS gf180mcu_fd_sc_mcu7t5v0__dffq_1
XTAP_TAPCELL_ROW_113_1847 VDD VSS gf180mcu_fd_sc_mcu7t5v0__filltie
XTAP_TAPCELL_ROW_113_1836 VDD VSS gf180mcu_fd_sc_mcu7t5v0__filltie
X_4372_ _5086_/A1 _4378_/A2 _4372_/B _6900_/D VDD VDD VSS VSS gf180mcu_fd_sc_mcu7t5v0__oai21_1
XTAP_TAPCELL_ROW_59_1090 VDD VSS gf180mcu_fd_sc_mcu7t5v0__filltie
X_6111_ _7126_/Q _6214_/A2 _6175_/A2 _7105_/Q _6214_/B _6115_/A2 VDD VDD VSS VSS gf180mcu_fd_sc_mcu7t5v0__oai221_1
X_7091_ _7091_/D _7101_/CLK _7091_/Q VDD VDD VSS VSS gf180mcu_fd_sc_mcu7t5v0__dffq_1
XPHY_EDGE_ROW_107_Right_107 VDD VSS gf180mcu_fd_sc_mcu7t5v0__endcap
X_6042_ _6978_/Q _6092_/A2 _6092_/B1 _6985_/Q _7006_/Q _6092_/C2 _6046_/A2 VDD VDD
+ VSS VSS gf180mcu_fd_sc_mcu7t5v0__oai222_1
XFILLER_101_917 VDD VDD VSS VSS gf180mcu_fd_sc_mcu7t5v0__fillcap_32
XFILLER_67_842 VDD VDD VSS VSS gf180mcu_fd_sc_mcu7t5v0__fillcap_4
X_6944_ _6944_/D _6944_/CLK _6944_/Q VDD VDD VSS VSS gf180mcu_fd_sc_mcu7t5v0__dffq_1
XFILLER_23_912 VDD VDD VSS VSS gf180mcu_fd_sc_mcu7t5v0__fillcap_64
XFILLER_35_772 VDD VDD VSS VSS gf180mcu_fd_sc_mcu7t5v0__fillcap_64
XTAP_TAPCELL_ROW_37_778 VDD VSS gf180mcu_fd_sc_mcu7t5v0__filltie
XTAP_TAPCELL_ROW_17_491 VDD VSS gf180mcu_fd_sc_mcu7t5v0__filltie
X_6875_ _6875_/D _7719_/CLK _6875_/Q VDD VDD VSS VSS gf180mcu_fd_sc_mcu7t5v0__dffq_1
X_5826_ _7262_/Q _6198_/A2 _6141_/A2 _7255_/Q _7220_/Q _6140_/B1 _5827_/A2 VDD VDD
+ VSS VSS gf180mcu_fd_sc_mcu7t5v0__oai222_1
XFILLER_22_477 VDD VDD VSS VSS gf180mcu_fd_sc_mcu7t5v0__fill_2
X_5757_ _7121_/Q _6097_/A2 wire353/Z _7114_/Q _7100_/Q _6098_/A2 _5758_/B2 VDD VDD
+ VSS VSS gf180mcu_fd_sc_mcu7t5v0__oai222_1
X_4708_ _4708_/A1 _4714_/A2 _4708_/B _7068_/D VDD VDD VSS VSS gf180mcu_fd_sc_mcu7t5v0__oai21_1
XFILLER_108_527 VDD VDD VSS VSS gf180mcu_fd_sc_mcu7t5v0__fill_2
XTAP_TAPCELL_ROW_75_1308 VDD VSS gf180mcu_fd_sc_mcu7t5v0__filltie
X_7427_ _7427_/D _7754_/CLK _7427_/Q VDD VDD VSS VSS gf180mcu_fd_sc_mcu7t5v0__dffq_1
X_5688_ _7881_/I _7882_/I _5748_/A2 _3703_/Z _6373_/S VDD VDD VSS VSS gf180mcu_fd_sc_mcu7t5v0__nor4_4
X_4639_ _7034_/Q _4644_/A2 _4640_/B VDD VDD VSS VSS gf180mcu_fd_sc_mcu7t5v0__nand2_1
XFILLER_104_722 VDD VDD VSS VSS gf180mcu_fd_sc_mcu7t5v0__fillcap_8
X_7358_ _7358_/D _7378_/CLK _7358_/Q VDD VDD VSS VSS gf180mcu_fd_sc_mcu7t5v0__dffq_1
X_6309_ _7610_/Q input11/Z _6310_/S _7610_/D VDD VDD VSS VSS gf180mcu_fd_sc_mcu7t5v0__mux2_2
X_7289_ _7289_/D _7418_/CLK _7289_/Q VDD VDD VSS VSS gf180mcu_fd_sc_mcu7t5v0__dffq_1
XFILLER_57_330 VDD VDD VSS VSS gf180mcu_fd_sc_mcu7t5v0__fill_1
XFILLER_73_834 VDD VDD VSS VSS gf180mcu_fd_sc_mcu7t5v0__fill_1
XTAP_TAPCELL_ROW_86_1459 VDD VSS gf180mcu_fd_sc_mcu7t5v0__filltie
XFILLER_25_282 VDD VDD VSS VSS gf180mcu_fd_sc_mcu7t5v0__fill_2
XFILLER_5_632 VDD VDD VSS VSS gf180mcu_fd_sc_mcu7t5v0__fillcap_64
XFILLER_49_842 VDD VDD VSS VSS gf180mcu_fd_sc_mcu7t5v0__fill_2
XFILLER_64_812 VDD VDD VSS VSS gf180mcu_fd_sc_mcu7t5v0__fillcap_8
XFILLER_63_333 VDD VDD VSS VSS gf180mcu_fd_sc_mcu7t5v0__fill_1
XFILLER_17_772 VDD VDD VSS VSS gf180mcu_fd_sc_mcu7t5v0__fillcap_64
X_4990_ wire241/Z _4994_/A2 _4990_/B _7209_/D VDD VDD VSS VSS gf180mcu_fd_sc_mcu7t5v0__oai21_1
X_3941_ _6738_/Q _4252_/A2 _3942_/B VDD VDD VSS VSS gf180mcu_fd_sc_mcu7t5v0__nand2_1
XFILLER_32_731 VDD VDD VSS VSS gf180mcu_fd_sc_mcu7t5v0__fillcap_4
XTAP_TAPCELL_ROW_34_737 VDD VSS gf180mcu_fd_sc_mcu7t5v0__filltie
X_6660_ _7737_/Q _5309_/S _6660_/Z VDD VDD VSS VSS gf180mcu_fd_sc_mcu7t5v0__xor2_1
X_3872_ _7648_/Q _7647_/Q _6361_/A2 _3872_/Z VDD VDD VSS VSS gf180mcu_fd_sc_mcu7t5v0__and3_1
XTAP_TAPCELL_ROW_14_461 VDD VSS gf180mcu_fd_sc_mcu7t5v0__filltie
XTAP_TAPCELL_ROW_14_450 VDD VSS gf180mcu_fd_sc_mcu7t5v0__filltie
X_5611_ _5611_/A1 _5611_/A2 _5615_/B1 VDD VDD VSS VSS gf180mcu_fd_sc_mcu7t5v0__nor2_1
X_6591_ _6585_/Z _6591_/A2 _6591_/B _7713_/D VDD VDD VSS VSS gf180mcu_fd_sc_mcu7t5v0__oai21_1
X_5542_ _7413_/Q _5542_/A2 _5600_/A2 _7399_/Q _5543_/A3 VDD VDD VSS VSS gf180mcu_fd_sc_mcu7t5v0__oai22_1
X_5473_ _7481_/Q _5607_/A2 _5606_/B1 _7474_/Q _5475_/A1 VDD VDD VSS VSS gf180mcu_fd_sc_mcu7t5v0__oai22_1
X_4424_ _4550_/A1 _4434_/A2 _4424_/B _6926_/D VDD VDD VSS VSS gf180mcu_fd_sc_mcu7t5v0__oai21_1
XFILLER_99_731 VDD VDD VSS VSS gf180mcu_fd_sc_mcu7t5v0__fill_1
X_7212_ _7212_/D _7216_/CLK _7212_/Q VDD VDD VSS VSS gf180mcu_fd_sc_mcu7t5v0__dffq_1
X_4355_ _6892_/Q _4364_/A2 _4356_/B VDD VDD VSS VSS gf180mcu_fd_sc_mcu7t5v0__nand2_1
XFILLER_99_753 VDD VDD VSS VSS gf180mcu_fd_sc_mcu7t5v0__fill_1
XFILLER_99_742 VDD VDD VSS VSS gf180mcu_fd_sc_mcu7t5v0__fill_1
X_7143_ _7143_/D _7266_/CLK _7143_/Q VDD VDD VSS VSS gf180mcu_fd_sc_mcu7t5v0__dffq_1
Xfanout405 fanout409/Z _6192_/A2 VDD VDD VSS VSS gf180mcu_fd_sc_mcu7t5v0__dlyd_1
Xfanout438 _6301_/A2 _6262_/A2 VDD VDD VSS VSS gf180mcu_fd_sc_mcu7t5v0__dlyd_1
X_7074_ _7074_/D _7099_/CLK _7074_/Q VDD VDD VSS VSS gf180mcu_fd_sc_mcu7t5v0__dffq_1
Xfanout427 _5604_/A2 wire428/I VDD VDD VSS VSS gf180mcu_fd_sc_mcu7t5v0__dlyd_1
XTAP_TAPCELL_ROW_70_1238 VDD VSS gf180mcu_fd_sc_mcu7t5v0__filltie
X_4286_ _4832_/A1 _4294_/A2 _4286_/B _6857_/D VDD VDD VSS VSS gf180mcu_fd_sc_mcu7t5v0__oai21_1
XFILLER_95_970 VDD VDD VSS VSS gf180mcu_fd_sc_mcu7t5v0__fillcap_8
X_6025_ _7013_/Q _6151_/A2 wire313/Z _7020_/Q _6208_/C _6026_/A2 VDD VDD VSS VSS gf180mcu_fd_sc_mcu7t5v0__oai221_1
XFILLER_39_341 VDD VDD VSS VSS gf180mcu_fd_sc_mcu7t5v0__fill_1
XFILLER_58_149 VDD VDD VSS VSS gf180mcu_fd_sc_mcu7t5v0__fill_1
XFILLER_94_480 VDD VDD VSS VSS gf180mcu_fd_sc_mcu7t5v0__fill_1
XFILLER_82_664 VDD VDD VSS VSS gf180mcu_fd_sc_mcu7t5v0__fill_1
XFILLER_27_558 VDD VDD VSS VSS gf180mcu_fd_sc_mcu7t5v0__fill_2
XFILLER_70_804 VDD VDD VSS VSS gf180mcu_fd_sc_mcu7t5v0__fill_1
X_6927_ _6927_/D _7259_/CLK _6927_/Q VDD VDD VSS VSS gf180mcu_fd_sc_mcu7t5v0__dffq_1
XFILLER_70_859 VDD VDD VSS VSS gf180mcu_fd_sc_mcu7t5v0__fill_2
X_6858_ _6858_/D _7724_/CLK _6858_/Q VDD VDD VSS VSS gf180mcu_fd_sc_mcu7t5v0__dffq_1
XTAP_TAPCELL_ROW_81_1389 VDD VSS gf180mcu_fd_sc_mcu7t5v0__filltie
X_5809_ _5809_/I _5819_/B1 VDD VDD VSS VSS gf180mcu_fd_sc_mcu7t5v0__clkinv_1
X_6789_ _6789_/D _7253_/CLK _6789_/Q VDD VDD VSS VSS gf180mcu_fd_sc_mcu7t5v0__dffq_1
XFILLER_104_585 VDD VDD VSS VSS gf180mcu_fd_sc_mcu7t5v0__fill_2
XFILLER_77_458 VDD VDD VSS VSS gf180mcu_fd_sc_mcu7t5v0__fill_1
XFILLER_86_981 VDD VDD VSS VSS gf180mcu_fd_sc_mcu7t5v0__fill_1
XFILLER_46_812 VDD VDD VSS VSS gf180mcu_fd_sc_mcu7t5v0__fillcap_8
XFILLER_14_731 VDD VDD VSS VSS gf180mcu_fd_sc_mcu7t5v0__fillcap_4
XFILLER_26_580 VDD VDD VSS VSS gf180mcu_fd_sc_mcu7t5v0__fillcap_8
XTAP_TAPCELL_ROW_99_1639 VDD VSS gf180mcu_fd_sc_mcu7t5v0__filltie
XFILLER_10_981 VDD VDD VSS VSS gf180mcu_fd_sc_mcu7t5v0__fill_1
Xclkload15 _7472_/CLK clkload15/ZN VDD VDD VSS VSS gf180mcu_fd_sc_mcu7t5v0__inv_3
Xclkload26 _7735_/CLK clkload26/Z VDD VDD VSS VSS gf180mcu_fd_sc_mcu7t5v0__clkbuf_4
Xclkload48 _7687_/CLK clkload48/Z VDD VDD VSS VSS gf180mcu_fd_sc_mcu7t5v0__clkbuf_4
Xclkload37 _7711_/CLK clkload37/Z VDD VDD VSS VSS gf180mcu_fd_sc_mcu7t5v0__clkbuf_2
XFILLER_6_941 VDD VDD VSS VSS gf180mcu_fd_sc_mcu7t5v0__fillcap_4
Xclkload59 _7217_/CLK clkload59/Z VDD VDD VSS VSS gf180mcu_fd_sc_mcu7t5v0__clkbuf_2
XFILLER_96_723 VDD VDD VSS VSS gf180mcu_fd_sc_mcu7t5v0__fill_2
X_4140_ _4140_/A1 _5075_/A2 _4140_/B _6797_/D VDD VDD VSS VSS gf180mcu_fd_sc_mcu7t5v0__aoi21_1
XFILLER_69_959 VDD VDD VSS VSS gf180mcu_fd_sc_mcu7t5v0__fillcap_16
X_4071_ _4071_/A1 _4770_/A2 _4071_/B _6775_/D VDD VDD VSS VSS gf180mcu_fd_sc_mcu7t5v0__oai21_1
XTAP_TAPCELL_ROW_39_807 VDD VSS gf180mcu_fd_sc_mcu7t5v0__filltie
XTAP_TAPCELL_ROW_19_531 VDD VSS gf180mcu_fd_sc_mcu7t5v0__filltie
XTAP_TAPCELL_ROW_19_520 VDD VSS gf180mcu_fd_sc_mcu7t5v0__filltie
XTAP_TAPCELL_ROW_108_1768 VDD VSS gf180mcu_fd_sc_mcu7t5v0__filltie
XFILLER_52_804 VDD VDD VSS VSS gf180mcu_fd_sc_mcu7t5v0__fill_1
X_7761_ _7761_/D _7810_/RN _7804_/CLK _7761_/Q VDD VDD VSS VSS gf180mcu_fd_sc_mcu7t5v0__dffrnq_1
X_4973_ _7201_/Q _4980_/A2 _4974_/B VDD VDD VSS VSS gf180mcu_fd_sc_mcu7t5v0__nand2_1
XFILLER_63_185 VDD VDD VSS VSS gf180mcu_fd_sc_mcu7t5v0__fill_1
X_7692_ _7692_/D _7694_/RN _7692_/CLK _7692_/Q VDD VDD VSS VSS gf180mcu_fd_sc_mcu7t5v0__dffrnq_1
X_6712_ _7754_/Q _6716_/A2 _6714_/B1 _7755_/Q _6713_/I VDD VDD VSS VSS gf180mcu_fd_sc_mcu7t5v0__aoi22_1
X_3924_ _7719_/Q _7720_/Q _7721_/Q _4147_/A1 VDD VDD VSS VSS gf180mcu_fd_sc_mcu7t5v0__nor3_2
X_6643_ _6643_/A1 _6643_/A2 _7730_/D VDD VDD VSS VSS gf180mcu_fd_sc_mcu7t5v0__nor2_1
Xclkload9 clkload9/I clkload9/Z VDD VDD VSS VSS gf180mcu_fd_sc_mcu7t5v0__clkbuf_4
X_3855_ _3930_/A1 _6679_/I0 _3856_/B VDD VDD VSS VSS gf180mcu_fd_sc_mcu7t5v0__nand2_1
XFILLER_118_611 VDD VDD VSS VSS gf180mcu_fd_sc_mcu7t5v0__fill_1
X_6574_ _7709_/Q _7708_/Q _6574_/S _7709_/D VDD VDD VSS VSS gf180mcu_fd_sc_mcu7t5v0__mux2_2
X_3786_ _6566_/S _7738_/Q _7739_/Q _3786_/Z VDD VDD VSS VSS gf180mcu_fd_sc_mcu7t5v0__and3_1
X_5525_ _7512_/Q _6732_/A1 _6624_/A2 _5621_/A1 _6728_/B _5526_/A2 VDD VDD VSS VSS
+ gf180mcu_fd_sc_mcu7t5v0__oai221_1
X_5456_ _5609_/B _5456_/A2 _5456_/A3 _5460_/B1 VDD VDD VSS VSS gf180mcu_fd_sc_mcu7t5v0__nor3_1
X_4407_ _6918_/Q _4420_/A2 _4408_/B VDD VDD VSS VSS gf180mcu_fd_sc_mcu7t5v0__nand2_1
XFILLER_99_572 VDD VDD VSS VSS gf180mcu_fd_sc_mcu7t5v0__fill_2
X_5387_ _7366_/Q _5600_/A2 _5600_/B1 _7373_/Q _7380_/Q _5600_/C2 _5388_/A2 VDD VDD
+ VSS VSS gf180mcu_fd_sc_mcu7t5v0__oai222_1
X_4338_ _4506_/A1 _4350_/A2 _4338_/B _6883_/D VDD VDD VSS VSS gf180mcu_fd_sc_mcu7t5v0__oai21_1
Xfanout235 _3865_/ZN _4948_/A1 VDD VDD VSS VSS gf180mcu_fd_sc_mcu7t5v0__dlyd_1
X_7126_ _7126_/D _7196_/CLK _7126_/Q VDD VDD VSS VSS gf180mcu_fd_sc_mcu7t5v0__dffq_1
X_7057_ _7057_/D _7064_/CLK _7057_/Q VDD VDD VSS VSS gf180mcu_fd_sc_mcu7t5v0__dffq_1
X_4269_ _6849_/Q _4280_/A2 _4270_/B VDD VDD VSS VSS gf180mcu_fd_sc_mcu7t5v0__nand2_1
Xfanout279 wire283/Z _5122_/A1 VDD VDD VSS VSS gf180mcu_fd_sc_mcu7t5v0__dlyd_1
XFILLER_87_767 VDD VDD VSS VSS gf180mcu_fd_sc_mcu7t5v0__fill_2
XFILLER_28_801 VDD VDD VSS VSS gf180mcu_fd_sc_mcu7t5v0__fillcap_4
X_6008_ _7069_/Q _6192_/A2 _6008_/B1 _6838_/Q _6010_/A1 VDD VDD VSS VSS gf180mcu_fd_sc_mcu7t5v0__oai22_1
XFILLER_68_981 VDD VDD VSS VSS gf180mcu_fd_sc_mcu7t5v0__fill_1
XTAP_TAPCELL_ROW_83_1418 VDD VSS gf180mcu_fd_sc_mcu7t5v0__filltie
XFILLER_70_601 VDD VDD VSS VSS gf180mcu_fd_sc_mcu7t5v0__fill_1
XFILLER_30_509 VDD VDD VSS VSS gf180mcu_fd_sc_mcu7t5v0__fill_1
XFILLER_10_244 VDD VDD VSS VSS gf180mcu_fd_sc_mcu7t5v0__fill_1
XFILLER_10_255 VDD VDD VSS VSS gf180mcu_fd_sc_mcu7t5v0__fill_1
XFILLER_109_688 VDD VDD VSS VSS gf180mcu_fd_sc_mcu7t5v0__fill_2
XFILLER_109_677 VDD VDD VSS VSS gf180mcu_fd_sc_mcu7t5v0__fill_2
XTAP_TAPCELL_ROW_94_1569 VDD VSS gf180mcu_fd_sc_mcu7t5v0__filltie
XFILLER_46_664 VDD VDD VSS VSS gf180mcu_fd_sc_mcu7t5v0__fill_1
XFILLER_65_72 VDD VDD VSS VSS gf180mcu_fd_sc_mcu7t5v0__fill_1
XTAP_TAPCELL_ROW_44_876 VDD VSS gf180mcu_fd_sc_mcu7t5v0__filltie
XTAP_TAPCELL_ROW_103_1698 VDD VSS gf180mcu_fd_sc_mcu7t5v0__filltie
XFILLER_14_594 VDD VDD VSS VSS gf180mcu_fd_sc_mcu7t5v0__fill_1
X_3640_ _3640_/A1 _3636_/Z _3639_/Z _3640_/Z VDD VDD VSS VSS gf180mcu_fd_sc_mcu7t5v0__xor3_1
X_3571_ input87/Z input86/Z _3611_/A1 VDD VDD VSS VSS gf180mcu_fd_sc_mcu7t5v0__xnor2_1
X_6290_ _6290_/A1 _6298_/A2 _6300_/B1 _6290_/B2 _7597_/D VDD VDD VSS VSS gf180mcu_fd_sc_mcu7t5v0__aoi22_1
X_5310_ _6353_/I0 _7457_/Q _5316_/S _7457_/D VDD VDD VSS VSS gf180mcu_fd_sc_mcu7t5v0__mux2_2
XTAP_TAPCELL_ROW_54_1008 VDD VSS gf180mcu_fd_sc_mcu7t5v0__filltie
X_5241_ _5332_/I0 _7388_/Q _5246_/S _7388_/D VDD VDD VSS VSS gf180mcu_fd_sc_mcu7t5v0__mux2_2
XFILLER_46_2 VDD VDD VSS VSS gf180mcu_fd_sc_mcu7t5v0__fill_2
XTAP_TAPCELL_ROW_54_1019 VDD VSS gf180mcu_fd_sc_mcu7t5v0__filltie
X_5172_ _5228_/I0 _7319_/Q _5176_/S _7319_/D VDD VDD VSS VSS gf180mcu_fd_sc_mcu7t5v0__mux2_2
XFILLER_111_842 VDD VDD VSS VSS gf180mcu_fd_sc_mcu7t5v0__fillcap_64
X_4123_ _4123_/A1 _4135_/A2 _5008_/A2 VDD VDD VSS VSS gf180mcu_fd_sc_mcu7t5v0__nand2_1
X_4054_ _6770_/Q _4700_/A2 _4055_/B VDD VDD VSS VSS gf180mcu_fd_sc_mcu7t5v0__nand2_1
XFILLER_84_737 VDD VDD VSS VSS gf180mcu_fd_sc_mcu7t5v0__fillcap_4
Xinput2 alert_rx_i[1] input2/Z VDD VDD VSS VSS gf180mcu_fd_sc_mcu7t5v0__dlyd_1
XFILLER_80_943 VDD VDD VSS VSS gf180mcu_fd_sc_mcu7t5v0__fill_2
X_7813_ _7813_/D _7822_/RN _7823_/CLK _7816_/D VDD VDD VSS VSS gf180mcu_fd_sc_mcu7t5v0__dffrnq_1
XFILLER_36_174 VDD VDD VSS VSS gf180mcu_fd_sc_mcu7t5v0__fill_1
XFILLER_24_369 VDD VDD VSS VSS gf180mcu_fd_sc_mcu7t5v0__fill_1
XFILLER_40_807 VDD VDD VSS VSS gf180mcu_fd_sc_mcu7t5v0__fillcap_64
X_7744_ _7744_/D _7755_/RN _7754_/CLK _7744_/Q VDD VDD VSS VSS gf180mcu_fd_sc_mcu7t5v0__dffrnq_1
X_4956_ wire268/I _4966_/A2 _4956_/B _7192_/D VDD VDD VSS VSS gf180mcu_fd_sc_mcu7t5v0__oai21_1
X_3907_ _7600_/Q _3830_/Z _3907_/Z VDD VDD VSS VSS gf180mcu_fd_sc_mcu7t5v0__xor2_1
X_4887_ _7158_/Q _4896_/A2 _4888_/B VDD VDD VSS VSS gf180mcu_fd_sc_mcu7t5v0__nand2_1
X_7675_ _7675_/D _7701_/RN _7802_/CLK _7675_/Q VDD VDD VSS VSS gf180mcu_fd_sc_mcu7t5v0__dffrnq_1
X_3838_ _7575_/Q _7573_/Q _7576_/Q _3838_/Z VDD VDD VSS VSS gf180mcu_fd_sc_mcu7t5v0__xor3_1
X_6626_ _7783_/Q _7552_/Q _6658_/A2 VDD VDD VSS VSS gf180mcu_fd_sc_mcu7t5v0__nand2_1
X_6557_ _7695_/Q _6555_/Z _6559_/A2 VDD VDD VSS VSS gf180mcu_fd_sc_mcu7t5v0__nor2_1
XFILLER_20_597 VDD VDD VSS VSS gf180mcu_fd_sc_mcu7t5v0__fillcap_64
X_5508_ _7482_/Q _5511_/B1 _5606_/B1 _7475_/Q _5508_/C _5509_/A2 VDD VDD VSS VSS gf180mcu_fd_sc_mcu7t5v0__oai221_1
X_3769_ _7567_/Q _7559_/Q _7806_/D VDD VDD VSS VSS gf180mcu_fd_sc_mcu7t5v0__and2_1
X_6488_ _7801_/Q _6488_/A2 _6488_/B _6488_/C _6521_/A2 VDD VDD VSS VSS gf180mcu_fd_sc_mcu7t5v0__aoi211_1
X_5439_ _7466_/Q _5613_/B1 _5559_/B1 _7473_/Q _7480_/Q _5610_/B1 _5440_/A2 VDD VDD
+ VSS VSS gf180mcu_fd_sc_mcu7t5v0__oai222_1
XFILLER_75_704 VDD VDD VSS VSS gf180mcu_fd_sc_mcu7t5v0__fill_1
X_7109_ _7109_/D _7196_/CLK _7109_/Q VDD VDD VSS VSS gf180mcu_fd_sc_mcu7t5v0__dffq_1
XFILLER_47_417 VDD VDD VSS VSS gf180mcu_fd_sc_mcu7t5v0__fill_2
XFILLER_48_929 VDD VDD VSS VSS gf180mcu_fd_sc_mcu7t5v0__fillcap_16
XTAP_TAPCELL_ROW_2_284 VDD VSS gf180mcu_fd_sc_mcu7t5v0__filltie
XFILLER_43_689 VDD VDD VSS VSS gf180mcu_fd_sc_mcu7t5v0__fillcap_4
XTAP_TAPCELL_ROW_41_835 VDD VSS gf180mcu_fd_sc_mcu7t5v0__filltie
XTAP_TAPCELL_ROW_96_1609 VDD VSS gf180mcu_fd_sc_mcu7t5v0__filltie
XFILLER_97_328 VDD VDD VSS VSS gf180mcu_fd_sc_mcu7t5v0__fill_2
XPHY_EDGE_ROW_29_Left_148 VDD VSS gf180mcu_fd_sc_mcu7t5v0__endcap
Xclkbuf_3_2__f_clk_i clkbuf_0_clk_i/Z clkload1/I VDD VDD VSS VSS gf180mcu_fd_sc_mcu7t5v0__clkbuf_16
XTAP_TAPCELL_ROW_49_946 VDD VSS gf180mcu_fd_sc_mcu7t5v0__filltie
XTAP_TAPCELL_ROW_105_1727 VDD VSS gf180mcu_fd_sc_mcu7t5v0__filltie
XFILLER_74_792 VDD VDD VSS VSS gf180mcu_fd_sc_mcu7t5v0__fill_1
XTAP_TAPCELL_ROW_29_670 VDD VSS gf180mcu_fd_sc_mcu7t5v0__filltie
XPHY_EDGE_ROW_1_Left_120 VDD VSS gf180mcu_fd_sc_mcu7t5v0__endcap
XFILLER_22_807 VDD VDD VSS VSS gf180mcu_fd_sc_mcu7t5v0__fillcap_64
XFILLER_34_667 VDD VDD VSS VSS gf180mcu_fd_sc_mcu7t5v0__fillcap_64
X_4810_ _4824_/A1 _4812_/A2 _4810_/B _7119_/D VDD VDD VSS VSS gf180mcu_fd_sc_mcu7t5v0__oai21_1
XPHY_EDGE_ROW_38_Left_157 VDD VSS gf180mcu_fd_sc_mcu7t5v0__endcap
X_5790_ _7149_/Q _6104_/A2 _6236_/A2 _7128_/Q _6238_/B _5791_/A2 VDD VDD VSS VSS gf180mcu_fd_sc_mcu7t5v0__oai221_1
X_4741_ _7085_/Q _4742_/A2 _4742_/B VDD VDD VSS VSS gf180mcu_fd_sc_mcu7t5v0__nand2_1
X_4672_ wire291/Z _4672_/A2 _4672_/B _7050_/D VDD VDD VSS VSS gf180mcu_fd_sc_mcu7t5v0__oai21_1
X_7460_ _7460_/D _7822_/CLK _7460_/Q VDD VDD VSS VSS gf180mcu_fd_sc_mcu7t5v0__dffq_1
X_6411_ _7660_/Q _7526_/Q _6399_/Z _6411_/B2 _6411_/C _6421_/A3 VDD VDD VSS VSS gf180mcu_fd_sc_mcu7t5v0__aoi221_1
X_3623_ input35/Z input51/Z input37/Z _3623_/Z VDD VDD VSS VSS gf180mcu_fd_sc_mcu7t5v0__xor3_1
X_7391_ _7391_/D _7472_/CLK _7391_/Q VDD VDD VSS VSS gf180mcu_fd_sc_mcu7t5v0__dffq_1
XFILLER_115_422 VDD VDD VSS VSS gf180mcu_fd_sc_mcu7t5v0__fill_1
X_6342_ input48/Z _6344_/S _6343_/B VDD VDD VSS VSS gf180mcu_fd_sc_mcu7t5v0__nand2_1
X_3554_ input36/Z input34/Z _3554_/Z VDD VDD VSS VSS gf180mcu_fd_sc_mcu7t5v0__xor2_1
XTAP_TAPCELL_ROW_116_1889 VDD VSS gf180mcu_fd_sc_mcu7t5v0__filltie
XTAP_TAPCELL_ROW_116_1878 VDD VSS gf180mcu_fd_sc_mcu7t5v0__filltie
X_6273_ _7632_/Q _6285_/A2 _6283_/B1 _7797_/D _6283_/C1 _7522_/Q _6274_/B2 VDD VDD
+ VSS VSS gf180mcu_fd_sc_mcu7t5v0__aoi222_1
X_3485_ _6134_/C _7721_/Q _3494_/B VDD VDD VSS VSS gf180mcu_fd_sc_mcu7t5v0__nand2_1
XPHY_EDGE_ROW_47_Left_166 VDD VSS gf180mcu_fd_sc_mcu7t5v0__endcap
X_5224_ _5245_/I0 _7371_/Q _5225_/S _7371_/D VDD VDD VSS VSS gf180mcu_fd_sc_mcu7t5v0__mux2_2
X_5155_ wire513/Z _7302_/Q _5155_/S _7302_/D VDD VDD VSS VSS gf180mcu_fd_sc_mcu7t5v0__mux2_2
XFILLER_57_715 VDD VDD VSS VSS gf180mcu_fd_sc_mcu7t5v0__fill_1
X_5086_ _5086_/A1 _5092_/A2 _5086_/B _7257_/D VDD VDD VSS VSS gf180mcu_fd_sc_mcu7t5v0__oai21_1
X_4106_ _4112_/A1 _4924_/A2 _4106_/B _6786_/D VDD VDD VSS VSS gf180mcu_fd_sc_mcu7t5v0__oai21_1
XFILLER_56_214 VDD VDD VSS VSS gf180mcu_fd_sc_mcu7t5v0__fill_1
X_4037_ _4071_/A1 _4616_/A2 _4037_/B _6764_/D VDD VDD VSS VSS gf180mcu_fd_sc_mcu7t5v0__oai21_1
XFILLER_53_976 VDD VDD VSS VSS gf180mcu_fd_sc_mcu7t5v0__fillcap_4
XPHY_EDGE_ROW_56_Left_175 VDD VSS gf180mcu_fd_sc_mcu7t5v0__endcap
X_5988_ _5988_/A1 _5988_/A2 _6122_/C _5995_/A2 VDD VDD VSS VSS gf180mcu_fd_sc_mcu7t5v0__oai21_1
XFILLER_12_317 VDD VDD VSS VSS gf180mcu_fd_sc_mcu7t5v0__fill_2
X_7727_ _7727_/D _7736_/RN _7734_/CLK _7727_/Q VDD VDD VSS VSS gf180mcu_fd_sc_mcu7t5v0__dffrnq_1
X_4939_ _7184_/Q _4952_/A2 _4940_/B VDD VDD VSS VSS gf180mcu_fd_sc_mcu7t5v0__nand2_1
X_7658_ _7658_/D _7660_/RN _7671_/CLK _7658_/Q VDD VDD VSS VSS gf180mcu_fd_sc_mcu7t5v0__dffrnq_1
X_6609_ _6609_/A1 _3937_/I _6612_/A2 VDD VDD VSS VSS gf180mcu_fd_sc_mcu7t5v0__nor2_1
XFILLER_107_912 VDD VDD VSS VSS gf180mcu_fd_sc_mcu7t5v0__fillcap_64
X_7589_ _7589_/D _7589_/RN _7613_/CLK _7589_/Q VDD VDD VSS VSS gf180mcu_fd_sc_mcu7t5v0__dffrnq_1
XFILLER_4_527 VDD VDD VSS VSS gf180mcu_fd_sc_mcu7t5v0__fillcap_64
XPHY_EDGE_ROW_65_Left_184 VDD VSS gf180mcu_fd_sc_mcu7t5v0__endcap
XTAP_TAPCELL_ROW_91_1528 VDD VSS gf180mcu_fd_sc_mcu7t5v0__filltie
XTAP_TAPCELL_ROW_91_1539 VDD VSS gf180mcu_fd_sc_mcu7t5v0__filltie
Xoutput180 _3842_/Z tl_o[6] VDD VDD VSS VSS gf180mcu_fd_sc_mcu7t5v0__dlyd_1
XTAP_TAPCELL_ROW_7_354 VDD VSS gf180mcu_fd_sc_mcu7t5v0__filltie
XFILLER_75_545 VDD VDD VSS VSS gf180mcu_fd_sc_mcu7t5v0__fill_2
XTAP_TAPCELL_ROW_46_905 VDD VSS gf180mcu_fd_sc_mcu7t5v0__filltie
XPHY_EDGE_ROW_74_Left_193 VDD VSS gf180mcu_fd_sc_mcu7t5v0__endcap
XFILLER_56_770 VDD VDD VSS VSS gf180mcu_fd_sc_mcu7t5v0__fill_2
XFILLER_16_667 VDD VDD VSS VSS gf180mcu_fd_sc_mcu7t5v0__fillcap_64
XFILLER_31_626 VDD VDD VSS VSS gf180mcu_fd_sc_mcu7t5v0__fillcap_4
XFILLER_30_136 VDD VDD VSS VSS gf180mcu_fd_sc_mcu7t5v0__fill_1
XTAP_TAPCELL_ROW_100_1657 VDD VSS gf180mcu_fd_sc_mcu7t5v0__filltie
Xwire241 wire241/I wire241/Z VDD VDD VSS VSS gf180mcu_fd_sc_mcu7t5v0__clkbuf_4
XFILLER_8_877 VDD VDD VSS VSS gf180mcu_fd_sc_mcu7t5v0__fillcap_64
Xload_slew213 _5126_/A1 _5014_/A1 VDD VDD VSS VSS gf180mcu_fd_sc_mcu7t5v0__buf_4
Xload_slew202 _5686_/S _5687_/S VDD VDD VSS VSS gf180mcu_fd_sc_mcu7t5v0__buf_4
Xload_slew246 _4140_/A1 _4125_/A1 VDD VDD VSS VSS gf180mcu_fd_sc_mcu7t5v0__buf_2
Xload_slew224 _4950_/A1 _4880_/A1 VDD VDD VSS VSS gf180mcu_fd_sc_mcu7t5v0__clkbuf_4
Xload_slew257 _4918_/A1 _4988_/A1 VDD VDD VSS VSS gf180mcu_fd_sc_mcu7t5v0__clkbuf_4
X_6960_ _6960_/D _7003_/CLK _6960_/Q VDD VDD VSS VSS gf180mcu_fd_sc_mcu7t5v0__dffq_1
XFILLER_94_887 VDD VDD VSS VSS gf180mcu_fd_sc_mcu7t5v0__fill_1
X_5911_ _6892_/Q _6076_/B1 _6212_/C _5913_/A1 VDD VDD VSS VSS gf180mcu_fd_sc_mcu7t5v0__oai21_1
X_6891_ _6891_/D _6939_/CLK _6891_/Q VDD VDD VSS VSS gf180mcu_fd_sc_mcu7t5v0__dffq_1
XFILLER_35_976 VDD VDD VSS VSS gf180mcu_fd_sc_mcu7t5v0__fillcap_4
X_5842_ _6933_/Q wire355/Z _6085_/B1 _6926_/Q _6195_/C _5846_/A2 VDD VDD VSS VSS gf180mcu_fd_sc_mcu7t5v0__oai221_1
X_5773_ _6848_/Q _6092_/C2 _6092_/A2 _7268_/Q _6197_/B _5774_/A2 VDD VDD VSS VSS gf180mcu_fd_sc_mcu7t5v0__oai221_1
XTAP_TAPCELL_ROW_62_1129 VDD VSS gf180mcu_fd_sc_mcu7t5v0__filltie
X_4724_ _4752_/A1 _4728_/A2 _4724_/B _7076_/D VDD VDD VSS VSS gf180mcu_fd_sc_mcu7t5v0__oai21_1
X_7512_ _7512_/D _7652_/RN _7765_/CLK _7512_/Q VDD VDD VSS VSS gf180mcu_fd_sc_mcu7t5v0__dffsnq_1
XFILLER_50_979 VDD VDD VSS VSS gf180mcu_fd_sc_mcu7t5v0__fill_2
XTAP_TAPCELL_ROW_118_1918 VDD VSS gf180mcu_fd_sc_mcu7t5v0__filltie
XTAP_TAPCELL_ROW_118_1907 VDD VSS gf180mcu_fd_sc_mcu7t5v0__filltie
XTAP_TAPCELL_ROW_118_1929 VDD VSS gf180mcu_fd_sc_mcu7t5v0__filltie
X_4655_ _7042_/Q _4658_/A2 _4656_/B VDD VDD VSS VSS gf180mcu_fd_sc_mcu7t5v0__nand2_1
X_7443_ _7443_/D _7736_/CLK _7443_/Q VDD VDD VSS VSS gf180mcu_fd_sc_mcu7t5v0__dffq_1
X_4586_ _5118_/A1 _4588_/A2 _4586_/B _7007_/D VDD VDD VSS VSS gf180mcu_fd_sc_mcu7t5v0__oai21_1
Xinput82 tl_i[77] input82/Z VDD VDD VSS VSS gf180mcu_fd_sc_mcu7t5v0__dlyd_1
Xinput71 tl_i[67] _7879_/I VDD VDD VSS VSS gf180mcu_fd_sc_mcu7t5v0__dlyd_1
Xinput60 tl_i[57] input60/Z VDD VDD VSS VSS gf180mcu_fd_sc_mcu7t5v0__dlyd_1
X_3606_ input80/Z input79/Z input81/Z _3606_/Z VDD VDD VSS VSS gf180mcu_fd_sc_mcu7t5v0__xor3_1
X_7374_ _7374_/D _7472_/CLK _7374_/Q VDD VDD VSS VSS gf180mcu_fd_sc_mcu7t5v0__dffq_1
Xinput93 tl_i[87] input93/Z VDD VDD VSS VSS gf180mcu_fd_sc_mcu7t5v0__dlyd_1
X_3537_ _3385_/I _3386_/I _3537_/Z VDD VDD VSS VSS gf180mcu_fd_sc_mcu7t5v0__xor2_1
X_6325_ _7620_/Q input35/Z _6325_/S _7620_/D VDD VDD VSS VSS gf180mcu_fd_sc_mcu7t5v0__mux2_2
X_6256_ _7542_/Q _6256_/A2 _6268_/B1 _7705_/Q _6271_/B1 _7624_/Q _6257_/B2 VDD VDD
+ VSS VSS gf180mcu_fd_sc_mcu7t5v0__aoi222_1
X_3468_ _7769_/D _3793_/B VDD VDD VSS VSS gf180mcu_fd_sc_mcu7t5v0__clkinv_1
Xclkbuf_leaf_62_clk_i clkload3/I _7189_/CLK VDD VDD VSS VSS gf180mcu_fd_sc_mcu7t5v0__clkbuf_8
XFILLER_112_981 VDD VDD VSS VSS gf180mcu_fd_sc_mcu7t5v0__fill_1
XFILLER_97_670 VDD VDD VSS VSS gf180mcu_fd_sc_mcu7t5v0__fillcap_4
X_6187_ _7538_/Q _6283_/C1 _6271_/B1 _7621_/Q _6189_/A3 VDD VDD VSS VSS gf180mcu_fd_sc_mcu7t5v0__aoi22_1
XTAP_TAPCELL_ROW_4_313 VDD VSS gf180mcu_fd_sc_mcu7t5v0__filltie
X_5207_ _5235_/I0 _7354_/Q _5211_/S _7354_/D VDD VDD VSS VSS gf180mcu_fd_sc_mcu7t5v0__mux2_2
X_3399_ _7619_/Q _6324_/A1 VDD VDD VSS VSS gf180mcu_fd_sc_mcu7t5v0__clkinv_1
XFILLER_85_832 VDD VDD VSS VSS gf180mcu_fd_sc_mcu7t5v0__fillcap_8
X_5138_ _5341_/I0 _7285_/Q _5141_/S _7285_/D VDD VDD VSS VSS gf180mcu_fd_sc_mcu7t5v0__mux2_2
XFILLER_84_364 VDD VDD VSS VSS gf180mcu_fd_sc_mcu7t5v0__fill_1
Xclkbuf_leaf_77_clk_i clkbuf_3_1__f_clk_i/Z _7735_/CLK VDD VDD VSS VSS gf180mcu_fd_sc_mcu7t5v0__clkbuf_8
X_5069_ _7249_/Q _5074_/A2 _5070_/B VDD VDD VSS VSS gf180mcu_fd_sc_mcu7t5v0__nor2_1
XTAP_TAPCELL_ROW_88_1490 VDD VSS gf180mcu_fd_sc_mcu7t5v0__filltie
XFILLER_13_626 VDD VDD VSS VSS gf180mcu_fd_sc_mcu7t5v0__fillcap_4
XTAP_TAPCELL_ROW_51_974 VDD VSS gf180mcu_fd_sc_mcu7t5v0__filltie
Xclkbuf_leaf_15_clk_i clkload2/I _7802_/CLK VDD VDD VSS VSS gf180mcu_fd_sc_mcu7t5v0__clkbuf_8
XFILLER_5_836 VDD VDD VSS VSS gf180mcu_fd_sc_mcu7t5v0__fillcap_4
XFILLER_107_742 VDD VDD VSS VSS gf180mcu_fd_sc_mcu7t5v0__fillcap_4
XPHY_EDGE_ROW_82_Left_201 VDD VSS gf180mcu_fd_sc_mcu7t5v0__endcap
XFILLER_17_976 VDD VDD VSS VSS gf180mcu_fd_sc_mcu7t5v0__fillcap_4
XFILLER_32_979 VDD VDD VSS VSS gf180mcu_fd_sc_mcu7t5v0__fill_2
XPHY_EDGE_ROW_91_Left_210 VDD VSS gf180mcu_fd_sc_mcu7t5v0__endcap
X_4440_ _5056_/A1 _4448_/A2 _4440_/B _6934_/D VDD VDD VSS VSS gf180mcu_fd_sc_mcu7t5v0__oai21_1
XFILLER_113_712 VDD VDD VSS VSS gf180mcu_fd_sc_mcu7t5v0__fill_1
XTAP_TAPCELL_ROW_113_1837 VDD VSS gf180mcu_fd_sc_mcu7t5v0__filltie
X_4371_ _6900_/Q _4378_/A2 _4372_/B VDD VDD VSS VSS gf180mcu_fd_sc_mcu7t5v0__nand2_1
XTAP_TAPCELL_ROW_59_1080 VDD VSS gf180mcu_fd_sc_mcu7t5v0__filltie
XTAP_TAPCELL_ROW_59_1091 VDD VSS gf180mcu_fd_sc_mcu7t5v0__filltie
X_6110_ _7119_/Q _6174_/A2 _6112_/A2 _7112_/Q _6115_/A1 VDD VDD VSS VSS gf180mcu_fd_sc_mcu7t5v0__oai22_1
X_7090_ _7090_/D _7097_/CLK _7090_/Q VDD VDD VSS VSS gf180mcu_fd_sc_mcu7t5v0__dffq_1
X_6041_ _6999_/Q _6222_/B1 _6090_/C _6046_/A1 VDD VDD VSS VSS gf180mcu_fd_sc_mcu7t5v0__oai21_1
XFILLER_39_534 VDD VDD VSS VSS gf180mcu_fd_sc_mcu7t5v0__fillcap_16
X_6943_ _6943_/D _7055_/CLK _6943_/Q VDD VDD VSS VSS gf180mcu_fd_sc_mcu7t5v0__dffq_1
X_6874_ _6874_/D _7279_/CLK _6874_/Q VDD VDD VSS VSS gf180mcu_fd_sc_mcu7t5v0__dffq_1
XTAP_TAPCELL_ROW_37_779 VDD VSS gf180mcu_fd_sc_mcu7t5v0__filltie
X_5825_ _7143_/Q wire322/I _6221_/B _5827_/A1 VDD VDD VSS VSS gf180mcu_fd_sc_mcu7t5v0__oai21_1
XTAP_TAPCELL_ROW_17_492 VDD VSS gf180mcu_fd_sc_mcu7t5v0__filltie
X_5756_ _7107_/Q _6112_/A2 _6214_/B _5758_/B1 VDD VDD VSS VSS gf180mcu_fd_sc_mcu7t5v0__oai21_1
X_4707_ _7068_/Q _4714_/A2 _4708_/B VDD VDD VSS VSS gf180mcu_fd_sc_mcu7t5v0__nand2_1
X_5687_ _7561_/Q input29/Z _5687_/S _7561_/D VDD VDD VSS VSS gf180mcu_fd_sc_mcu7t5v0__mux2_2
X_4638_ _4708_/A1 _4644_/A2 _4638_/B _7033_/D VDD VDD VSS VSS gf180mcu_fd_sc_mcu7t5v0__oai21_1
XTAP_TAPCELL_ROW_75_1309 VDD VSS gf180mcu_fd_sc_mcu7t5v0__filltie
X_7426_ _7426_/D _7451_/CLK _7426_/Q VDD VDD VSS VSS gf180mcu_fd_sc_mcu7t5v0__dffq_1
X_4569_ _6999_/Q _4574_/A2 _4570_/B VDD VDD VSS VSS gf180mcu_fd_sc_mcu7t5v0__nand2_1
X_7357_ _7357_/D _7378_/CLK _7357_/Q VDD VDD VSS VSS gf180mcu_fd_sc_mcu7t5v0__dffq_1
XFILLER_116_594 VDD VDD VSS VSS gf180mcu_fd_sc_mcu7t5v0__fill_1
XFILLER_104_734 VDD VDD VSS VSS gf180mcu_fd_sc_mcu7t5v0__fill_1
X_6308_ _7609_/Q input10/Z _6310_/S _7609_/D VDD VDD VSS VSS gf180mcu_fd_sc_mcu7t5v0__mux2_2
XFILLER_89_456 VDD VDD VSS VSS gf180mcu_fd_sc_mcu7t5v0__fill_2
X_7288_ _7288_/D _7483_/CLK _7288_/Q VDD VDD VSS VSS gf180mcu_fd_sc_mcu7t5v0__dffq_1
XFILLER_89_489 VDD VDD VSS VSS gf180mcu_fd_sc_mcu7t5v0__fill_1
X_6239_ _6780_/Q _6241_/A2 _6239_/B1 _6781_/Q _6784_/Q _6242_/A2 _6240_/A2 VDD VDD
+ VSS VSS gf180mcu_fd_sc_mcu7t5v0__oai222_1
XFILLER_72_389 VDD VDD VSS VSS gf180mcu_fd_sc_mcu7t5v0__fill_1
XFILLER_53_592 VDD VDD VSS VSS gf180mcu_fd_sc_mcu7t5v0__fill_1
XFILLER_14_979 VDD VDD VSS VSS gf180mcu_fd_sc_mcu7t5v0__fill_2
XFILLER_13_456 VDD VDD VSS VSS gf180mcu_fd_sc_mcu7t5v0__fill_2
XFILLER_13_489 VDD VDD VSS VSS gf180mcu_fd_sc_mcu7t5v0__fill_1
XFILLER_110_737 VDD VDD VSS VSS gf180mcu_fd_sc_mcu7t5v0__fill_1
XFILLER_48_375 VDD VDD VSS VSS gf180mcu_fd_sc_mcu7t5v0__fill_2
X_3940_ _4114_/A1 _4144_/A1 _4252_/A2 VDD VDD VSS VSS gf180mcu_fd_sc_mcu7t5v0__nand2_1
XTAP_TAPCELL_ROW_34_738 VDD VSS gf180mcu_fd_sc_mcu7t5v0__filltie
X_3871_ _3871_/A1 _3877_/A1 _3871_/A3 _6361_/A2 VDD VDD VSS VSS gf180mcu_fd_sc_mcu7t5v0__nor3_1
XTAP_TAPCELL_ROW_14_451 VDD VSS gf180mcu_fd_sc_mcu7t5v0__filltie
X_5610_ _6808_/Q _5612_/A2 _5610_/B1 _6807_/Q _6806_/Q _5610_/C2 _5611_/A2 VDD VDD
+ VSS VSS gf180mcu_fd_sc_mcu7t5v0__oai222_1
X_6590_ _6593_/A2 _6590_/A2 _6591_/A2 VDD VDD VSS VSS gf180mcu_fd_sc_mcu7t5v0__nand2_1
X_5541_ _7420_/Q _5597_/A2 _5597_/B1 _7406_/Q _5543_/A2 VDD VDD VSS VSS gf180mcu_fd_sc_mcu7t5v0__oai22_1
X_5472_ _5508_/C _5472_/A2 _5472_/A3 _5584_/S _5479_/B2 VDD VDD VSS VSS gf180mcu_fd_sc_mcu7t5v0__oai31_1
X_7211_ _7211_/D _7216_/CLK _7211_/Q VDD VDD VSS VSS gf180mcu_fd_sc_mcu7t5v0__dffq_1
X_4423_ _6926_/Q _4434_/A2 _4424_/B VDD VDD VSS VSS gf180mcu_fd_sc_mcu7t5v0__nand2_1
X_4354_ _5012_/A1 _4364_/A2 _4354_/B _6891_/D VDD VDD VSS VSS gf180mcu_fd_sc_mcu7t5v0__oai21_1
X_7142_ _7142_/D _7261_/CLK _7142_/Q VDD VDD VSS VSS gf180mcu_fd_sc_mcu7t5v0__dffq_1
X_7073_ _7073_/D _7099_/CLK _7073_/Q VDD VDD VSS VSS gf180mcu_fd_sc_mcu7t5v0__dffq_1
Xfanout417 wire420/I _5507_/B1 VDD VDD VSS VSS gf180mcu_fd_sc_mcu7t5v0__dlyd_1
XFILLER_59_629 VDD VDD VSS VSS gf180mcu_fd_sc_mcu7t5v0__fill_1
XTAP_TAPCELL_ROW_70_1239 VDD VSS gf180mcu_fd_sc_mcu7t5v0__filltie
X_6024_ _7034_/Q _6151_/C2 _6154_/A2 _7027_/Q _6026_/A1 VDD VDD VSS VSS gf180mcu_fd_sc_mcu7t5v0__oai22_1
X_4285_ _6857_/Q _4294_/A2 _4286_/B VDD VDD VSS VSS gf180mcu_fd_sc_mcu7t5v0__nand2_1
XFILLER_100_247 VDD VDD VSS VSS gf180mcu_fd_sc_mcu7t5v0__fill_2
XFILLER_55_824 VDD VDD VSS VSS gf180mcu_fd_sc_mcu7t5v0__fill_2
X_6926_ _6926_/D _7259_/CLK _6926_/Q VDD VDD VSS VSS gf180mcu_fd_sc_mcu7t5v0__dffq_1
X_6857_ _6857_/D _7719_/CLK _6857_/Q VDD VDD VSS VSS gf180mcu_fd_sc_mcu7t5v0__dffq_1
X_6788_ _6788_/D _7453_/CLK _6788_/Q VDD VDD VSS VSS gf180mcu_fd_sc_mcu7t5v0__dffq_1
X_5808_ _5808_/A1 _5813_/A1 _5809_/I VDD VDD VSS VSS gf180mcu_fd_sc_mcu7t5v0__nor2_1
X_5739_ _5748_/A2 _5813_/A2 _5878_/A2 VDD VDD VSS VSS gf180mcu_fd_sc_mcu7t5v0__nor2_1
X_7409_ _7409_/D _7500_/CLK _7409_/Q VDD VDD VSS VSS gf180mcu_fd_sc_mcu7t5v0__dffq_1
XFILLER_89_297 VDD VDD VSS VSS gf180mcu_fd_sc_mcu7t5v0__fill_1
XFILLER_38_20 VDD VDD VSS VSS gf180mcu_fd_sc_mcu7t5v0__fill_1
XFILLER_100_770 VDD VDD VSS VSS gf180mcu_fd_sc_mcu7t5v0__fillcap_16
XFILLER_73_632 VDD VDD VSS VSS gf180mcu_fd_sc_mcu7t5v0__fill_1
XFILLER_73_698 VDD VDD VSS VSS gf180mcu_fd_sc_mcu7t5v0__fill_2
XFILLER_26_592 VDD VDD VSS VSS gf180mcu_fd_sc_mcu7t5v0__fill_2
XFILLER_41_562 VDD VDD VSS VSS gf180mcu_fd_sc_mcu7t5v0__fillcap_64
XTAP_TAPCELL_ROW_11_410 VDD VSS gf180mcu_fd_sc_mcu7t5v0__filltie
Xclkload16 _7482_/CLK clkload16/ZN VDD VDD VSS VSS gf180mcu_fd_sc_mcu7t5v0__inv_3
XFILLER_9_279 VDD VDD VSS VSS gf180mcu_fd_sc_mcu7t5v0__fill_1
Xclkload38 _7710_/CLK clkload38/Z VDD VDD VSS VSS gf180mcu_fd_sc_mcu7t5v0__clkbuf_2
Xclkload27 _7499_/CLK clkload27/Z VDD VDD VSS VSS gf180mcu_fd_sc_mcu7t5v0__clkbuf_2
Xclkload49 _7692_/CLK clkload49/Z VDD VDD VSS VSS gf180mcu_fd_sc_mcu7t5v0__clkbuf_2
XPHY_EDGE_ROW_10_Left_129 VDD VSS gf180mcu_fd_sc_mcu7t5v0__endcap
XFILLER_69_927 VDD VDD VSS VSS gf180mcu_fd_sc_mcu7t5v0__fillcap_32
X_4070_ _6775_/Q _4770_/A2 _4071_/B VDD VDD VSS VSS gf180mcu_fd_sc_mcu7t5v0__nand2_1
XTAP_TAPCELL_ROW_39_808 VDD VSS gf180mcu_fd_sc_mcu7t5v0__filltie
XTAP_TAPCELL_ROW_19_521 VDD VSS gf180mcu_fd_sc_mcu7t5v0__filltie
XTAP_TAPCELL_ROW_108_1769 VDD VSS gf180mcu_fd_sc_mcu7t5v0__filltie
XFILLER_91_462 VDD VDD VSS VSS gf180mcu_fd_sc_mcu7t5v0__fill_2
XFILLER_64_676 VDD VDD VSS VSS gf180mcu_fd_sc_mcu7t5v0__fill_2
X_7760_ _7760_/D _7760_/RN _7790_/CLK _7760_/Q VDD VDD VSS VSS gf180mcu_fd_sc_mcu7t5v0__dffrnq_1
X_4972_ _5070_/A1 _4980_/A2 _4972_/B _7200_/D VDD VDD VSS VSS gf180mcu_fd_sc_mcu7t5v0__oai21_1
X_3923_ _3919_/Z _3920_/Z _3922_/Z _3923_/Z VDD VDD VSS VSS gf180mcu_fd_sc_mcu7t5v0__xor3_1
X_7691_ _7691_/D _7694_/RN _7692_/CLK _7691_/Q VDD VDD VSS VSS gf180mcu_fd_sc_mcu7t5v0__dffrnq_1
X_6711_ _6711_/I _7753_/D VDD VDD VSS VSS gf180mcu_fd_sc_mcu7t5v0__clkinv_1
XTAP_TAPCELL_ROW_67_1190 VDD VSS gf180mcu_fd_sc_mcu7t5v0__filltie
X_6642_ _6658_/A2 _6644_/A2 _6643_/A2 VDD VDD VSS VSS gf180mcu_fd_sc_mcu7t5v0__nand2_1
X_3854_ _7748_/Q _6679_/I0 _3854_/B wire283/I VDD VDD VSS VSS gf180mcu_fd_sc_mcu7t5v0__oai21_1
XFILLER_60_871 VDD VDD VSS VSS gf180mcu_fd_sc_mcu7t5v0__fillcap_4
X_6573_ _7708_/Q _7707_/Q _6574_/S _7708_/D VDD VDD VSS VSS gf180mcu_fd_sc_mcu7t5v0__mux2_2
X_3785_ _7540_/Q _6679_/S _6697_/A1 VDD VDD VSS VSS gf180mcu_fd_sc_mcu7t5v0__nand2_1
X_5524_ _7511_/Q _6733_/A4 _5526_/A1 VDD VDD VSS VSS gf180mcu_fd_sc_mcu7t5v0__nand2_1
X_5455_ _7298_/Q _5612_/A2 _5610_/C2 _7501_/Q _5456_/A3 VDD VDD VSS VSS gf180mcu_fd_sc_mcu7t5v0__oai22_1
X_4406_ _5078_/A1 _4406_/A2 _4406_/B _6917_/D VDD VDD VSS VSS gf180mcu_fd_sc_mcu7t5v0__oai21_1
Xfanout203 _5636_/ZN _5642_/S VDD VDD VSS VSS gf180mcu_fd_sc_mcu7t5v0__dlyd_1
X_5386_ _7387_/Q _5599_/A2 _5590_/B _5388_/A1 VDD VDD VSS VSS gf180mcu_fd_sc_mcu7t5v0__oai21_1
Xfanout214 wire220/I fanout214/Z VDD VDD VSS VSS gf180mcu_fd_sc_mcu7t5v0__dlyd_1
X_7125_ _7125_/D _7217_/CLK _7125_/Q VDD VDD VSS VSS gf180mcu_fd_sc_mcu7t5v0__dffq_1
X_4337_ _6883_/Q _4350_/A2 _4338_/B VDD VDD VSS VSS gf180mcu_fd_sc_mcu7t5v0__nand2_1
Xfanout247 _4029_/A1 wire248/I VDD VDD VSS VSS gf180mcu_fd_sc_mcu7t5v0__dlyd_1
Xfanout236 wire241/I _4402_/A1 VDD VDD VSS VSS gf180mcu_fd_sc_mcu7t5v0__dlyd_1
X_7056_ _7056_/D _7060_/CLK _7056_/Q VDD VDD VSS VSS gf180mcu_fd_sc_mcu7t5v0__dffq_1
Xfanout258 _5072_/A1 _5100_/A1 VDD VDD VSS VSS gf180mcu_fd_sc_mcu7t5v0__dlyd_1
X_4268_ _4324_/A1 _4280_/A2 _4268_/B _6848_/D VDD VDD VSS VSS gf180mcu_fd_sc_mcu7t5v0__oai21_1
X_6007_ _6007_/A1 _5744_/B _6300_/B1 _6007_/B2 _7575_/D VDD VDD VSS VSS gf180mcu_fd_sc_mcu7t5v0__aoi22_1
X_4199_ _4234_/I0 _6816_/Q _5239_/S _6816_/D VDD VDD VSS VSS gf180mcu_fd_sc_mcu7t5v0__mux2_2
XFILLER_83_974 VDD VDD VSS VSS gf180mcu_fd_sc_mcu7t5v0__fillcap_4
XTAP_TAPCELL_ROW_83_1419 VDD VSS gf180mcu_fd_sc_mcu7t5v0__filltie
X_6909_ _6909_/D _6939_/CLK _6909_/Q VDD VDD VSS VSS gf180mcu_fd_sc_mcu7t5v0__dffq_1
XFILLER_23_551 VDD VDD VSS VSS gf180mcu_fd_sc_mcu7t5v0__fillcap_8
XFILLER_11_702 VDD VDD VSS VSS gf180mcu_fd_sc_mcu7t5v0__fillcap_64
XFILLER_23_562 VDD VDD VSS VSS gf180mcu_fd_sc_mcu7t5v0__fillcap_64
XFILLER_51_871 VDD VDD VSS VSS gf180mcu_fd_sc_mcu7t5v0__fillcap_32
XFILLER_108_122 VDD VDD VSS VSS gf180mcu_fd_sc_mcu7t5v0__fill_1
XFILLER_3_912 VDD VDD VSS VSS gf180mcu_fd_sc_mcu7t5v0__fillcap_64
XFILLER_105_873 VDD VDD VSS VSS gf180mcu_fd_sc_mcu7t5v0__fillcap_4
XFILLER_6_2 VDD VDD VSS VSS gf180mcu_fd_sc_mcu7t5v0__fill_2
XFILLER_74_941 VDD VDD VSS VSS gf180mcu_fd_sc_mcu7t5v0__fillcap_4
XFILLER_45_142 VDD VDD VSS VSS gf180mcu_fd_sc_mcu7t5v0__fill_1
XFILLER_42_871 VDD VDD VSS VSS gf180mcu_fd_sc_mcu7t5v0__fillcap_4
XTAP_TAPCELL_ROW_44_877 VDD VSS gf180mcu_fd_sc_mcu7t5v0__filltie
XTAP_TAPCELL_ROW_103_1699 VDD VSS gf180mcu_fd_sc_mcu7t5v0__filltie
XTAP_TAPCELL_ROW_24_590 VDD VSS gf180mcu_fd_sc_mcu7t5v0__filltie
X_3570_ input89/Z input93/Z _3561_/Z _3570_/Z VDD VDD VSS VSS gf180mcu_fd_sc_mcu7t5v0__xor3_1
X_5240_ _5352_/I0 _7387_/Q _5246_/S _7387_/D VDD VDD VSS VSS gf180mcu_fd_sc_mcu7t5v0__mux2_2
XTAP_TAPCELL_ROW_54_1009 VDD VSS gf180mcu_fd_sc_mcu7t5v0__filltie
X_5171_ _5339_/I0 _7318_/Q _5176_/S _7318_/D VDD VDD VSS VSS gf180mcu_fd_sc_mcu7t5v0__mux2_2
XPHY_EDGE_ROW_18_Right_18 VDD VSS gf180mcu_fd_sc_mcu7t5v0__endcap
X_4122_ _4125_/A1 _4994_/A2 _4122_/B _6791_/D VDD VDD VSS VSS gf180mcu_fd_sc_mcu7t5v0__oai21_1
XFILLER_57_908 VDD VDD VSS VSS gf180mcu_fd_sc_mcu7t5v0__fill_2
X_4053_ _3967_/I _4053_/A2 _4700_/A2 VDD VDD VSS VSS gf180mcu_fd_sc_mcu7t5v0__nand2_1
Xinput3 alert_rx_i[2] input3/Z VDD VDD VSS VSS gf180mcu_fd_sc_mcu7t5v0__dlyd_1
XFILLER_37_632 VDD VDD VSS VSS gf180mcu_fd_sc_mcu7t5v0__fillcap_64
XFILLER_49_492 VDD VDD VSS VSS gf180mcu_fd_sc_mcu7t5v0__fill_1
XTAP_TAPCELL_ROW_69_1230 VDD VSS gf180mcu_fd_sc_mcu7t5v0__filltie
XFILLER_52_602 VDD VDD VSS VSS gf180mcu_fd_sc_mcu7t5v0__fill_1
XFILLER_65_974 VDD VDD VSS VSS gf180mcu_fd_sc_mcu7t5v0__fillcap_4
X_7812_ input4/Z _7823_/RN _7822_/CLK _7813_/D VDD VDD VSS VSS gf180mcu_fd_sc_mcu7t5v0__dffrnq_1
XPHY_EDGE_ROW_27_Right_27 VDD VSS gf180mcu_fd_sc_mcu7t5v0__endcap
X_7743_ _7743_/D wire565/Z _7792_/CLK _7743_/Q VDD VDD VSS VSS gf180mcu_fd_sc_mcu7t5v0__dffrnq_1
X_4955_ _7192_/Q _4966_/A2 _4956_/B VDD VDD VSS VSS gf180mcu_fd_sc_mcu7t5v0__nand2_1
X_3906_ _6274_/A1 _3836_/Z _3904_/Z _3906_/Z VDD VDD VSS VSS gf180mcu_fd_sc_mcu7t5v0__xor3_1
X_7674_ _7674_/D _7694_/RN _7802_/CLK _7674_/Q VDD VDD VSS VSS gf180mcu_fd_sc_mcu7t5v0__dffrnq_1
X_4886_ _4942_/A1 _4896_/A2 _4886_/B _7157_/D VDD VDD VSS VSS gf180mcu_fd_sc_mcu7t5v0__oai21_1
X_3837_ _7597_/Q _7581_/Q _3837_/Z VDD VDD VSS VSS gf180mcu_fd_sc_mcu7t5v0__xor2_1
X_6625_ _7783_/Q _7552_/Q _6654_/B VDD VDD VSS VSS gf180mcu_fd_sc_mcu7t5v0__and2_1
X_6556_ _6559_/A1 _6556_/A2 _6555_/Z _7694_/D VDD VDD VSS VSS gf180mcu_fd_sc_mcu7t5v0__nor3_1
X_3768_ _7558_/Q _7780_/D _7805_/D VDD VDD VSS VSS gf180mcu_fd_sc_mcu7t5v0__and2_1
XFILLER_118_475 VDD VDD VSS VSS gf180mcu_fd_sc_mcu7t5v0__fill_1
X_5507_ _7489_/Q wire428/I _5507_/B1 _7468_/Q _5509_/A1 VDD VDD VSS VSS gf180mcu_fd_sc_mcu7t5v0__oai22_1
X_3699_ _6314_/A1 _3699_/A2 _3699_/B _3700_/A4 VDD VDD VSS VSS gf180mcu_fd_sc_mcu7t5v0__aoi21_1
X_6487_ _7800_/Q _3502_/I _6488_/A2 _7801_/Q _6487_/C _6488_/C VDD VDD VSS VSS gf180mcu_fd_sc_mcu7t5v0__oai221_1
X_5438_ _7487_/Q _5453_/C2 _5609_/B _5440_/A1 VDD VDD VSS VSS gf180mcu_fd_sc_mcu7t5v0__oai21_1
XPHY_EDGE_ROW_36_Right_36 VDD VSS gf180mcu_fd_sc_mcu7t5v0__endcap
X_5369_ _7726_/Q _7727_/Q _5369_/ZN VDD VDD VSS VSS gf180mcu_fd_sc_mcu7t5v0__nand2_1
X_7108_ _7108_/D _7196_/CLK _7108_/Q VDD VDD VSS VSS gf180mcu_fd_sc_mcu7t5v0__dffq_1
X_7039_ _7039_/D _7060_/CLK _7039_/Q VDD VDD VSS VSS gf180mcu_fd_sc_mcu7t5v0__dffq_1
XFILLER_87_598 VDD VDD VSS VSS gf180mcu_fd_sc_mcu7t5v0__fill_2
XFILLER_56_941 VDD VDD VSS VSS gf180mcu_fd_sc_mcu7t5v0__fillcap_4
XFILLER_74_259 VDD VDD VSS VSS gf180mcu_fd_sc_mcu7t5v0__fill_2
XTAP_TAPCELL_ROW_2_285 VDD VSS gf180mcu_fd_sc_mcu7t5v0__filltie
XFILLER_43_624 VDD VDD VSS VSS gf180mcu_fd_sc_mcu7t5v0__fillcap_4
XPHY_EDGE_ROW_45_Right_45 VDD VSS gf180mcu_fd_sc_mcu7t5v0__endcap
XFILLER_71_977 VDD VDD VSS VSS gf180mcu_fd_sc_mcu7t5v0__fill_2
XFILLER_24_871 VDD VDD VSS VSS gf180mcu_fd_sc_mcu7t5v0__fillcap_4
XTAP_TAPCELL_ROW_41_836 VDD VSS gf180mcu_fd_sc_mcu7t5v0__filltie
XFILLER_11_554 VDD VDD VSS VSS gf180mcu_fd_sc_mcu7t5v0__fillcap_4
XFILLER_7_558 VDD VDD VSS VSS gf180mcu_fd_sc_mcu7t5v0__fill_2
XPHY_EDGE_ROW_54_Right_54 VDD VSS gf180mcu_fd_sc_mcu7t5v0__endcap
Xload_slew406 _6192_/A2 _6235_/A2 VDD VDD VSS VSS gf180mcu_fd_sc_mcu7t5v0__buf_4
Xuart_640 tl_o[48] VDD VDD VSS VSS gf180mcu_fd_sc_mcu7t5v0__tiel
Xload_slew439 _6283_/A2 _6285_/A2 VDD VDD VSS VSS gf180mcu_fd_sc_mcu7t5v0__buf_4
XFILLER_78_532 VDD VDD VSS VSS gf180mcu_fd_sc_mcu7t5v0__fill_1
XFILLER_66_705 VDD VDD VSS VSS gf180mcu_fd_sc_mcu7t5v0__fill_1
XFILLER_19_632 VDD VDD VSS VSS gf180mcu_fd_sc_mcu7t5v0__fillcap_64
XTAP_TAPCELL_ROW_49_947 VDD VSS gf180mcu_fd_sc_mcu7t5v0__filltie
XPHY_EDGE_ROW_63_Right_63 VDD VSS gf180mcu_fd_sc_mcu7t5v0__endcap
XTAP_TAPCELL_ROW_105_1728 VDD VSS gf180mcu_fd_sc_mcu7t5v0__filltie
XTAP_TAPCELL_ROW_29_660 VDD VSS gf180mcu_fd_sc_mcu7t5v0__filltie
XTAP_TAPCELL_ROW_29_671 VDD VSS gf180mcu_fd_sc_mcu7t5v0__filltie
XFILLER_62_944 VDD VDD VSS VSS gf180mcu_fd_sc_mcu7t5v0__fill_1
XFILLER_73_292 VDD VDD VSS VSS gf180mcu_fd_sc_mcu7t5v0__fill_2
XTAP_TAPCELL_ROW_64_1160 VDD VSS gf180mcu_fd_sc_mcu7t5v0__filltie
X_4740_ _4824_/A1 _4742_/A2 _4740_/B _7084_/D VDD VDD VSS VSS gf180mcu_fd_sc_mcu7t5v0__oai21_1
X_4671_ _7050_/Q _4672_/A2 _4672_/B VDD VDD VSS VSS gf180mcu_fd_sc_mcu7t5v0__nand2_1
X_6410_ _7661_/Q _7527_/Q _6421_/A2 VDD VDD VSS VSS gf180mcu_fd_sc_mcu7t5v0__nor2_1
X_7390_ _7390_/D _7735_/CLK _7390_/Q VDD VDD VSS VSS gf180mcu_fd_sc_mcu7t5v0__dffq_1
X_3622_ input42/Z input38/Z input41/Z _3626_/A2 VDD VDD VSS VSS gf180mcu_fd_sc_mcu7t5v0__xnor3_1
X_6341_ _7631_/Q input47/Z _6341_/S _7631_/D VDD VDD VSS VSS gf180mcu_fd_sc_mcu7t5v0__mux2_2
XPHY_EDGE_ROW_72_Right_72 VDD VSS gf180mcu_fd_sc_mcu7t5v0__endcap
X_3553_ input29/Z input40/Z _3552_/Z _3553_/Z VDD VDD VSS VSS gf180mcu_fd_sc_mcu7t5v0__xor3_1
XFILLER_116_979 VDD VDD VSS VSS gf180mcu_fd_sc_mcu7t5v0__fill_2
XTAP_TAPCELL_ROW_116_1879 VDD VSS gf180mcu_fd_sc_mcu7t5v0__filltie
X_6272_ _6272_/A1 _6284_/A2 _6284_/B1 _6272_/B2 _7588_/D VDD VDD VSS VSS gf180mcu_fd_sc_mcu7t5v0__aoi22_1
X_3484_ _3484_/I _7797_/D VDD VDD VSS VSS gf180mcu_fd_sc_mcu7t5v0__clkinv_1
XFILLER_115_489 VDD VDD VSS VSS gf180mcu_fd_sc_mcu7t5v0__fill_1
XPHY_EDGE_ROW_102_Left_221 VDD VSS gf180mcu_fd_sc_mcu7t5v0__endcap
X_5223_ _5244_/I0 _7370_/Q _5225_/S _7370_/D VDD VDD VSS VSS gf180mcu_fd_sc_mcu7t5v0__mux2_2
XFILLER_111_640 VDD VDD VSS VSS gf180mcu_fd_sc_mcu7t5v0__fill_2
X_5154_ wire517/Z _7301_/Q _5155_/S _7301_/D VDD VDD VSS VSS gf180mcu_fd_sc_mcu7t5v0__mux2_2
X_4105_ _6786_/Q _4924_/A2 _4106_/B VDD VDD VSS VSS gf180mcu_fd_sc_mcu7t5v0__nand2_1
X_5085_ _7257_/Q _5092_/A2 _5086_/B VDD VDD VSS VSS gf180mcu_fd_sc_mcu7t5v0__nand2_1
XFILLER_96_384 VDD VDD VSS VSS gf180mcu_fd_sc_mcu7t5v0__fill_1
XPHY_EDGE_ROW_81_Right_81 VDD VSS gf180mcu_fd_sc_mcu7t5v0__endcap
XFILLER_38_941 VDD VDD VSS VSS gf180mcu_fd_sc_mcu7t5v0__fillcap_4
XFILLER_57_749 VDD VDD VSS VSS gf180mcu_fd_sc_mcu7t5v0__fill_1
X_4036_ _6764_/Q _4616_/A2 _4037_/B VDD VDD VSS VSS gf180mcu_fd_sc_mcu7t5v0__nand2_1
XFILLER_71_207 VDD VDD VSS VSS gf180mcu_fd_sc_mcu7t5v0__fill_2
XPHY_EDGE_ROW_111_Left_230 VDD VSS gf180mcu_fd_sc_mcu7t5v0__endcap
X_5987_ _7096_/Q _6233_/A2 wire353/I _7089_/Q _6191_/B _5988_/A2 VDD VDD VSS VSS gf180mcu_fd_sc_mcu7t5v0__oai221_1
X_4938_ _4952_/A1 _4938_/A2 _4938_/B _7183_/D VDD VDD VSS VSS gf180mcu_fd_sc_mcu7t5v0__oai21_1
X_7726_ _7726_/D _7740_/RN _7793_/CLK _7726_/Q VDD VDD VSS VSS gf180mcu_fd_sc_mcu7t5v0__dffrnq_1
X_7657_ _7657_/D _7657_/RN _7668_/CLK _7657_/Q VDD VDD VSS VSS gf180mcu_fd_sc_mcu7t5v0__dffrnq_1
X_4869_ _7149_/Q _4882_/A2 _4870_/B VDD VDD VSS VSS gf180mcu_fd_sc_mcu7t5v0__nand2_1
XPHY_EDGE_ROW_90_Right_90 VDD VSS gf180mcu_fd_sc_mcu7t5v0__endcap
X_6608_ _7719_/Q _6608_/A2 _6610_/A2 VDD VDD VSS VSS gf180mcu_fd_sc_mcu7t5v0__nor2_1
X_7588_ _7588_/D _7595_/RN _7671_/CLK _7588_/Q VDD VDD VSS VSS gf180mcu_fd_sc_mcu7t5v0__dffrnq_1
X_6539_ _7689_/Q _6537_/Z _6541_/A2 VDD VDD VSS VSS gf180mcu_fd_sc_mcu7t5v0__nor2_1
XTAP_TAPCELL_ROW_91_1529 VDD VSS gf180mcu_fd_sc_mcu7t5v0__filltie
Xoutput170 _7607_/Q tl_o[52] VDD VDD VSS VSS gf180mcu_fd_sc_mcu7t5v0__dlyd_1
Xoutput181 _3923_/Z tl_o[7] VDD VDD VSS VSS gf180mcu_fd_sc_mcu7t5v0__dlyd_1
XFILLER_88_863 VDD VDD VSS VSS gf180mcu_fd_sc_mcu7t5v0__fillcap_4
XTAP_TAPCELL_ROW_7_355 VDD VSS gf180mcu_fd_sc_mcu7t5v0__filltie
XFILLER_88_896 VDD VDD VSS VSS gf180mcu_fd_sc_mcu7t5v0__fill_1
XTAP_TAPCELL_ROW_46_906 VDD VSS gf180mcu_fd_sc_mcu7t5v0__filltie
XFILLER_90_527 VDD VDD VSS VSS gf180mcu_fd_sc_mcu7t5v0__fill_2
XTAP_TAPCELL_ROW_100_1658 VDD VSS gf180mcu_fd_sc_mcu7t5v0__filltie
XFILLER_8_801 VDD VDD VSS VSS gf180mcu_fd_sc_mcu7t5v0__fillcap_4
Xwire220 wire220/I wire220/Z VDD VDD VSS VSS gf180mcu_fd_sc_mcu7t5v0__buf_2
Xwire231 wire231/I wire231/Z VDD VDD VSS VSS gf180mcu_fd_sc_mcu7t5v0__buf_4
XFILLER_98_605 VDD VDD VSS VSS gf180mcu_fd_sc_mcu7t5v0__fill_2
XFILLER_98_649 VDD VDD VSS VSS gf180mcu_fd_sc_mcu7t5v0__fill_1
Xload_slew225 _3874_/A2 _4950_/A1 VDD VDD VSS VSS gf180mcu_fd_sc_mcu7t5v0__buf_3
Xload_slew269 wire268/I _5068_/A1 VDD VDD VSS VSS gf180mcu_fd_sc_mcu7t5v0__buf_2
XFILLER_94_844 VDD VDD VSS VSS gf180mcu_fd_sc_mcu7t5v0__fill_2
XFILLER_78_384 VDD VDD VSS VSS gf180mcu_fd_sc_mcu7t5v0__fill_1
XFILLER_66_524 VDD VDD VSS VSS gf180mcu_fd_sc_mcu7t5v0__fill_1
X_5910_ _6941_/Q _6225_/A2 _6167_/B1 _6920_/Q _6227_/C _5914_/A2 VDD VDD VSS VSS gf180mcu_fd_sc_mcu7t5v0__oai221_1
X_6890_ _6890_/D _7008_/CLK _6890_/Q VDD VDD VSS VSS gf180mcu_fd_sc_mcu7t5v0__dffq_1
XFILLER_81_549 VDD VDD VSS VSS gf180mcu_fd_sc_mcu7t5v0__fill_1
X_5841_ _6940_/Q _6087_/A2 _6167_/B1 _6919_/Q _5846_/A1 VDD VDD VSS VSS gf180mcu_fd_sc_mcu7t5v0__oai22_1
XFILLER_34_454 VDD VDD VSS VSS gf180mcu_fd_sc_mcu7t5v0__fill_1
X_5772_ _6841_/Q _6091_/A2 _6092_/B1 _7275_/Q _5774_/A1 VDD VDD VSS VSS gf180mcu_fd_sc_mcu7t5v0__oai22_1
XFILLER_50_947 VDD VDD VSS VSS gf180mcu_fd_sc_mcu7t5v0__fillcap_32
X_4723_ _7076_/Q _4728_/A2 _4724_/B VDD VDD VSS VSS gf180mcu_fd_sc_mcu7t5v0__nand2_1
X_7511_ _7511_/D _7764_/RN _7765_/CLK _7511_/Q VDD VDD VSS VSS gf180mcu_fd_sc_mcu7t5v0__dffsnq_1
XTAP_TAPCELL_ROW_118_1919 VDD VSS gf180mcu_fd_sc_mcu7t5v0__filltie
XTAP_TAPCELL_ROW_118_1908 VDD VSS gf180mcu_fd_sc_mcu7t5v0__filltie
X_7442_ _7442_/D _7483_/CLK _7442_/Q VDD VDD VSS VSS gf180mcu_fd_sc_mcu7t5v0__dffq_1
X_4654_ wire240/Z _4658_/A2 _4654_/B _7041_/D VDD VDD VSS VSS gf180mcu_fd_sc_mcu7t5v0__oai21_1
X_4585_ _7007_/Q _4588_/A2 _4586_/B VDD VDD VSS VSS gf180mcu_fd_sc_mcu7t5v0__nand2_1
Xinput72 tl_i[68] _7880_/I VDD VDD VSS VSS gf180mcu_fd_sc_mcu7t5v0__dlyd_1
Xinput61 tl_i[58] input61/Z VDD VDD VSS VSS gf180mcu_fd_sc_mcu7t5v0__dlyd_1
XTAP_TAPCELL_ROW_77_1340 VDD VSS gf180mcu_fd_sc_mcu7t5v0__filltie
Xinput50 tl_i[48] input50/Z VDD VDD VSS VSS gf180mcu_fd_sc_mcu7t5v0__dlyd_1
X_7373_ _7373_/D _7736_/CLK _7373_/Q VDD VDD VSS VSS gf180mcu_fd_sc_mcu7t5v0__dffq_1
X_3605_ _3605_/A1 _3547_/Z _3605_/Z VDD VDD VSS VSS gf180mcu_fd_sc_mcu7t5v0__xor2_1
Xinput94 tl_i[88] input94/Z VDD VDD VSS VSS gf180mcu_fd_sc_mcu7t5v0__dlyd_1
Xinput83 tl_i[78] input83/Z VDD VDD VSS VSS gf180mcu_fd_sc_mcu7t5v0__dlyd_1
X_3536_ _3385_/I _3386_/I _3685_/A3 VDD VDD VSS VSS gf180mcu_fd_sc_mcu7t5v0__nand2_1
X_6324_ _6324_/A1 _6331_/S _6324_/B _7619_/D VDD VDD VSS VSS gf180mcu_fd_sc_mcu7t5v0__oai21_1
XFILLER_116_798 VDD VDD VSS VSS gf180mcu_fd_sc_mcu7t5v0__fillcap_4
X_6255_ _6255_/A1 _6300_/A2 _6274_/B1 _6255_/B2 _7580_/D VDD VDD VSS VSS gf180mcu_fd_sc_mcu7t5v0__aoi22_1
X_3467_ _7821_/Q _7819_/Q _7769_/D VDD VDD VSS VSS gf180mcu_fd_sc_mcu7t5v0__xor2_1
X_5206_ _6354_/I0 _7353_/Q _5211_/S _7353_/D VDD VDD VSS VSS gf180mcu_fd_sc_mcu7t5v0__mux2_2
X_3398_ _7675_/Q _6499_/A1 VDD VDD VSS VSS gf180mcu_fd_sc_mcu7t5v0__clkinv_1
XTAP_TAPCELL_ROW_4_314 VDD VSS gf180mcu_fd_sc_mcu7t5v0__filltie
X_6186_ _7550_/Q _6247_/A2 _5677_/I _7557_/Q _6189_/A2 VDD VDD VSS VSS gf180mcu_fd_sc_mcu7t5v0__aoi22_1
XFILLER_57_502 VDD VDD VSS VSS gf180mcu_fd_sc_mcu7t5v0__fill_1
XFILLER_97_693 VDD VDD VSS VSS gf180mcu_fd_sc_mcu7t5v0__fill_2
X_5137_ _5347_/I0 _7284_/Q _5141_/S _7284_/D VDD VDD VSS VSS gf180mcu_fd_sc_mcu7t5v0__mux2_2
XFILLER_85_888 VDD VDD VSS VSS gf180mcu_fd_sc_mcu7t5v0__fillcap_8
X_5068_ _5068_/A1 _5075_/A2 _5068_/B _7248_/D VDD VDD VSS VSS gf180mcu_fd_sc_mcu7t5v0__aoi21_1
X_4019_ _6759_/Q _4546_/A2 _4020_/B VDD VDD VSS VSS gf180mcu_fd_sc_mcu7t5v0__nand2_1
XFILLER_84_387 VDD VDD VSS VSS gf180mcu_fd_sc_mcu7t5v0__fill_1
XFILLER_72_527 VDD VDD VSS VSS gf180mcu_fd_sc_mcu7t5v0__fillcap_4
XTAP_TAPCELL_ROW_88_1491 VDD VSS gf180mcu_fd_sc_mcu7t5v0__filltie
XFILLER_37_292 VDD VDD VSS VSS gf180mcu_fd_sc_mcu7t5v0__fill_1
XPHY_EDGE_ROW_0_Right_0 VDD VSS gf180mcu_fd_sc_mcu7t5v0__endcap
XFILLER_25_498 VDD VDD VSS VSS gf180mcu_fd_sc_mcu7t5v0__fill_2
XFILLER_53_796 VDD VDD VSS VSS gf180mcu_fd_sc_mcu7t5v0__fillcap_4
X_7709_ _7709_/D _7709_/RN _7711_/CLK _7709_/Q VDD VDD VSS VSS gf180mcu_fd_sc_mcu7t5v0__dffrnq_1
XTAP_TAPCELL_ROW_51_975 VDD VSS gf180mcu_fd_sc_mcu7t5v0__filltie
XFILLER_4_314 VDD VDD VSS VSS gf180mcu_fd_sc_mcu7t5v0__fill_1
XFILLER_48_524 VDD VDD VSS VSS gf180mcu_fd_sc_mcu7t5v0__fill_1
XFILLER_48_535 VDD VDD VSS VSS gf180mcu_fd_sc_mcu7t5v0__fillcap_8
XFILLER_76_899 VDD VDD VSS VSS gf180mcu_fd_sc_mcu7t5v0__fill_1
XFILLER_32_947 VDD VDD VSS VSS gf180mcu_fd_sc_mcu7t5v0__fillcap_32
XFILLER_43_284 VDD VDD VSS VSS gf180mcu_fd_sc_mcu7t5v0__fill_1
X_4370_ _5014_/A1 _4378_/A2 _4370_/B _6899_/D VDD VDD VSS VSS gf180mcu_fd_sc_mcu7t5v0__oai21_1
XTAP_TAPCELL_ROW_113_1838 VDD VSS gf180mcu_fd_sc_mcu7t5v0__filltie
XTAP_TAPCELL_ROW_59_1081 VDD VSS gf180mcu_fd_sc_mcu7t5v0__filltie
XFILLER_98_457 VDD VDD VSS VSS gf180mcu_fd_sc_mcu7t5v0__fill_1
X_6040_ _6040_/A1 _6040_/A2 _6196_/B _6047_/A2 VDD VDD VSS VSS gf180mcu_fd_sc_mcu7t5v0__oai21_1
XFILLER_101_908 VDD VDD VSS VSS gf180mcu_fd_sc_mcu7t5v0__fill_2
XFILLER_67_811 VDD VDD VSS VSS gf180mcu_fd_sc_mcu7t5v0__fill_2
XTAP_TAPCELL_ROW_72_1270 VDD VSS gf180mcu_fd_sc_mcu7t5v0__filltie
XFILLER_82_803 VDD VDD VSS VSS gf180mcu_fd_sc_mcu7t5v0__fill_2
X_6942_ _6942_/D _7259_/CLK _6942_/Q VDD VDD VSS VSS gf180mcu_fd_sc_mcu7t5v0__dffq_1
X_6873_ _6873_/D _6915_/CLK _6873_/Q VDD VDD VSS VSS gf180mcu_fd_sc_mcu7t5v0__dffq_1
X_5824_ _5824_/A1 _5824_/A2 _5834_/A1 VDD VDD VSS VSS gf180mcu_fd_sc_mcu7t5v0__nor2_1
XTAP_TAPCELL_ROW_17_493 VDD VSS gf180mcu_fd_sc_mcu7t5v0__filltie
X_5755_ _7072_/Q _6215_/A2 _6112_/A2 _7079_/Q _7086_/Q wire353/Z _5758_/A2 VDD VDD
+ VSS VSS gf180mcu_fd_sc_mcu7t5v0__oai222_1
X_4706_ _4832_/A1 _4714_/A2 _4706_/B _7067_/D VDD VDD VSS VSS gf180mcu_fd_sc_mcu7t5v0__oai21_1
X_5686_ _7560_/Q input38/Z _5686_/S _7560_/D VDD VDD VSS VSS gf180mcu_fd_sc_mcu7t5v0__mux2_2
XFILLER_108_529 VDD VDD VSS VSS gf180mcu_fd_sc_mcu7t5v0__fill_1
X_4637_ _7033_/Q _4644_/A2 _4638_/B VDD VDD VSS VSS gf180mcu_fd_sc_mcu7t5v0__nand2_1
X_7425_ _7425_/D _7451_/CLK _7425_/Q VDD VDD VSS VSS gf180mcu_fd_sc_mcu7t5v0__dffq_1
X_4568_ _5128_/A1 _4574_/A2 _4568_/B _6998_/D VDD VDD VSS VSS gf180mcu_fd_sc_mcu7t5v0__oai21_1
XFILLER_2_807 VDD VDD VSS VSS gf180mcu_fd_sc_mcu7t5v0__fillcap_64
X_7356_ _7356_/D _7378_/CLK _7356_/Q VDD VDD VSS VSS gf180mcu_fd_sc_mcu7t5v0__dffq_1
X_4499_ _6964_/Q _4504_/A2 _4500_/B VDD VDD VSS VSS gf180mcu_fd_sc_mcu7t5v0__nand2_1
X_6307_ _7608_/Q input9/Z _6310_/S _7608_/D VDD VDD VSS VSS gf180mcu_fd_sc_mcu7t5v0__mux2_2
X_7287_ _7287_/D _7483_/CLK _7287_/Q VDD VDD VSS VSS gf180mcu_fd_sc_mcu7t5v0__dffq_1
X_3519_ _3519_/I _7777_/D VDD VDD VSS VSS gf180mcu_fd_sc_mcu7t5v0__clkinv_1
XFILLER_104_779 VDD VDD VSS VSS gf180mcu_fd_sc_mcu7t5v0__fillcap_16
X_6238_ _6783_/Q _6242_/B1 _6238_/B _6240_/A1 VDD VDD VSS VSS gf180mcu_fd_sc_mcu7t5v0__oai21_1
X_6169_ _6169_/A1 _6169_/A2 _6196_/B _6170_/B2 VDD VDD VSS VSS gf180mcu_fd_sc_mcu7t5v0__oai21_1
XFILLER_84_173 VDD VDD VSS VSS gf180mcu_fd_sc_mcu7t5v0__fill_2
XFILLER_38_590 VDD VDD VSS VSS gf180mcu_fd_sc_mcu7t5v0__fillcap_4
XFILLER_45_549 VDD VDD VSS VSS gf180mcu_fd_sc_mcu7t5v0__fill_2
XFILLER_81_891 VDD VDD VSS VSS gf180mcu_fd_sc_mcu7t5v0__fill_1
XFILLER_14_947 VDD VDD VSS VSS gf180mcu_fd_sc_mcu7t5v0__fillcap_32
XFILLER_25_284 VDD VDD VSS VSS gf180mcu_fd_sc_mcu7t5v0__fill_1
XFILLER_41_766 VDD VDD VSS VSS gf180mcu_fd_sc_mcu7t5v0__fillcap_4
XFILLER_9_428 VDD VDD VSS VSS gf180mcu_fd_sc_mcu7t5v0__fill_1
XFILLER_4_37 VDD VDD VSS VSS gf180mcu_fd_sc_mcu7t5v0__fill_2
XFILLER_96_939 VDD VDD VSS VSS gf180mcu_fd_sc_mcu7t5v0__fillcap_4
XFILLER_64_858 VDD VDD VSS VSS gf180mcu_fd_sc_mcu7t5v0__fillcap_4
XTAP_TAPCELL_ROW_34_728 VDD VSS gf180mcu_fd_sc_mcu7t5v0__filltie
XTAP_TAPCELL_ROW_34_739 VDD VSS gf180mcu_fd_sc_mcu7t5v0__filltie
X_3870_ _4112_/A1 _4948_/A1 _3874_/A2 _5112_/A1 _3871_/A3 VDD VDD VSS VSS gf180mcu_fd_sc_mcu7t5v0__nand4_1
XTAP_TAPCELL_ROW_14_452 VDD VSS gf180mcu_fd_sc_mcu7t5v0__filltie
Xclkbuf_leaf_61_clk_i clkload3/I _7248_/CLK VDD VDD VSS VSS gf180mcu_fd_sc_mcu7t5v0__clkbuf_8
X_5540_ _5397_/B _5540_/A2 _5540_/A3 _5540_/B _5554_/I0 VDD VDD VSS VSS gf180mcu_fd_sc_mcu7t5v0__oai31_1
X_5471_ _7355_/Q wire428/Z _5511_/B1 _7348_/Q _7334_/Q _5607_/B1 _5472_/A3 VDD VDD
+ VSS VSS gf180mcu_fd_sc_mcu7t5v0__oai222_1
X_4422_ _5080_/A1 _4434_/A2 _4422_/B _6925_/D VDD VDD VSS VSS gf180mcu_fd_sc_mcu7t5v0__oai21_1
X_7210_ _7210_/D _7250_/CLK _7210_/Q VDD VDD VSS VSS gf180mcu_fd_sc_mcu7t5v0__dffq_1
Xclkbuf_leaf_76_clk_i clkbuf_3_1__f_clk_i/Z _7736_/CLK VDD VDD VSS VSS gf180mcu_fd_sc_mcu7t5v0__clkbuf_8
X_4353_ _6891_/Q _4364_/A2 _4354_/B VDD VDD VSS VSS gf180mcu_fd_sc_mcu7t5v0__nand2_1
X_7141_ _7141_/D _7253_/CLK _7141_/Q VDD VDD VSS VSS gf180mcu_fd_sc_mcu7t5v0__dffq_1
X_4284_ _4396_/A1 _4294_/A2 _4284_/B _6856_/D VDD VDD VSS VSS gf180mcu_fd_sc_mcu7t5v0__oai21_1
X_7072_ _7072_/D _7099_/CLK _7072_/Q VDD VDD VSS VSS gf180mcu_fd_sc_mcu7t5v0__dffq_1
Xfanout429 _5369_/ZN _6632_/A1 VDD VDD VSS VSS gf180mcu_fd_sc_mcu7t5v0__dlyd_1
Xfanout407 fanout409/Z _6233_/A2 VDD VDD VSS VSS gf180mcu_fd_sc_mcu7t5v0__dlyd_1
X_6023_ _7062_/Q _6151_/C2 _6023_/B _6204_/B _6026_/B VDD VDD VSS VSS gf180mcu_fd_sc_mcu7t5v0__oai211_1
Xclkbuf_leaf_14_clk_i clkload2/I _7796_/CLK VDD VDD VSS VSS gf180mcu_fd_sc_mcu7t5v0__clkbuf_8
X_6925_ _6925_/D _6939_/CLK _6925_/Q VDD VDD VSS VSS gf180mcu_fd_sc_mcu7t5v0__dffq_1
XTAP_TAPCELL_ROW_85_1450 VDD VSS gf180mcu_fd_sc_mcu7t5v0__filltie
X_6856_ _6856_/D _6915_/CLK _6856_/Q VDD VDD VSS VSS gf180mcu_fd_sc_mcu7t5v0__dffq_1
XFILLER_11_906 VDD VDD VSS VSS gf180mcu_fd_sc_mcu7t5v0__fillcap_4
XFILLER_23_766 VDD VDD VSS VSS gf180mcu_fd_sc_mcu7t5v0__fillcap_4
Xclkbuf_leaf_29_clk_i clkload5/I _7002_/CLK VDD VDD VSS VSS gf180mcu_fd_sc_mcu7t5v0__clkbuf_8
X_3999_ _3967_/I _3999_/A2 _4462_/A2 VDD VDD VSS VSS gf180mcu_fd_sc_mcu7t5v0__nand2_1
X_6787_ _6787_/D _7453_/CLK _6787_/Q VDD VDD VSS VSS gf180mcu_fd_sc_mcu7t5v0__dffq_1
XFILLER_50_585 VDD VDD VSS VSS gf180mcu_fd_sc_mcu7t5v0__fill_2
X_5807_ _5807_/A1 _5807_/A2 _5819_/A2 VDD VDD VSS VSS gf180mcu_fd_sc_mcu7t5v0__nand2_1
XFILLER_109_805 VDD VDD VSS VSS gf180mcu_fd_sc_mcu7t5v0__fillcap_16
X_5738_ input32/Z _5738_/A2 _5738_/B _7567_/D VDD VDD VSS VSS gf180mcu_fd_sc_mcu7t5v0__aoi21_1
X_5669_ _3747_/B _7783_/D _5669_/B _7547_/D VDD VDD VSS VSS gf180mcu_fd_sc_mcu7t5v0__oai21_1
X_7408_ _7408_/D _7456_/CLK _7408_/Q VDD VDD VSS VSS gf180mcu_fd_sc_mcu7t5v0__dffq_1
X_7339_ _7339_/D _7482_/CLK _7339_/Q VDD VDD VSS VSS gf180mcu_fd_sc_mcu7t5v0__dffq_1
XFILLER_78_939 VDD VDD VSS VSS gf180mcu_fd_sc_mcu7t5v0__fillcap_4
XFILLER_38_98 VDD VDD VSS VSS gf180mcu_fd_sc_mcu7t5v0__fill_1
XFILLER_45_357 VDD VDD VSS VSS gf180mcu_fd_sc_mcu7t5v0__fill_2
XFILLER_41_541 VDD VDD VSS VSS gf180mcu_fd_sc_mcu7t5v0__fillcap_16
XTAP_TAPCELL_ROW_11_411 VDD VSS gf180mcu_fd_sc_mcu7t5v0__filltie
Xclkload17 _7822_/CLK clkload17/ZN VDD VDD VSS VSS gf180mcu_fd_sc_mcu7t5v0__clkinv_2
Xclkload39 _7613_/CLK clkload39/ZN VDD VDD VSS VSS gf180mcu_fd_sc_mcu7t5v0__clkinv_2
Xclkload28 _7418_/CLK clkload28/Z VDD VDD VSS VSS gf180mcu_fd_sc_mcu7t5v0__clkbuf_4
XTAP_TAPCELL_ROW_56_1040 VDD VSS gf180mcu_fd_sc_mcu7t5v0__filltie
XFILLER_92_920 VDD VDD VSS VSS gf180mcu_fd_sc_mcu7t5v0__fillcap_16
XFILLER_83_419 VDD VDD VSS VSS gf180mcu_fd_sc_mcu7t5v0__fill_1
XTAP_TAPCELL_ROW_39_809 VDD VSS gf180mcu_fd_sc_mcu7t5v0__filltie
XTAP_TAPCELL_ROW_19_522 VDD VSS gf180mcu_fd_sc_mcu7t5v0__filltie
XFILLER_37_836 VDD VDD VSS VSS gf180mcu_fd_sc_mcu7t5v0__fillcap_4
X_4971_ _7200_/Q _4980_/A2 _4972_/B VDD VDD VSS VSS gf180mcu_fd_sc_mcu7t5v0__nand2_1
X_3922_ _7585_/Q _3911_/Z _3921_/Z _3922_/Z VDD VDD VSS VSS gf180mcu_fd_sc_mcu7t5v0__xor3_1
X_7690_ _7690_/D _7690_/RN _7692_/CLK _7690_/Q VDD VDD VSS VSS gf180mcu_fd_sc_mcu7t5v0__dffrnq_1
XFILLER_51_349 VDD VDD VSS VSS gf180mcu_fd_sc_mcu7t5v0__fill_1
X_6710_ _7753_/Q _6716_/A2 _6714_/B1 _7754_/Q _6711_/I VDD VDD VSS VSS gf180mcu_fd_sc_mcu7t5v0__aoi22_1
XTAP_TAPCELL_ROW_67_1191 VDD VSS gf180mcu_fd_sc_mcu7t5v0__filltie
X_6641_ _6641_/A1 _6638_/Z _6644_/A2 VDD VDD VSS VSS gf180mcu_fd_sc_mcu7t5v0__nand2_1
X_3853_ _3930_/A2 _6679_/I0 _3854_/B VDD VDD VSS VSS gf180mcu_fd_sc_mcu7t5v0__nand2_1
XTAP_TAPCELL_ROW_80_1380 VDD VSS gf180mcu_fd_sc_mcu7t5v0__filltie
X_6572_ _7707_/Q _7706_/Q _6574_/S _7707_/D VDD VDD VSS VSS gf180mcu_fd_sc_mcu7t5v0__mux2_2
X_3784_ _7746_/Q _6717_/A1 _6679_/S VDD VDD VSS VSS gf180mcu_fd_sc_mcu7t5v0__nand2_1
X_5523_ _5493_/S _5523_/A2 _5523_/B _5621_/A1 VDD VDD VSS VSS gf180mcu_fd_sc_mcu7t5v0__oai21_1
X_5454_ _7291_/Q _5610_/B1 _5613_/B1 _7494_/Q _5456_/A2 VDD VDD VSS VSS gf180mcu_fd_sc_mcu7t5v0__oai22_1
X_4405_ _6917_/Q _4406_/A2 _4406_/B VDD VDD VSS VSS gf180mcu_fd_sc_mcu7t5v0__nand2_1
X_5385_ _5397_/B _5385_/A2 _5385_/A3 _5385_/B1 _5385_/B2 _5399_/I0 VDD VDD VSS VSS
+ gf180mcu_fd_sc_mcu7t5v0__oai32_1
X_4336_ _4336_/A1 _4336_/A2 _4336_/B _6882_/D VDD VDD VSS VSS gf180mcu_fd_sc_mcu7t5v0__oai21_1
X_7124_ _7124_/D _7250_/CLK _7124_/Q VDD VDD VSS VSS gf180mcu_fd_sc_mcu7t5v0__dffq_1
Xfanout226 _5006_/A1 _5076_/A1 VDD VDD VSS VSS gf180mcu_fd_sc_mcu7t5v0__dlyd_1
X_4267_ _6848_/Q _4280_/A2 _4268_/B VDD VDD VSS VSS gf180mcu_fd_sc_mcu7t5v0__nand2_1
X_7055_ _7055_/D _7055_/CLK _7055_/Q VDD VDD VSS VSS gf180mcu_fd_sc_mcu7t5v0__dffq_1
XFILLER_87_769 VDD VDD VSS VSS gf180mcu_fd_sc_mcu7t5v0__fill_1
X_4198_ _6651_/A1 _4200_/A2 _5239_/S VDD VDD VSS VSS gf180mcu_fd_sc_mcu7t5v0__nand2_1
X_6006_ _3738_/B _6283_/B1 _6006_/B _6006_/C _6007_/B2 VDD VDD VSS VSS gf180mcu_fd_sc_mcu7t5v0__aoi211_1
XFILLER_95_780 VDD VDD VSS VSS gf180mcu_fd_sc_mcu7t5v0__fill_1
X_6908_ _6908_/D _7148_/CLK _6908_/Q VDD VDD VSS VSS gf180mcu_fd_sc_mcu7t5v0__dffq_1
X_6839_ _6839_/D _7254_/CLK _6839_/Q VDD VDD VSS VSS gf180mcu_fd_sc_mcu7t5v0__dffq_1
XTAP_TAPCELL_ROW_98_1630 VDD VSS gf180mcu_fd_sc_mcu7t5v0__filltie
XFILLER_109_679 VDD VDD VSS VSS gf180mcu_fd_sc_mcu7t5v0__fill_1
XFILLER_19_836 VDD VDD VSS VSS gf180mcu_fd_sc_mcu7t5v0__fillcap_4
XFILLER_46_677 VDD VDD VSS VSS gf180mcu_fd_sc_mcu7t5v0__fillcap_4
XFILLER_33_305 VDD VDD VSS VSS gf180mcu_fd_sc_mcu7t5v0__fill_1
XFILLER_61_614 VDD VDD VSS VSS gf180mcu_fd_sc_mcu7t5v0__fillcap_8
XFILLER_60_135 VDD VDD VSS VSS gf180mcu_fd_sc_mcu7t5v0__fill_1
XTAP_TAPCELL_ROW_44_878 VDD VSS gf180mcu_fd_sc_mcu7t5v0__filltie
XTAP_TAPCELL_ROW_24_591 VDD VSS gf180mcu_fd_sc_mcu7t5v0__filltie
X_5170_ _5345_/I0 _7317_/Q _5176_/S _7317_/D VDD VDD VSS VSS gf180mcu_fd_sc_mcu7t5v0__mux2_2
X_4121_ _6791_/Q _4994_/A2 _4122_/B VDD VDD VSS VSS gf180mcu_fd_sc_mcu7t5v0__nand2_1
X_4052_ _4146_/A1 _4686_/A2 _4052_/B _6769_/D VDD VDD VSS VSS gf180mcu_fd_sc_mcu7t5v0__oai21_1
XFILLER_49_460 VDD VDD VSS VSS gf180mcu_fd_sc_mcu7t5v0__fill_1
XFILLER_110_387 VDD VDD VSS VSS gf180mcu_fd_sc_mcu7t5v0__fill_2
Xinput4 alert_rx_i[3] input4/Z VDD VDD VSS VSS gf180mcu_fd_sc_mcu7t5v0__dlyd_1
XTAP_TAPCELL_ROW_69_1220 VDD VSS gf180mcu_fd_sc_mcu7t5v0__filltie
XTAP_TAPCELL_ROW_69_1231 VDD VSS gf180mcu_fd_sc_mcu7t5v0__filltie
X_7811_ _7811_/D _7811_/RN clkload8/I _7811_/Q VDD VDD VSS VSS gf180mcu_fd_sc_mcu7t5v0__dffrnq_1
XFILLER_91_282 VDD VDD VSS VSS gf180mcu_fd_sc_mcu7t5v0__fill_1
X_7742_ _7742_/D _7742_/RN _7793_/CLK _7742_/Q VDD VDD VSS VSS gf180mcu_fd_sc_mcu7t5v0__dffrnq_1
X_4954_ _4996_/A1 _4966_/A2 _4954_/B _7191_/D VDD VDD VSS VSS gf180mcu_fd_sc_mcu7t5v0__oai21_1
X_3905_ _7587_/Q _3823_/Z _3905_/Z VDD VDD VSS VSS gf180mcu_fd_sc_mcu7t5v0__xor2_1
XFILLER_20_522 VDD VDD VSS VSS gf180mcu_fd_sc_mcu7t5v0__fill_2
X_4885_ _7157_/Q _4896_/A2 _4886_/B VDD VDD VSS VSS gf180mcu_fd_sc_mcu7t5v0__nand2_1
X_7673_ _7673_/D _7800_/RN _7802_/CLK _7673_/Q VDD VDD VSS VSS gf180mcu_fd_sc_mcu7t5v0__dffrnq_1
X_3836_ _7602_/Q _7603_/Q _3836_/Z VDD VDD VSS VSS gf180mcu_fd_sc_mcu7t5v0__xor2_1
X_6624_ _7793_/Q _6624_/A2 _6635_/A3 VDD VDD VSS VSS gf180mcu_fd_sc_mcu7t5v0__nor2_1
X_3767_ _6372_/A1 _3759_/B _7780_/D VDD VDD VSS VSS gf180mcu_fd_sc_mcu7t5v0__nand2_1
X_6555_ _7694_/Q _6552_/Z _6555_/Z VDD VDD VSS VSS gf180mcu_fd_sc_mcu7t5v0__and2_1
X_5506_ _7335_/Q wire420/Z _5594_/B1 _7342_/Q _7349_/Q _5593_/A2 _5518_/A3 VDD VDD
+ VSS VSS gf180mcu_fd_sc_mcu7t5v0__oai222_1
X_3698_ input18/Z _6303_/S _3685_/B _5630_/B VDD VDD VSS VSS gf180mcu_fd_sc_mcu7t5v0__nand3_1
X_6486_ _6486_/A1 _7799_/D _3502_/I _7800_/Q _6486_/C _6487_/C VDD VDD VSS VSS gf180mcu_fd_sc_mcu7t5v0__aoi221_1
XTAP_TAPCELL_ROW_93_1560 VDD VSS gf180mcu_fd_sc_mcu7t5v0__filltie
X_5437_ _5531_/B _5437_/A2 _5437_/A3 _5460_/A2 VDD VDD VSS VSS gf180mcu_fd_sc_mcu7t5v0__nor3_1
X_5368_ _7726_/Q _7727_/Q _5368_/Z VDD VDD VSS VSS gf180mcu_fd_sc_mcu7t5v0__and2_1
XFILLER_102_855 VDD VDD VSS VSS gf180mcu_fd_sc_mcu7t5v0__fillcap_8
X_4319_ _6874_/Q _4322_/A2 _4320_/B VDD VDD VSS VSS gf180mcu_fd_sc_mcu7t5v0__nand2_1
X_5299_ wire525/I _7446_/Q _5302_/S _7446_/D VDD VDD VSS VSS gf180mcu_fd_sc_mcu7t5v0__mux2_2
X_7107_ _7107_/D _7118_/CLK _7107_/Q VDD VDD VSS VSS gf180mcu_fd_sc_mcu7t5v0__dffq_1
X_7038_ _7038_/D _7062_/CLK _7038_/Q VDD VDD VSS VSS gf180mcu_fd_sc_mcu7t5v0__dffq_1
XFILLER_47_419 VDD VDD VSS VSS gf180mcu_fd_sc_mcu7t5v0__fill_1
XFILLER_59_268 VDD VDD VSS VSS gf180mcu_fd_sc_mcu7t5v0__fill_2
XFILLER_83_750 VDD VDD VSS VSS gf180mcu_fd_sc_mcu7t5v0__fill_1
XFILLER_71_901 VDD VDD VSS VSS gf180mcu_fd_sc_mcu7t5v0__fill_2
XTAP_TAPCELL_ROW_2_286 VDD VSS gf180mcu_fd_sc_mcu7t5v0__filltie
XFILLER_11_500 VDD VDD VSS VSS gf180mcu_fd_sc_mcu7t5v0__fillcap_8
XTAP_TAPCELL_ROW_41_826 VDD VSS gf180mcu_fd_sc_mcu7t5v0__filltie
XTAP_TAPCELL_ROW_41_837 VDD VSS gf180mcu_fd_sc_mcu7t5v0__filltie
XTAP_TAPCELL_ROW_21_550 VDD VSS gf180mcu_fd_sc_mcu7t5v0__filltie
Xload_slew418 _5507_/B1 _5607_/B1 VDD VDD VSS VSS gf180mcu_fd_sc_mcu7t5v0__clkbuf_4
Xuart_641 tl_o[59] VDD VDD VSS VSS gf180mcu_fd_sc_mcu7t5v0__tiel
XFILLER_2_275 VDD VDD VSS VSS gf180mcu_fd_sc_mcu7t5v0__fill_1
Xuart_630 racl_error_o[34] VDD VDD VSS VSS gf180mcu_fd_sc_mcu7t5v0__tiel
XTAP_TAPCELL_ROW_49_948 VDD VSS gf180mcu_fd_sc_mcu7t5v0__filltie
XFILLER_93_558 VDD VDD VSS VSS gf180mcu_fd_sc_mcu7t5v0__fill_2
XTAP_TAPCELL_ROW_105_1729 VDD VSS gf180mcu_fd_sc_mcu7t5v0__filltie
XTAP_TAPCELL_ROW_29_661 VDD VSS gf180mcu_fd_sc_mcu7t5v0__filltie
XTAP_TAPCELL_ROW_64_1150 VDD VSS gf180mcu_fd_sc_mcu7t5v0__filltie
XTAP_TAPCELL_ROW_64_1161 VDD VSS gf180mcu_fd_sc_mcu7t5v0__filltie
X_4670_ _4964_/A1 _4672_/A2 _4670_/B _7049_/D VDD VDD VSS VSS gf180mcu_fd_sc_mcu7t5v0__oai21_1
X_3621_ _3543_/Z _3544_/Z _3620_/Z _3663_/A2 VDD VDD VSS VSS gf180mcu_fd_sc_mcu7t5v0__xnor3_1
X_3552_ input39/Z input45/Z _3552_/Z VDD VDD VSS VSS gf180mcu_fd_sc_mcu7t5v0__xor2_1
X_6340_ _6340_/A1 _6344_/S _6340_/B _7630_/D VDD VDD VSS VSS gf180mcu_fd_sc_mcu7t5v0__oai21_1
XFILLER_116_947 VDD VDD VSS VSS gf180mcu_fd_sc_mcu7t5v0__fillcap_32
XFILLER_51_2 VDD VDD VSS VSS gf180mcu_fd_sc_mcu7t5v0__fill_1
X_6271_ _7521_/Q _6283_/C1 _6271_/B1 _7631_/Q _6271_/C _6272_/B2 VDD VDD VSS VSS gf180mcu_fd_sc_mcu7t5v0__aoi221_1
X_3483_ _3488_/A2 _3483_/A2 _3484_/I VDD VDD VSS VSS gf180mcu_fd_sc_mcu7t5v0__nand2_1
X_5222_ _5243_/I0 _7369_/Q _5225_/S _7369_/D VDD VDD VSS VSS gf180mcu_fd_sc_mcu7t5v0__mux2_2
X_5153_ wire521/Z _7300_/Q _5155_/S _7300_/D VDD VDD VSS VSS gf180mcu_fd_sc_mcu7t5v0__mux2_2
XFILLER_84_503 VDD VDD VSS VSS gf180mcu_fd_sc_mcu7t5v0__fill_2
XFILLER_29_419 VDD VDD VSS VSS gf180mcu_fd_sc_mcu7t5v0__fill_1
X_4104_ _4132_/A1 _4110_/A2 _4924_/A2 VDD VDD VSS VSS gf180mcu_fd_sc_mcu7t5v0__nand2_1
X_5084_ _5098_/A1 _5092_/A2 _5084_/B _7256_/D VDD VDD VSS VSS gf180mcu_fd_sc_mcu7t5v0__oai21_1
X_4035_ _4150_/A2 _4053_/A2 _4616_/A2 VDD VDD VSS VSS gf180mcu_fd_sc_mcu7t5v0__nand2_1
XFILLER_37_441 VDD VDD VSS VSS gf180mcu_fd_sc_mcu7t5v0__fill_2
XFILLER_53_912 VDD VDD VSS VSS gf180mcu_fd_sc_mcu7t5v0__fillcap_64
X_5986_ _7075_/Q _6104_/B1 _6171_/A2 _7082_/Q _5988_/A1 VDD VDD VSS VSS gf180mcu_fd_sc_mcu7t5v0__oai22_1
X_4937_ _7183_/Q _4938_/A2 _4938_/B VDD VDD VSS VSS gf180mcu_fd_sc_mcu7t5v0__nand2_1
X_7725_ _7725_/D _7800_/RN _7796_/CLK _7725_/Q VDD VDD VSS VSS gf180mcu_fd_sc_mcu7t5v0__dffrnq_1
XANTENNA_20 _3818_/ZN VDD VDD VSS VSS gf180mcu_fd_sc_mcu7t5v0__antenna
X_7656_ _7656_/D _7657_/RN _7695_/CLK _7656_/Q VDD VDD VSS VSS gf180mcu_fd_sc_mcu7t5v0__dffrnq_1
X_4868_ _5134_/A1 _4868_/A2 _4868_/B _7148_/D VDD VDD VSS VSS gf180mcu_fd_sc_mcu7t5v0__oai21_1
XFILLER_21_842 VDD VDD VSS VSS gf180mcu_fd_sc_mcu7t5v0__fillcap_64
X_3819_ _7585_/Q _7584_/Q _3819_/Z VDD VDD VSS VSS gf180mcu_fd_sc_mcu7t5v0__xor2_1
X_6607_ _6621_/B _6606_/Z _7718_/D VDD VDD VSS VSS gf180mcu_fd_sc_mcu7t5v0__nor2_1
XFILLER_118_240 VDD VDD VSS VSS gf180mcu_fd_sc_mcu7t5v0__fill_2
X_7587_ _7587_/D _7614_/RN _7695_/CLK _7587_/Q VDD VDD VSS VSS gf180mcu_fd_sc_mcu7t5v0__dffrnq_1
X_4799_ _7114_/Q _4812_/A2 _4800_/B VDD VDD VSS VSS gf180mcu_fd_sc_mcu7t5v0__nand2_1
X_6538_ _6538_/A1 _6538_/A2 _6537_/Z _7688_/D VDD VDD VSS VSS gf180mcu_fd_sc_mcu7t5v0__nor3_1
X_6469_ _6469_/A1 _6469_/A2 _6469_/B _6469_/C _6473_/A2 VDD VDD VSS VSS gf180mcu_fd_sc_mcu7t5v0__oai211_1
Xoutput160 _7598_/Q tl_o[42] VDD VDD VSS VSS gf180mcu_fd_sc_mcu7t5v0__dlyd_1
Xoutput182 _3847_/Z tl_o[8] VDD VDD VSS VSS gf180mcu_fd_sc_mcu7t5v0__dlyd_1
Xoutput171 _7608_/Q tl_o[53] VDD VDD VSS VSS gf180mcu_fd_sc_mcu7t5v0__dlyd_1
XTAP_TAPCELL_ROW_7_356 VDD VSS gf180mcu_fd_sc_mcu7t5v0__filltie
XPHY_EDGE_ROW_102_Right_102 VDD VSS gf180mcu_fd_sc_mcu7t5v0__endcap
XFILLER_87_385 VDD VDD VSS VSS gf180mcu_fd_sc_mcu7t5v0__fill_1
XFILLER_75_547 VDD VDD VSS VSS gf180mcu_fd_sc_mcu7t5v0__fill_1
XTAP_TAPCELL_ROW_46_907 VDD VSS gf180mcu_fd_sc_mcu7t5v0__filltie
XFILLER_56_794 VDD VDD VSS VSS gf180mcu_fd_sc_mcu7t5v0__fill_2
XTAP_TAPCELL_ROW_26_620 VDD VSS gf180mcu_fd_sc_mcu7t5v0__filltie
XTAP_TAPCELL_ROW_100_1659 VDD VSS gf180mcu_fd_sc_mcu7t5v0__filltie
XFILLER_11_352 VDD VDD VSS VSS gf180mcu_fd_sc_mcu7t5v0__fill_2
XFILLER_7_378 VDD VDD VSS VSS gf180mcu_fd_sc_mcu7t5v0__fill_2
XFILLER_113_906 VDD VDD VSS VSS gf180mcu_fd_sc_mcu7t5v0__fillcap_4
XFILLER_3_562 VDD VDD VSS VSS gf180mcu_fd_sc_mcu7t5v0__fillcap_64
Xload_slew237 _4402_/A1 _4822_/A1 VDD VDD VSS VSS gf180mcu_fd_sc_mcu7t5v0__clkbuf_4
Xload_slew215 fanout214/Z _5098_/A1 VDD VDD VSS VSS gf180mcu_fd_sc_mcu7t5v0__buf_2
Xload_slew259 _5100_/A1 _5086_/A1 VDD VDD VSS VSS gf180mcu_fd_sc_mcu7t5v0__clkbuf_4
XFILLER_87_72 VDD VDD VSS VSS gf180mcu_fd_sc_mcu7t5v0__fill_2
XFILLER_66_569 VDD VDD VSS VSS gf180mcu_fd_sc_mcu7t5v0__fillcap_4
XFILLER_35_912 VDD VDD VSS VSS gf180mcu_fd_sc_mcu7t5v0__fillcap_64
X_5840_ _5840_/A1 _5840_/A2 _5840_/B _5926_/B _5847_/C VDD VDD VSS VSS gf180mcu_fd_sc_mcu7t5v0__oai211_1
X_5771_ _5771_/A1 _5771_/A2 _5771_/B _5778_/A2 VDD VDD VSS VSS gf180mcu_fd_sc_mcu7t5v0__oai21_1
X_4722_ _4988_/A1 _4728_/A2 _4722_/B _7075_/D VDD VDD VSS VSS gf180mcu_fd_sc_mcu7t5v0__oai21_1
X_7510_ _7510_/D fanout543/Z _7765_/CLK _7510_/Q VDD VDD VSS VSS gf180mcu_fd_sc_mcu7t5v0__dffsnq_1
XTAP_TAPCELL_ROW_118_1909 VDD VSS gf180mcu_fd_sc_mcu7t5v0__filltie
X_7441_ _7441_/D _7822_/CLK _7441_/Q VDD VDD VSS VSS gf180mcu_fd_sc_mcu7t5v0__dffq_1
XFILLER_30_661 VDD VDD VSS VSS gf180mcu_fd_sc_mcu7t5v0__fillcap_4
X_4653_ _7041_/Q _4658_/A2 _4654_/B VDD VDD VSS VSS gf180mcu_fd_sc_mcu7t5v0__nand2_1
Xinput40 tl_i[39] input40/Z VDD VDD VSS VSS gf180mcu_fd_sc_mcu7t5v0__dlyd_1
X_4584_ _4584_/A1 _4588_/A2 _4584_/B _7006_/D VDD VDD VSS VSS gf180mcu_fd_sc_mcu7t5v0__oai21_1
Xinput73 tl_i[69] _7881_/I VDD VDD VSS VSS gf180mcu_fd_sc_mcu7t5v0__dlyd_1
XTAP_TAPCELL_ROW_77_1341 VDD VSS gf180mcu_fd_sc_mcu7t5v0__filltie
XTAP_TAPCELL_ROW_77_1330 VDD VSS gf180mcu_fd_sc_mcu7t5v0__filltie
Xinput62 tl_i[59] input62/Z VDD VDD VSS VSS gf180mcu_fd_sc_mcu7t5v0__dlyd_1
X_7372_ _7372_/D _7736_/CLK _7372_/Q VDD VDD VSS VSS gf180mcu_fd_sc_mcu7t5v0__dffq_1
X_3604_ _3551_/Z _3556_/Z _3661_/B VDD VDD VSS VSS gf180mcu_fd_sc_mcu7t5v0__nand2_1
Xinput51 tl_i[49] input51/Z VDD VDD VSS VSS gf180mcu_fd_sc_mcu7t5v0__dlyd_1
XFILLER_116_766 VDD VDD VSS VSS gf180mcu_fd_sc_mcu7t5v0__fillcap_32
X_6323_ input34/Z _6331_/S _6324_/B VDD VDD VSS VSS gf180mcu_fd_sc_mcu7t5v0__nand2_1
Xinput95 tl_i[89] input95/Z VDD VDD VSS VSS gf180mcu_fd_sc_mcu7t5v0__dlyd_1
Xinput84 tl_i[79] input84/Z VDD VDD VSS VSS gf180mcu_fd_sc_mcu7t5v0__dlyd_1
X_3535_ input68/Z input67/Z _3535_/Z VDD VDD VSS VSS gf180mcu_fd_sc_mcu7t5v0__xor2_1
X_3466_ _3466_/A1 _7819_/Q _3471_/A1 VDD VDD VSS VSS gf180mcu_fd_sc_mcu7t5v0__nor2_1
X_6254_ _7541_/Q _6256_/A2 _6254_/B1 _7704_/Q _6254_/C _6255_/B2 VDD VDD VSS VSS gf180mcu_fd_sc_mcu7t5v0__aoi221_1
X_5205_ _6353_/I0 _7352_/Q _5211_/S _7352_/D VDD VDD VSS VSS gf180mcu_fd_sc_mcu7t5v0__mux2_2
X_6185_ _6184_/C _6185_/A2 _6185_/B _6246_/C _6189_/A1 VDD VDD VSS VSS gf180mcu_fd_sc_mcu7t5v0__oai211_1
XTAP_TAPCELL_ROW_4_315 VDD VSS gf180mcu_fd_sc_mcu7t5v0__filltie
X_3397_ _7618_/Q _6322_/A1 VDD VDD VSS VSS gf180mcu_fd_sc_mcu7t5v0__clkinv_1
X_5136_ _6354_/I0 _7283_/Q _5141_/S _7283_/D VDD VDD VSS VSS gf180mcu_fd_sc_mcu7t5v0__mux2_2
XFILLER_29_249 VDD VDD VSS VSS gf180mcu_fd_sc_mcu7t5v0__fill_1
X_5067_ _7248_/Q _5074_/A2 _5068_/B VDD VDD VSS VSS gf180mcu_fd_sc_mcu7t5v0__nor2_1
X_4018_ _4132_/A1 _4027_/A2 _4546_/A2 VDD VDD VSS VSS gf180mcu_fd_sc_mcu7t5v0__nand2_1
XTAP_TAPCELL_ROW_88_1492 VDD VSS gf180mcu_fd_sc_mcu7t5v0__filltie
XFILLER_37_282 VDD VDD VSS VSS gf180mcu_fd_sc_mcu7t5v0__fill_2
X_5969_ _6970_/Q _6092_/C2 _5969_/B1 _6963_/Q _6956_/Q _6092_/B1 _5970_/A2 VDD VDD
+ VSS VSS gf180mcu_fd_sc_mcu7t5v0__oai222_1
XFILLER_80_583 VDD VDD VSS VSS gf180mcu_fd_sc_mcu7t5v0__fillcap_4
X_7708_ _7708_/D _7708_/RN _7781_/CLK _7708_/Q VDD VDD VSS VSS gf180mcu_fd_sc_mcu7t5v0__dffrnq_1
XFILLER_32_34 VDD VDD VSS VSS gf180mcu_fd_sc_mcu7t5v0__fill_1
XTAP_TAPCELL_ROW_51_976 VDD VSS gf180mcu_fd_sc_mcu7t5v0__filltie
XFILLER_32_89 VDD VDD VSS VSS gf180mcu_fd_sc_mcu7t5v0__fill_2
X_7639_ _7639_/D _7782_/RN _7804_/CLK _7639_/Q VDD VDD VSS VSS gf180mcu_fd_sc_mcu7t5v0__dffrnq_1
XFILLER_48_514 VDD VDD VSS VSS gf180mcu_fd_sc_mcu7t5v0__fill_2
XFILLER_17_912 VDD VDD VSS VSS gf180mcu_fd_sc_mcu7t5v0__fillcap_64
XFILLER_29_772 VDD VDD VSS VSS gf180mcu_fd_sc_mcu7t5v0__fillcap_64
XFILLER_12_661 VDD VDD VSS VSS gf180mcu_fd_sc_mcu7t5v0__fillcap_4
XFILLER_40_981 VDD VDD VSS VSS gf180mcu_fd_sc_mcu7t5v0__fill_1
XTAP_TAPCELL_ROW_113_1839 VDD VSS gf180mcu_fd_sc_mcu7t5v0__filltie
XFILLER_4_871 VDD VDD VSS VSS gf180mcu_fd_sc_mcu7t5v0__fillcap_4
XTAP_TAPCELL_ROW_59_1082 VDD VSS gf180mcu_fd_sc_mcu7t5v0__filltie
XFILLER_113_769 VDD VDD VSS VSS gf180mcu_fd_sc_mcu7t5v0__fill_1
XFILLER_3_392 VDD VDD VSS VSS gf180mcu_fd_sc_mcu7t5v0__fill_2
XTAP_TAPCELL_ROW_72_1260 VDD VSS gf180mcu_fd_sc_mcu7t5v0__filltie
XTAP_TAPCELL_ROW_72_1271 VDD VSS gf180mcu_fd_sc_mcu7t5v0__filltie
XFILLER_79_683 VDD VDD VSS VSS gf180mcu_fd_sc_mcu7t5v0__fill_2
XFILLER_39_558 VDD VDD VSS VSS gf180mcu_fd_sc_mcu7t5v0__fill_2
X_6941_ _6941_/D _7261_/CLK _6941_/Q VDD VDD VSS VSS gf180mcu_fd_sc_mcu7t5v0__dffq_1
XFILLER_82_848 VDD VDD VSS VSS gf180mcu_fd_sc_mcu7t5v0__fill_1
X_6872_ _6872_/D _7683_/CLK _6872_/Q VDD VDD VSS VSS gf180mcu_fd_sc_mcu7t5v0__dffq_1
X_5823_ _7066_/Q _6225_/A2 _6197_/A2 _6912_/Q _5823_/C _5824_/A2 VDD VDD VSS VSS gf180mcu_fd_sc_mcu7t5v0__oai221_1
XTAP_TAPCELL_ROW_17_494 VDD VSS gf180mcu_fd_sc_mcu7t5v0__filltie
X_5754_ _7712_/Q _5754_/A2 _5754_/ZN VDD VDD VSS VSS gf180mcu_fd_sc_mcu7t5v0__nand2_1
X_4705_ _7067_/Q _4714_/A2 _4706_/B VDD VDD VSS VSS gf180mcu_fd_sc_mcu7t5v0__nand2_1
X_5685_ _7559_/Q input32/Z _5686_/S _7559_/D VDD VDD VSS VSS gf180mcu_fd_sc_mcu7t5v0__mux2_2
X_4636_ _4748_/A1 _4644_/A2 _4636_/B _7032_/D VDD VDD VSS VSS gf180mcu_fd_sc_mcu7t5v0__oai21_1
X_7424_ _7424_/D _7754_/CLK _7424_/Q VDD VDD VSS VSS gf180mcu_fd_sc_mcu7t5v0__dffq_1
X_7355_ _7355_/D clkload9/I _7355_/Q VDD VDD VSS VSS gf180mcu_fd_sc_mcu7t5v0__dffq_1
X_6306_ _7607_/Q input8/Z _6310_/S _7607_/D VDD VDD VSS VSS gf180mcu_fd_sc_mcu7t5v0__mux2_2
X_4567_ _6998_/Q _4574_/A2 _4568_/B VDD VDD VSS VSS gf180mcu_fd_sc_mcu7t5v0__nand2_1
X_4498_ _4540_/A1 _4504_/A2 _4498_/B _6963_/D VDD VDD VSS VSS gf180mcu_fd_sc_mcu7t5v0__oai21_1
X_7286_ _7286_/D _7482_/CLK _7286_/Q VDD VDD VSS VSS gf180mcu_fd_sc_mcu7t5v0__dffq_1
X_3518_ _7774_/Q _7773_/Q _3518_/B _3519_/I VDD VDD VSS VSS gf180mcu_fd_sc_mcu7t5v0__oai21_1
X_3449_ _7573_/Q _5884_/A1 VDD VDD VSS VSS gf180mcu_fd_sc_mcu7t5v0__clkinv_1
X_6237_ _6237_/A1 _6237_/A2 _6237_/B _6244_/A2 VDD VDD VSS VSS gf180mcu_fd_sc_mcu7t5v0__oai21_1
X_6168_ _6945_/Q wire416/Z wire313/Z _6931_/Q _6227_/C _6169_/A2 VDD VDD VSS VSS gf180mcu_fd_sc_mcu7t5v0__oai221_1
XFILLER_98_981 VDD VDD VSS VSS gf180mcu_fd_sc_mcu7t5v0__fill_1
XFILLER_58_812 VDD VDD VSS VSS gf180mcu_fd_sc_mcu7t5v0__fill_2
XFILLER_100_931 VDD VDD VSS VSS gf180mcu_fd_sc_mcu7t5v0__fillcap_8
X_5119_ _7274_/Q _5120_/A2 _5120_/B VDD VDD VSS VSS gf180mcu_fd_sc_mcu7t5v0__nand2_1
Xload_slew590 _7802_/RN _7694_/RN VDD VDD VSS VSS gf180mcu_fd_sc_mcu7t5v0__buf_4
X_6099_ _6099_/A1 _6099_/A2 _6109_/A1 VDD VDD VSS VSS gf180mcu_fd_sc_mcu7t5v0__nor2_1
XFILLER_26_731 VDD VDD VSS VSS gf180mcu_fd_sc_mcu7t5v0__fillcap_4
XFILLER_53_550 VDD VDD VSS VSS gf180mcu_fd_sc_mcu7t5v0__fillcap_4
XFILLER_13_458 VDD VDD VSS VSS gf180mcu_fd_sc_mcu7t5v0__fill_1
XFILLER_22_981 VDD VDD VSS VSS gf180mcu_fd_sc_mcu7t5v0__fill_1
XFILLER_96_907 VDD VDD VSS VSS gf180mcu_fd_sc_mcu7t5v0__fillcap_32
XFILLER_49_823 VDD VDD VSS VSS gf180mcu_fd_sc_mcu7t5v0__fill_2
XFILLER_49_834 VDD VDD VSS VSS gf180mcu_fd_sc_mcu7t5v0__fillcap_4
XFILLER_48_377 VDD VDD VSS VSS gf180mcu_fd_sc_mcu7t5v0__fill_1
XFILLER_49_889 VDD VDD VSS VSS gf180mcu_fd_sc_mcu7t5v0__fillcap_16
XFILLER_90_177 VDD VDD VSS VSS gf180mcu_fd_sc_mcu7t5v0__fill_2
XTAP_TAPCELL_ROW_34_729 VDD VSS gf180mcu_fd_sc_mcu7t5v0__filltie
XFILLER_44_594 VDD VDD VSS VSS gf180mcu_fd_sc_mcu7t5v0__fill_1
XTAP_TAPCELL_ROW_14_453 VDD VSS gf180mcu_fd_sc_mcu7t5v0__filltie
XFILLER_31_277 VDD VDD VSS VSS gf180mcu_fd_sc_mcu7t5v0__fill_2
X_5470_ _7341_/Q _5511_/C2 _5472_/A2 VDD VDD VSS VSS gf180mcu_fd_sc_mcu7t5v0__nor2_1
XFILLER_117_349 VDD VDD VSS VSS gf180mcu_fd_sc_mcu7t5v0__fill_1
X_4421_ _6925_/Q _4434_/A2 _4422_/B VDD VDD VSS VSS gf180mcu_fd_sc_mcu7t5v0__nand2_1
XTAP_TAPCELL_ROW_74_1300 VDD VSS gf180mcu_fd_sc_mcu7t5v0__filltie
X_4352_ _4506_/A1 _4364_/A2 _4352_/B _6890_/D VDD VDD VSS VSS gf180mcu_fd_sc_mcu7t5v0__oai21_1
X_7140_ _7140_/D _7248_/CLK _7140_/Q VDD VDD VSS VSS gf180mcu_fd_sc_mcu7t5v0__dffq_1
XFILLER_99_767 VDD VDD VSS VSS gf180mcu_fd_sc_mcu7t5v0__fill_2
X_4283_ _6856_/Q _4294_/A2 _4284_/B VDD VDD VSS VSS gf180mcu_fd_sc_mcu7t5v0__nand2_1
X_7071_ _7071_/D _7252_/CLK _7071_/Q VDD VDD VSS VSS gf180mcu_fd_sc_mcu7t5v0__dffq_1
Xfanout419 _5372_/Z wire420/I VDD VDD VSS VSS gf180mcu_fd_sc_mcu7t5v0__dlyd_1
XFILLER_101_728 VDD VDD VSS VSS gf180mcu_fd_sc_mcu7t5v0__fillcap_4
X_6022_ _6022_/I _6023_/B VDD VDD VSS VSS gf180mcu_fd_sc_mcu7t5v0__clkinv_1
XFILLER_67_697 VDD VDD VSS VSS gf180mcu_fd_sc_mcu7t5v0__fill_2
X_6924_ _6924_/D _6944_/CLK _6924_/Q VDD VDD VSS VSS gf180mcu_fd_sc_mcu7t5v0__dffq_1
XTAP_TAPCELL_ROW_85_1451 VDD VSS gf180mcu_fd_sc_mcu7t5v0__filltie
X_6855_ _6855_/D _7683_/CLK _6855_/Q VDD VDD VSS VSS gf180mcu_fd_sc_mcu7t5v0__dffq_1
X_3998_ _4143_/A1 _4448_/A2 _3998_/B _6752_/D VDD VDD VSS VSS gf180mcu_fd_sc_mcu7t5v0__oai21_1
X_6786_ _6786_/D _7453_/CLK _6786_/Q VDD VDD VSS VSS gf180mcu_fd_sc_mcu7t5v0__dffq_1
X_5806_ _6244_/C _5806_/A2 _5806_/B _6184_/C _5807_/A2 VDD VDD VSS VSS gf180mcu_fd_sc_mcu7t5v0__oai211_1
X_5737_ input32/Z _6373_/S _5737_/B _7567_/Q _5738_/B VDD VDD VSS VSS gf180mcu_fd_sc_mcu7t5v0__aoi211_1
X_7407_ _7407_/D _7451_/CLK _7407_/Q VDD VDD VSS VSS gf180mcu_fd_sc_mcu7t5v0__dffq_1
X_5668_ input34/Z _7783_/D _5669_/B VDD VDD VSS VSS gf180mcu_fd_sc_mcu7t5v0__nand2_1
X_4619_ _7024_/Q _4630_/A2 _4620_/B VDD VDD VSS VSS gf180mcu_fd_sc_mcu7t5v0__nand2_1
X_5599_ _6826_/Q _5599_/A2 _5599_/B _5601_/A1 VDD VDD VSS VSS gf180mcu_fd_sc_mcu7t5v0__oai21_1
XFILLER_116_382 VDD VDD VSS VSS gf180mcu_fd_sc_mcu7t5v0__fill_1
X_7338_ _7338_/D _7804_/CLK _7338_/Q VDD VDD VSS VSS gf180mcu_fd_sc_mcu7t5v0__dffq_1
X_7269_ _7269_/D _7279_/CLK _7269_/Q VDD VDD VSS VSS gf180mcu_fd_sc_mcu7t5v0__dffq_1
XFILLER_77_428 VDD VDD VSS VSS gf180mcu_fd_sc_mcu7t5v0__fill_1
XFILLER_72_177 VDD VDD VSS VSS gf180mcu_fd_sc_mcu7t5v0__fill_2
XFILLER_26_594 VDD VDD VSS VSS gf180mcu_fd_sc_mcu7t5v0__fill_1
XTAP_TAPCELL_ROW_11_412 VDD VSS gf180mcu_fd_sc_mcu7t5v0__filltie
Xclkload18 _7823_/CLK clkload18/ZN VDD VDD VSS VSS gf180mcu_fd_sc_mcu7t5v0__inv_4
Xclkload29 _7492_/CLK clkload29/ZN VDD VDD VSS VSS gf180mcu_fd_sc_mcu7t5v0__inv_2
XTAP_TAPCELL_ROW_56_1041 VDD VSS gf180mcu_fd_sc_mcu7t5v0__filltie
XFILLER_69_907 VDD VDD VSS VSS gf180mcu_fd_sc_mcu7t5v0__fill_2
XFILLER_77_973 VDD VDD VSS VSS gf180mcu_fd_sc_mcu7t5v0__fillcap_4
XTAP_TAPCELL_ROW_19_523 VDD VSS gf180mcu_fd_sc_mcu7t5v0__filltie
XFILLER_49_697 VDD VDD VSS VSS gf180mcu_fd_sc_mcu7t5v0__fill_2
XFILLER_64_667 VDD VDD VSS VSS gf180mcu_fd_sc_mcu7t5v0__fill_1
XFILLER_64_656 VDD VDD VSS VSS gf180mcu_fd_sc_mcu7t5v0__fill_1
XFILLER_17_550 VDD VDD VSS VSS gf180mcu_fd_sc_mcu7t5v0__fillcap_8
X_4970_ _4998_/A1 _4980_/A2 _4970_/B _7199_/D VDD VDD VSS VSS gf180mcu_fd_sc_mcu7t5v0__oai21_1
X_3921_ _7596_/Q _7599_/Q _3833_/Z _3921_/Z VDD VDD VSS VSS gf180mcu_fd_sc_mcu7t5v0__xor3_1
XTAP_TAPCELL_ROW_67_1192 VDD VSS gf180mcu_fd_sc_mcu7t5v0__filltie
X_6640_ _5616_/S _6638_/Z _6643_/A1 VDD VDD VSS VSS gf180mcu_fd_sc_mcu7t5v0__nor2_1
X_3852_ _6679_/I0 _7754_/Q _3852_/B _5120_/A1 VDD VDD VSS VSS gf180mcu_fd_sc_mcu7t5v0__oai21_2
XFILLER_60_862 VDD VDD VSS VSS gf180mcu_fd_sc_mcu7t5v0__fill_1
XTAP_TAPCELL_ROW_80_1381 VDD VSS gf180mcu_fd_sc_mcu7t5v0__filltie
X_6571_ _7706_/Q _7705_/Q _6571_/S _7706_/D VDD VDD VSS VSS gf180mcu_fd_sc_mcu7t5v0__mux2_2
XFILLER_20_737 VDD VDD VSS VSS gf180mcu_fd_sc_mcu7t5v0__fillcap_64
XFILLER_32_597 VDD VDD VSS VSS gf180mcu_fd_sc_mcu7t5v0__fillcap_64
X_5522_ _5522_/A1 _5522_/A2 _5522_/B1 _7730_/Q _5582_/C _5523_/B VDD VDD VSS VSS gf180mcu_fd_sc_mcu7t5v0__oai221_1
X_3783_ _7520_/Q _7543_/Q _3783_/A3 _3783_/B _6717_/A1 VDD VDD VSS VSS gf180mcu_fd_sc_mcu7t5v0__oai31_2
X_5453_ _7305_/Q _5613_/B1 _5559_/B1 _7312_/Q _7326_/Q _5453_/C2 _5459_/A2 VDD VDD
+ VSS VSS gf180mcu_fd_sc_mcu7t5v0__oai222_1
X_4404_ _4880_/A1 _4406_/A2 _4404_/B _6916_/D VDD VDD VSS VSS gf180mcu_fd_sc_mcu7t5v0__oai21_1
X_5384_ _5508_/C _5384_/A2 _5384_/A3 _5385_/A3 VDD VDD VSS VSS gf180mcu_fd_sc_mcu7t5v0__nor3_1
X_4335_ _6882_/Q _4336_/A2 _4336_/B VDD VDD VSS VSS gf180mcu_fd_sc_mcu7t5v0__nand2_1
X_7123_ _7123_/D _7196_/CLK _7123_/Q VDD VDD VSS VSS gf180mcu_fd_sc_mcu7t5v0__dffq_1
Xfanout216 wire220/Z _5056_/A1 VDD VDD VSS VSS gf180mcu_fd_sc_mcu7t5v0__dlyd_1
XFILLER_101_558 VDD VDD VSS VSS gf180mcu_fd_sc_mcu7t5v0__fill_2
X_7054_ _7054_/D _7062_/CLK _7054_/Q VDD VDD VSS VSS gf180mcu_fd_sc_mcu7t5v0__dffq_1
X_4266_ _4336_/A1 _4266_/A2 _4266_/B _6847_/D VDD VDD VSS VSS gf180mcu_fd_sc_mcu7t5v0__oai21_1
Xfanout249 _4146_/A1 _4071_/A1 VDD VDD VSS VSS gf180mcu_fd_sc_mcu7t5v0__dlyd_1
X_4197_ _4234_/I0 _6815_/Q _5232_/S _6815_/D VDD VDD VSS VSS gf180mcu_fd_sc_mcu7t5v0__mux2_2
X_6005_ _6005_/A1 _6005_/A2 _6005_/A3 _6006_/C VDD VDD VSS VSS gf180mcu_fd_sc_mcu7t5v0__nand3_1
X_6907_ _6907_/D _7266_/CLK _6907_/Q VDD VDD VSS VSS gf180mcu_fd_sc_mcu7t5v0__dffq_1
X_6838_ _6838_/D _7254_/CLK _6838_/Q VDD VDD VSS VSS gf180mcu_fd_sc_mcu7t5v0__dffq_1
X_6769_ _6769_/D _7261_/CLK _6769_/Q VDD VDD VSS VSS gf180mcu_fd_sc_mcu7t5v0__dffq_1
XTAP_TAPCELL_ROW_98_1631 VDD VSS gf180mcu_fd_sc_mcu7t5v0__filltie
XFILLER_108_157 VDD VDD VSS VSS gf180mcu_fd_sc_mcu7t5v0__fill_2
XFILLER_105_886 VDD VDD VSS VSS gf180mcu_fd_sc_mcu7t5v0__fill_2
XFILLER_78_737 VDD VDD VSS VSS gf180mcu_fd_sc_mcu7t5v0__fillcap_4
Xclkbuf_leaf_60_clk_i clkload4/I _7252_/CLK VDD VDD VSS VSS gf180mcu_fd_sc_mcu7t5v0__clkbuf_8
XFILLER_34_807 VDD VDD VSS VSS gf180mcu_fd_sc_mcu7t5v0__fillcap_64
XTAP_TAPCELL_ROW_107_1760 VDD VSS gf180mcu_fd_sc_mcu7t5v0__filltie
Xclkbuf_leaf_75_clk_i clkbuf_3_1__f_clk_i/Z _7456_/CLK VDD VDD VSS VSS gf180mcu_fd_sc_mcu7t5v0__clkbuf_8
XTAP_TAPCELL_ROW_44_868 VDD VSS gf180mcu_fd_sc_mcu7t5v0__filltie
XTAP_TAPCELL_ROW_44_879 VDD VSS gf180mcu_fd_sc_mcu7t5v0__filltie
XFILLER_14_597 VDD VDD VSS VSS gf180mcu_fd_sc_mcu7t5v0__fillcap_64
XTAP_TAPCELL_ROW_24_592 VDD VSS gf180mcu_fd_sc_mcu7t5v0__filltie
XPHY_EDGE_ROW_116_Right_116 VDD VSS gf180mcu_fd_sc_mcu7t5v0__endcap
XFILLER_115_628 VDD VDD VSS VSS gf180mcu_fd_sc_mcu7t5v0__fill_2
Xclkbuf_leaf_13_clk_i clkload2/I _7755_/CLK VDD VDD VSS VSS gf180mcu_fd_sc_mcu7t5v0__clkbuf_8
Xclkbuf_leaf_28_clk_i clkload2/I _7003_/CLK VDD VDD VSS VSS gf180mcu_fd_sc_mcu7t5v0__clkbuf_8
X_4120_ _4120_/A1 _4135_/A2 _4994_/A2 VDD VDD VSS VSS gf180mcu_fd_sc_mcu7t5v0__nand2_1
XFILLER_110_355 VDD VDD VSS VSS gf180mcu_fd_sc_mcu7t5v0__fill_1
X_4051_ _6769_/Q _4686_/A2 _4052_/B VDD VDD VSS VSS gf180mcu_fd_sc_mcu7t5v0__nand2_1
Xinput5 cio_rx_i input5/Z VDD VDD VSS VSS gf180mcu_fd_sc_mcu7t5v0__dlyd_1
XTAP_TAPCELL_ROW_69_1221 VDD VSS gf180mcu_fd_sc_mcu7t5v0__filltie
X_7810_ _7810_/D _7810_/RN clkload8/I _7810_/Q VDD VDD VSS VSS gf180mcu_fd_sc_mcu7t5v0__dffrnq_1
XFILLER_80_935 VDD VDD VSS VSS gf180mcu_fd_sc_mcu7t5v0__fillcap_8
XFILLER_24_317 VDD VDD VSS VSS gf180mcu_fd_sc_mcu7t5v0__fill_2
XTAP_TAPCELL_ROW_82_1410 VDD VSS gf180mcu_fd_sc_mcu7t5v0__filltie
XFILLER_80_979 VDD VDD VSS VSS gf180mcu_fd_sc_mcu7t5v0__fill_2
X_7741_ _7741_/D _7742_/RN _7793_/CLK _7741_/Q VDD VDD VSS VSS gf180mcu_fd_sc_mcu7t5v0__dffrnq_1
XFILLER_52_648 VDD VDD VSS VSS gf180mcu_fd_sc_mcu7t5v0__fill_2
XFILLER_52_637 VDD VDD VSS VSS gf180mcu_fd_sc_mcu7t5v0__fill_2
X_4953_ _7191_/Q _4966_/A2 _4954_/B VDD VDD VSS VSS gf180mcu_fd_sc_mcu7t5v0__nand2_1
X_3904_ _7591_/Q _7595_/Q _3904_/Z VDD VDD VSS VSS gf180mcu_fd_sc_mcu7t5v0__xor2_1
X_7672_ _7672_/D _7694_/RN _7802_/CLK _7672_/Q VDD VDD VSS VSS gf180mcu_fd_sc_mcu7t5v0__dffrnq_1
XFILLER_32_383 VDD VDD VSS VSS gf180mcu_fd_sc_mcu7t5v0__fill_2
X_4884_ _5066_/A1 _4896_/A2 _4884_/B _7156_/D VDD VDD VSS VSS gf180mcu_fd_sc_mcu7t5v0__oai21_1
X_6623_ _7725_/Q _6621_/C _6623_/B _7725_/D VDD VDD VSS VSS gf180mcu_fd_sc_mcu7t5v0__aoi21_1
X_3835_ _3829_/Z _3832_/Z _3834_/Z _3835_/Z VDD VDD VSS VSS gf180mcu_fd_sc_mcu7t5v0__xor3_1
XFILLER_20_567 VDD VDD VSS VSS gf180mcu_fd_sc_mcu7t5v0__fillcap_16
X_6554_ _7694_/Q _6552_/Z _6556_/A2 VDD VDD VSS VSS gf180mcu_fd_sc_mcu7t5v0__nor2_1
X_3766_ _7560_/Q _7781_/D _7804_/D VDD VDD VSS VSS gf180mcu_fd_sc_mcu7t5v0__and2_1
X_6485_ _6486_/A1 _7799_/D _6485_/B _6485_/C _6486_/C VDD VDD VSS VSS gf180mcu_fd_sc_mcu7t5v0__oai211_1
X_5505_ _7356_/Q _6632_/A1 _5518_/A2 VDD VDD VSS VSS gf180mcu_fd_sc_mcu7t5v0__nor2_1
XFILLER_106_617 VDD VDD VSS VSS gf180mcu_fd_sc_mcu7t5v0__fill_2
X_3697_ _7881_/I _7882_/I _6315_/A2 VDD VDD VSS VSS gf180mcu_fd_sc_mcu7t5v0__nand2_1
XFILLER_10_37 VDD VDD VSS VSS gf180mcu_fd_sc_mcu7t5v0__fill_2
X_5436_ _7438_/Q _5607_/A2 _5607_/B1 _7284_/Q _5437_/A3 VDD VDD VSS VSS gf180mcu_fd_sc_mcu7t5v0__oai22_1
XTAP_TAPCELL_ROW_93_1561 VDD VSS gf180mcu_fd_sc_mcu7t5v0__filltie
X_5367_ _7544_/Q _5367_/A2 _6624_/A2 VDD VDD VSS VSS gf180mcu_fd_sc_mcu7t5v0__nand2_1
XFILLER_102_845 VDD VDD VSS VSS gf180mcu_fd_sc_mcu7t5v0__fillcap_4
X_4318_ _5130_/A1 _4322_/A2 _4318_/B _6873_/D VDD VDD VSS VSS gf180mcu_fd_sc_mcu7t5v0__oai21_1
X_5298_ _5354_/I0 _7445_/Q _5302_/S _7445_/D VDD VDD VSS VSS gf180mcu_fd_sc_mcu7t5v0__mux2_2
X_7106_ _7106_/D _7217_/CLK _7106_/Q VDD VDD VSS VSS gf180mcu_fd_sc_mcu7t5v0__dffq_1
X_7037_ _7037_/D _7064_/CLK _7037_/Q VDD VDD VSS VSS gf180mcu_fd_sc_mcu7t5v0__dffq_1
X_4249_ _6839_/Q _4252_/A2 _4250_/B VDD VDD VSS VSS gf180mcu_fd_sc_mcu7t5v0__nand2_1
XFILLER_16_807 VDD VDD VSS VSS gf180mcu_fd_sc_mcu7t5v0__fillcap_64
XFILLER_28_667 VDD VDD VSS VSS gf180mcu_fd_sc_mcu7t5v0__fillcap_64
XTAP_TAPCELL_ROW_2_287 VDD VSS gf180mcu_fd_sc_mcu7t5v0__filltie
XFILLER_43_615 VDD VDD VSS VSS gf180mcu_fd_sc_mcu7t5v0__fill_1
XFILLER_15_339 VDD VDD VSS VSS gf180mcu_fd_sc_mcu7t5v0__fill_2
XFILLER_71_979 VDD VDD VSS VSS gf180mcu_fd_sc_mcu7t5v0__fill_1
XTAP_TAPCELL_ROW_41_827 VDD VSS gf180mcu_fd_sc_mcu7t5v0__filltie
XTAP_TAPCELL_ROW_41_838 VDD VSS gf180mcu_fd_sc_mcu7t5v0__filltie
XTAP_TAPCELL_ROW_102_1690 VDD VSS gf180mcu_fd_sc_mcu7t5v0__filltie
XTAP_TAPCELL_ROW_21_551 VDD VSS gf180mcu_fd_sc_mcu7t5v0__filltie
XFILLER_2_243 VDD VDD VSS VSS gf180mcu_fd_sc_mcu7t5v0__fill_2
XFILLER_3_766 VDD VDD VSS VSS gf180mcu_fd_sc_mcu7t5v0__fillcap_4
XTAP_TAPCELL_ROW_53_1000 VDD VSS gf180mcu_fd_sc_mcu7t5v0__filltie
Xload_slew408 _6233_/A2 _6097_/A2 VDD VDD VSS VSS gf180mcu_fd_sc_mcu7t5v0__buf_4
Xuart_642 tl_o[60] VDD VDD VSS VSS gf180mcu_fd_sc_mcu7t5v0__tiel
Xuart_631 racl_error_o[35] VDD VDD VSS VSS gf180mcu_fd_sc_mcu7t5v0__tiel
Xuart_620 racl_error_o[24] VDD VDD VSS VSS gf180mcu_fd_sc_mcu7t5v0__tiel
Xfanout580 _7601_/RN _7711_/RN VDD VDD VSS VSS gf180mcu_fd_sc_mcu7t5v0__dlyd_1
XTAP_TAPCELL_ROW_49_938 VDD VSS gf180mcu_fd_sc_mcu7t5v0__filltie
XTAP_TAPCELL_ROW_49_949 VDD VSS gf180mcu_fd_sc_mcu7t5v0__filltie
XFILLER_47_976 VDD VDD VSS VSS gf180mcu_fd_sc_mcu7t5v0__fillcap_4
XTAP_TAPCELL_ROW_29_662 VDD VSS gf180mcu_fd_sc_mcu7t5v0__filltie
XFILLER_62_979 VDD VDD VSS VSS gf180mcu_fd_sc_mcu7t5v0__fill_2
XTAP_TAPCELL_ROW_64_1151 VDD VSS gf180mcu_fd_sc_mcu7t5v0__filltie
X_3620_ input25/Z input15/Z _3620_/Z VDD VDD VSS VSS gf180mcu_fd_sc_mcu7t5v0__xor2_1
X_3551_ input48/Z _3549_/Z _3550_/Z _3551_/Z VDD VDD VSS VSS gf180mcu_fd_sc_mcu7t5v0__xor3_1
X_6270_ _3476_/I _5813_/Z _6271_/C VDD VDD VSS VSS gf180mcu_fd_sc_mcu7t5v0__nor2_1
XFILLER_6_593 VDD VDD VSS VSS gf180mcu_fd_sc_mcu7t5v0__fill_2
X_3482_ _6609_/A1 _7712_/Q _5746_/A2 _3483_/A2 VDD VDD VSS VSS gf180mcu_fd_sc_mcu7t5v0__nand3_1
X_5221_ _5235_/I0 _7368_/Q _5225_/S _7368_/D VDD VDD VSS VSS gf180mcu_fd_sc_mcu7t5v0__mux2_2
X_5152_ wire525/Z _7299_/Q _5155_/S _7299_/D VDD VDD VSS VSS gf180mcu_fd_sc_mcu7t5v0__mux2_2
X_4103_ _4112_/A1 _4910_/A2 _4103_/B _6785_/D VDD VDD VSS VSS gf180mcu_fd_sc_mcu7t5v0__oai21_1
XFILLER_69_567 VDD VDD VSS VSS gf180mcu_fd_sc_mcu7t5v0__fill_1
X_5083_ _7256_/Q _5092_/A2 _5084_/B VDD VDD VSS VSS gf180mcu_fd_sc_mcu7t5v0__nand2_1
XPHY_EDGE_ROW_16_Left_135 VDD VSS gf180mcu_fd_sc_mcu7t5v0__endcap
X_4034_ _4143_/A1 _4602_/A2 _4034_/B _6763_/D VDD VDD VSS VSS gf180mcu_fd_sc_mcu7t5v0__oai21_1
XFILLER_71_209 VDD VDD VSS VSS gf180mcu_fd_sc_mcu7t5v0__fill_1
XFILLER_92_592 VDD VDD VSS VSS gf180mcu_fd_sc_mcu7t5v0__fill_2
XFILLER_25_626 VDD VDD VSS VSS gf180mcu_fd_sc_mcu7t5v0__fillcap_4
XFILLER_37_497 VDD VDD VSS VSS gf180mcu_fd_sc_mcu7t5v0__fillcap_4
X_7724_ _7724_/D wire593/Z _7724_/CLK _7724_/Q VDD VDD VSS VSS gf180mcu_fd_sc_mcu7t5v0__dffrnq_1
XFILLER_52_445 VDD VDD VSS VSS gf180mcu_fd_sc_mcu7t5v0__fill_1
X_5985_ _5985_/A1 _5985_/A2 _5995_/A1 VDD VDD VSS VSS gf180mcu_fd_sc_mcu7t5v0__nor2_1
X_4936_ _4950_/A1 _4938_/A2 _4936_/B _7182_/D VDD VDD VSS VSS gf180mcu_fd_sc_mcu7t5v0__oai21_1
XANTENNA_21 _7666_/D VDD VDD VSS VSS gf180mcu_fd_sc_mcu7t5v0__antenna
X_7655_ _7655_/D _7660_/RN _7671_/CLK _7655_/Q VDD VDD VSS VSS gf180mcu_fd_sc_mcu7t5v0__dffrnq_1
X_4867_ _7148_/Q _4868_/A2 _4868_/B VDD VDD VSS VSS gf180mcu_fd_sc_mcu7t5v0__nand2_1
XANTENNA_10 _6129_/Z VDD VDD VSS VSS gf180mcu_fd_sc_mcu7t5v0__antenna
XPHY_EDGE_ROW_25_Left_144 VDD VSS gf180mcu_fd_sc_mcu7t5v0__endcap
X_7586_ _7586_/D _7589_/RN _7613_/CLK _7586_/Q VDD VDD VSS VSS gf180mcu_fd_sc_mcu7t5v0__dffrnq_1
X_3818_ _3818_/I _3818_/ZN VDD VDD VSS VSS gf180mcu_fd_sc_mcu7t5v0__clkinv_1
X_6606_ _7718_/Q _6606_/A2 _6606_/Z VDD VDD VSS VSS gf180mcu_fd_sc_mcu7t5v0__xor2_1
X_6537_ _7688_/Q _6534_/Z _6537_/Z VDD VDD VSS VSS gf180mcu_fd_sc_mcu7t5v0__and2_1
X_4798_ _5008_/A1 _4798_/A2 _4798_/B _7113_/D VDD VDD VSS VSS gf180mcu_fd_sc_mcu7t5v0__oai21_1
XFILLER_118_274 VDD VDD VSS VSS gf180mcu_fd_sc_mcu7t5v0__fill_1
XFILLER_4_519 VDD VDD VSS VSS gf180mcu_fd_sc_mcu7t5v0__fillcap_4
X_3749_ _3484_/I _3749_/A2 _3750_/C VDD VDD VSS VSS gf180mcu_fd_sc_mcu7t5v0__nand2_1
X_6468_ _7667_/Q _7533_/Q _6459_/Z _6469_/B VDD VDD VSS VSS gf180mcu_fd_sc_mcu7t5v0__nand3_1
Xoutput161 _7599_/Q tl_o[43] VDD VDD VSS VSS gf180mcu_fd_sc_mcu7t5v0__dlyd_1
X_6399_ _7659_/Q _7525_/Q _6399_/Z VDD VDD VSS VSS gf180mcu_fd_sc_mcu7t5v0__xor2_1
Xoutput150 _7589_/Q tl_o[33] VDD VDD VSS VSS gf180mcu_fd_sc_mcu7t5v0__dlyd_1
X_5419_ _7297_/Q _5535_/C2 _5562_/A2 _7290_/Q _7493_/Q _5515_/A2 _5420_/A3 VDD VDD
+ VSS VSS gf180mcu_fd_sc_mcu7t5v0__oai222_1
Xoutput172 _7609_/Q tl_o[54] VDD VDD VSS VSS gf180mcu_fd_sc_mcu7t5v0__dlyd_1
Xoutput183 _3818_/I tl_o[9] VDD VDD VSS VSS gf180mcu_fd_sc_mcu7t5v0__dlyd_1
XTAP_TAPCELL_ROW_7_357 VDD VSS gf180mcu_fd_sc_mcu7t5v0__filltie
XPHY_EDGE_ROW_34_Left_153 VDD VSS gf180mcu_fd_sc_mcu7t5v0__endcap
XFILLER_75_537 VDD VDD VSS VSS gf180mcu_fd_sc_mcu7t5v0__fill_2
XTAP_TAPCELL_ROW_46_908 VDD VSS gf180mcu_fd_sc_mcu7t5v0__filltie
XFILLER_29_976 VDD VDD VSS VSS gf180mcu_fd_sc_mcu7t5v0__fillcap_4
XFILLER_71_710 VDD VDD VSS VSS gf180mcu_fd_sc_mcu7t5v0__fill_2
XTAP_TAPCELL_ROW_26_621 VDD VSS gf180mcu_fd_sc_mcu7t5v0__filltie
XFILLER_44_979 VDD VDD VSS VSS gf180mcu_fd_sc_mcu7t5v0__fill_2
XFILLER_70_242 VDD VDD VSS VSS gf180mcu_fd_sc_mcu7t5v0__fill_2
XFILLER_71_776 VDD VDD VSS VSS gf180mcu_fd_sc_mcu7t5v0__fill_2
XPHY_EDGE_ROW_43_Left_162 VDD VSS gf180mcu_fd_sc_mcu7t5v0__endcap
XTAP_TAPCELL_ROW_115_1870 VDD VSS gf180mcu_fd_sc_mcu7t5v0__filltie
XPHY_EDGE_ROW_52_Left_171 VDD VSS gf180mcu_fd_sc_mcu7t5v0__endcap
XFILLER_106_981 VDD VDD VSS VSS gf180mcu_fd_sc_mcu7t5v0__fill_1
Xload_slew227 _5076_/A1 _4824_/A1 VDD VDD VSS VSS gf180mcu_fd_sc_mcu7t5v0__clkbuf_4
Xload_slew205 _5642_/S _5661_/S VDD VDD VSS VSS gf180mcu_fd_sc_mcu7t5v0__buf_4
XFILLER_79_854 VDD VDD VSS VSS gf180mcu_fd_sc_mcu7t5v0__fill_2
Xload_slew238 _4402_/A1 _5060_/A1 VDD VDD VSS VSS gf180mcu_fd_sc_mcu7t5v0__buf_2
XFILLER_47_762 VDD VDD VSS VSS gf180mcu_fd_sc_mcu7t5v0__fill_2
XPHY_EDGE_ROW_61_Left_180 VDD VSS gf180mcu_fd_sc_mcu7t5v0__endcap
X_5770_ _7254_/Q wire355/I _6207_/B1 _7219_/Q _6195_/C _5771_/A2 VDD VDD VSS VSS gf180mcu_fd_sc_mcu7t5v0__oai221_1
X_4721_ _7075_/Q _4728_/A2 _4722_/B VDD VDD VSS VSS gf180mcu_fd_sc_mcu7t5v0__nand2_1
X_4652_ _4708_/A1 _4658_/A2 _4652_/B _7040_/D VDD VDD VSS VSS gf180mcu_fd_sc_mcu7t5v0__oai21_1
X_7440_ _7440_/D clkload7/I _7440_/Q VDD VDD VSS VSS gf180mcu_fd_sc_mcu7t5v0__dffq_1
Xinput30 tl_i[2] input30/Z VDD VDD VSS VSS gf180mcu_fd_sc_mcu7t5v0__dlyd_1
X_3603_ _3599_/Z _3600_/Z _3601_/Z _3603_/Z VDD VDD VSS VSS gf180mcu_fd_sc_mcu7t5v0__xor3_1
X_4583_ _7006_/Q _4588_/A2 _4584_/B VDD VDD VSS VSS gf180mcu_fd_sc_mcu7t5v0__nand2_1
XTAP_TAPCELL_ROW_77_1331 VDD VSS gf180mcu_fd_sc_mcu7t5v0__filltie
X_7371_ _7371_/D _7734_/CLK _7371_/Q VDD VDD VSS VSS gf180mcu_fd_sc_mcu7t5v0__dffq_1
Xinput41 tl_i[3] input41/Z VDD VDD VSS VSS gf180mcu_fd_sc_mcu7t5v0__dlyd_1
Xinput63 tl_i[5] input63/Z VDD VDD VSS VSS gf180mcu_fd_sc_mcu7t5v0__dlyd_1
Xinput52 tl_i[4] input52/Z VDD VDD VSS VSS gf180mcu_fd_sc_mcu7t5v0__dlyd_1
XTAP_TAPCELL_ROW_77_1342 VDD VSS gf180mcu_fd_sc_mcu7t5v0__filltie
X_3534_ input68/Z input67/Z _3685_/A2 VDD VDD VSS VSS gf180mcu_fd_sc_mcu7t5v0__nand2_1
Xinput85 tl_i[7] input85/Z VDD VDD VSS VSS gf180mcu_fd_sc_mcu7t5v0__dlyd_1
Xinput96 tl_i[8] input96/Z VDD VDD VSS VSS gf180mcu_fd_sc_mcu7t5v0__dlyd_1
Xinput74 tl_i[6] input74/Z VDD VDD VSS VSS gf180mcu_fd_sc_mcu7t5v0__dlyd_1
X_6322_ _6322_/A1 _6326_/A2 _6322_/B _7618_/D VDD VDD VSS VSS gf180mcu_fd_sc_mcu7t5v0__oai21_1
X_3465_ _7578_/Q _6190_/A1 VDD VDD VSS VSS gf180mcu_fd_sc_mcu7t5v0__clkinv_1
X_6253_ _6253_/I _6254_/C VDD VDD VSS VSS gf180mcu_fd_sc_mcu7t5v0__clkinv_1
XFILLER_103_428 VDD VDD VSS VSS gf180mcu_fd_sc_mcu7t5v0__fill_1
XTAP_TAPCELL_ROW_90_1520 VDD VSS gf180mcu_fd_sc_mcu7t5v0__filltie
X_5204_ _5239_/I0 _7351_/Q _5204_/S _7351_/D VDD VDD VSS VSS gf180mcu_fd_sc_mcu7t5v0__mux2_2
XFILLER_97_640 VDD VDD VSS VSS gf180mcu_fd_sc_mcu7t5v0__fill_1
X_6184_ _6124_/S _6184_/A2 _6184_/B _6184_/C _6185_/B VDD VDD VSS VSS gf180mcu_fd_sc_mcu7t5v0__oai211_1
X_3396_ _7617_/Q _6320_/A1 VDD VDD VSS VSS gf180mcu_fd_sc_mcu7t5v0__clkinv_1
XFILLER_96_172 VDD VDD VSS VSS gf180mcu_fd_sc_mcu7t5v0__fill_2
X_5135_ _6353_/I0 _7282_/Q _5141_/S _7282_/D VDD VDD VSS VSS gf180mcu_fd_sc_mcu7t5v0__mux2_2
XTAP_TAPCELL_ROW_4_316 VDD VSS gf180mcu_fd_sc_mcu7t5v0__filltie
X_5066_ _5066_/A1 _5075_/A2 _5066_/B _7247_/D VDD VDD VSS VSS gf180mcu_fd_sc_mcu7t5v0__aoi21_1
X_4017_ _4029_/A1 _4532_/A2 _4017_/B _6758_/D VDD VDD VSS VSS gf180mcu_fd_sc_mcu7t5v0__oai21_1
XFILLER_44_209 VDD VDD VSS VSS gf180mcu_fd_sc_mcu7t5v0__fill_1
XTAP_TAPCELL_ROW_88_1493 VDD VSS gf180mcu_fd_sc_mcu7t5v0__filltie
XFILLER_53_710 VDD VDD VSS VSS gf180mcu_fd_sc_mcu7t5v0__fillcap_4
XFILLER_26_979 VDD VDD VSS VSS gf180mcu_fd_sc_mcu7t5v0__fill_2
XFILLER_52_220 VDD VDD VSS VSS gf180mcu_fd_sc_mcu7t5v0__fill_1
X_5968_ _6949_/Q _6092_/A2 _6197_/B _5970_/A1 VDD VDD VSS VSS gf180mcu_fd_sc_mcu7t5v0__oai21_1
X_7707_ _7707_/D _7708_/RN _7711_/CLK _7707_/Q VDD VDD VSS VSS gf180mcu_fd_sc_mcu7t5v0__dffrnq_1
XTAP_TAPCELL_ROW_51_966 VDD VSS gf180mcu_fd_sc_mcu7t5v0__filltie
X_4919_ _7174_/Q _4924_/A2 _4920_/B VDD VDD VSS VSS gf180mcu_fd_sc_mcu7t5v0__nand2_1
XTAP_TAPCELL_ROW_51_977 VDD VSS gf180mcu_fd_sc_mcu7t5v0__filltie
X_5899_ _5899_/A1 _5899_/A2 _5902_/C VDD VDD VSS VSS gf180mcu_fd_sc_mcu7t5v0__or2_1
X_7638_ _7638_/D _7711_/RN _7710_/CLK _7638_/Q VDD VDD VSS VSS gf180mcu_fd_sc_mcu7t5v0__dffrnq_1
XTAP_TAPCELL_ROW_31_690 VDD VSS gf180mcu_fd_sc_mcu7t5v0__filltie
X_7569_ _7569_/D _7785_/RN _7794_/CLK _7569_/Q VDD VDD VSS VSS gf180mcu_fd_sc_mcu7t5v0__dffrnq_1
XFILLER_107_734 VDD VDD VSS VSS gf180mcu_fd_sc_mcu7t5v0__fillcap_8
XFILLER_31_459 VDD VDD VSS VSS gf180mcu_fd_sc_mcu7t5v0__fill_2
XTAP_TAPCELL_ROW_61_1110 VDD VSS gf180mcu_fd_sc_mcu7t5v0__filltie
XTAP_TAPCELL_ROW_59_1083 VDD VSS gf180mcu_fd_sc_mcu7t5v0__filltie
XFILLER_98_448 VDD VDD VSS VSS gf180mcu_fd_sc_mcu7t5v0__fill_2
XTAP_TAPCELL_ROW_72_1261 VDD VSS gf180mcu_fd_sc_mcu7t5v0__filltie
XFILLER_39_515 VDD VDD VSS VSS gf180mcu_fd_sc_mcu7t5v0__fillcap_4
XFILLER_66_312 VDD VDD VSS VSS gf180mcu_fd_sc_mcu7t5v0__fill_2
XFILLER_67_813 VDD VDD VSS VSS gf180mcu_fd_sc_mcu7t5v0__fill_1
XTAP_TAPCELL_ROW_72_1272 VDD VSS gf180mcu_fd_sc_mcu7t5v0__filltie
X_6940_ _6940_/D _6944_/CLK _6940_/Q VDD VDD VSS VSS gf180mcu_fd_sc_mcu7t5v0__dffq_1
XFILLER_26_209 VDD VDD VSS VSS gf180mcu_fd_sc_mcu7t5v0__fill_2
X_6871_ _6871_/D _6882_/CLK _6871_/Q VDD VDD VSS VSS gf180mcu_fd_sc_mcu7t5v0__dffq_1
X_5822_ _6989_/Q _6141_/A2 wire322/I _6835_/Q _5824_/A1 VDD VDD VSS VSS gf180mcu_fd_sc_mcu7t5v0__oai22_1
XTAP_TAPCELL_ROW_17_495 VDD VSS gf180mcu_fd_sc_mcu7t5v0__filltie
X_5753_ _5753_/A1 _5754_/A2 _5753_/ZN VDD VDD VSS VSS gf180mcu_fd_sc_mcu7t5v0__nand2_1
X_4704_ _5068_/A1 _4714_/A2 _4704_/B _7066_/D VDD VDD VSS VSS gf180mcu_fd_sc_mcu7t5v0__oai21_1
X_5684_ _7558_/Q input31/Z _5686_/S _7558_/D VDD VDD VSS VSS gf180mcu_fd_sc_mcu7t5v0__mux2_2
X_4635_ _7032_/Q _4644_/A2 _4636_/B VDD VDD VSS VSS gf180mcu_fd_sc_mcu7t5v0__nand2_1
X_7423_ _7423_/D _7451_/CLK _7423_/Q VDD VDD VSS VSS gf180mcu_fd_sc_mcu7t5v0__dffq_1
X_4566_ _5014_/A1 _4574_/A2 _4566_/B _6997_/D VDD VDD VSS VSS gf180mcu_fd_sc_mcu7t5v0__oai21_1
X_7354_ _7354_/D _7378_/CLK _7354_/Q VDD VDD VSS VSS gf180mcu_fd_sc_mcu7t5v0__dffq_1
X_6305_ _7606_/Q _6305_/I1 _6310_/S _7606_/D VDD VDD VSS VSS gf180mcu_fd_sc_mcu7t5v0__mux2_2
X_3517_ _7822_/D _3901_/B _3518_/B VDD VDD VSS VSS gf180mcu_fd_sc_mcu7t5v0__nor2_1
XFILLER_103_203 VDD VDD VSS VSS gf180mcu_fd_sc_mcu7t5v0__fill_1
X_4497_ _6963_/Q _4504_/A2 _4498_/B VDD VDD VSS VSS gf180mcu_fd_sc_mcu7t5v0__nand2_1
X_7285_ _7285_/D _7822_/CLK _7285_/Q VDD VDD VSS VSS gf180mcu_fd_sc_mcu7t5v0__dffq_1
X_3448_ _7575_/Q _6007_/A1 VDD VDD VSS VSS gf180mcu_fd_sc_mcu7t5v0__clkinv_1
X_6236_ _6794_/Q _6236_/A2 _6236_/B1 _6795_/Q _6236_/C _6237_/A2 VDD VDD VSS VSS gf180mcu_fd_sc_mcu7t5v0__oai221_1
X_6167_ _6938_/Q wire355/Z _6167_/B1 _6924_/Q _6169_/A1 VDD VDD VSS VSS gf180mcu_fd_sc_mcu7t5v0__oai22_1
XFILLER_112_770 VDD VDD VSS VSS gf180mcu_fd_sc_mcu7t5v0__fill_2
X_3379_ _7879_/I _3668_/A1 VDD VDD VSS VSS gf180mcu_fd_sc_mcu7t5v0__clkinv_1
XFILLER_100_943 VDD VDD VSS VSS gf180mcu_fd_sc_mcu7t5v0__fill_2
X_5118_ _5118_/A1 _5120_/A2 _5118_/B _7273_/D VDD VDD VSS VSS gf180mcu_fd_sc_mcu7t5v0__oai21_1
Xload_slew591 fanout589/Z _7802_/RN VDD VDD VSS VSS gf180mcu_fd_sc_mcu7t5v0__clkbuf_4
X_6098_ _7196_/Q _6098_/A2 _6232_/A2 _7203_/Q _6191_/B _6099_/A2 VDD VDD VSS VSS gf180mcu_fd_sc_mcu7t5v0__oai221_1
X_5049_ _7239_/Q _5050_/A2 _5050_/B VDD VDD VSS VSS gf180mcu_fd_sc_mcu7t5v0__nand2_1
XTAP_TAPCELL_ROW_36_760 VDD VSS gf180mcu_fd_sc_mcu7t5v0__filltie
XFILLER_41_702 VDD VDD VSS VSS gf180mcu_fd_sc_mcu7t5v0__fillcap_64
XFILLER_53_562 VDD VDD VSS VSS gf180mcu_fd_sc_mcu7t5v0__fill_2
XFILLER_107_575 VDD VDD VSS VSS gf180mcu_fd_sc_mcu7t5v0__fill_2
XFILLER_1_842 VDD VDD VSS VSS gf180mcu_fd_sc_mcu7t5v0__fillcap_64
XFILLER_72_882 VDD VDD VSS VSS gf180mcu_fd_sc_mcu7t5v0__fillcap_4
XTAP_TAPCELL_ROW_14_454 VDD VSS gf180mcu_fd_sc_mcu7t5v0__filltie
XFILLER_118_818 VDD VDD VSS VSS gf180mcu_fd_sc_mcu7t5v0__fillcap_32
X_4420_ wire292/Z _4420_/A2 _4420_/B _6924_/D VDD VDD VSS VSS gf180mcu_fd_sc_mcu7t5v0__oai21_1
XFILLER_8_474 VDD VDD VSS VSS gf180mcu_fd_sc_mcu7t5v0__fill_2
XTAP_TAPCELL_ROW_74_1301 VDD VSS gf180mcu_fd_sc_mcu7t5v0__filltie
X_4351_ _6890_/Q _4364_/A2 _4352_/B VDD VDD VSS VSS gf180mcu_fd_sc_mcu7t5v0__nand2_1
X_7070_ _7070_/D _7070_/CLK _7070_/Q VDD VDD VSS VSS gf180mcu_fd_sc_mcu7t5v0__dffq_1
X_4282_ _4324_/A1 _4294_/A2 _4282_/B _6855_/D VDD VDD VSS VSS gf180mcu_fd_sc_mcu7t5v0__oai21_1
Xfanout409 wire416/Z fanout409/Z VDD VDD VSS VSS gf180mcu_fd_sc_mcu7t5v0__dlyd_1
X_6021_ _7041_/Q _6151_/A2 wire313/Z _7048_/Q _7055_/Q _6154_/A2 _6022_/I VDD VDD
+ VSS VSS gf180mcu_fd_sc_mcu7t5v0__oai222_1
XFILLER_67_632 VDD VDD VSS VSS gf180mcu_fd_sc_mcu7t5v0__fill_2
XFILLER_94_440 VDD VDD VSS VSS gf180mcu_fd_sc_mcu7t5v0__fill_1
X_6923_ _6923_/D _6944_/CLK _6923_/Q VDD VDD VSS VSS gf180mcu_fd_sc_mcu7t5v0__dffq_1
XTAP_TAPCELL_ROW_85_1452 VDD VSS gf180mcu_fd_sc_mcu7t5v0__filltie
XFILLER_23_702 VDD VDD VSS VSS gf180mcu_fd_sc_mcu7t5v0__fillcap_64
XFILLER_35_562 VDD VDD VSS VSS gf180mcu_fd_sc_mcu7t5v0__fillcap_64
X_6854_ _6854_/D _7724_/CLK _6854_/Q VDD VDD VSS VSS gf180mcu_fd_sc_mcu7t5v0__dffq_1
X_5805_ _5805_/A1 _5805_/A2 _5805_/B1 _5805_/B2 _5806_/A2 VDD VDD VSS VSS gf180mcu_fd_sc_mcu7t5v0__oai22_1
X_3997_ _6752_/Q _4448_/A2 _3998_/B VDD VDD VSS VSS gf180mcu_fd_sc_mcu7t5v0__nand2_1
X_6785_ _6785_/D _7453_/CLK _6785_/Q VDD VDD VSS VSS gf180mcu_fd_sc_mcu7t5v0__dffq_1
X_5736_ _5736_/A1 _7794_/D _5625_/C _5737_/B VDD VDD VSS VSS gf180mcu_fd_sc_mcu7t5v0__and3_1
XFILLER_109_829 VDD VDD VSS VSS gf180mcu_fd_sc_mcu7t5v0__fill_2
X_5667_ _3747_/C _7783_/D _5667_/B _7546_/D VDD VDD VSS VSS gf180mcu_fd_sc_mcu7t5v0__oai21_1
X_4618_ _5094_/A1 _4630_/A2 _4618_/B _7023_/D VDD VDD VSS VSS gf180mcu_fd_sc_mcu7t5v0__oai21_1
X_7406_ _7406_/D _7456_/CLK _7406_/Q VDD VDD VSS VSS gf180mcu_fd_sc_mcu7t5v0__dffq_1
X_5598_ _5590_/B _5598_/A2 _5598_/A3 _5602_/B1 VDD VDD VSS VSS gf180mcu_fd_sc_mcu7t5v0__nor3_1
X_4549_ _6989_/Q _4560_/A2 _4550_/B VDD VDD VSS VSS gf180mcu_fd_sc_mcu7t5v0__nand2_1
X_7337_ _7337_/D _7804_/CLK _7337_/Q VDD VDD VSS VSS gf180mcu_fd_sc_mcu7t5v0__dffq_1
X_7268_ _7268_/D _7692_/CLK _7268_/Q VDD VDD VSS VSS gf180mcu_fd_sc_mcu7t5v0__dffq_1
XFILLER_78_908 VDD VDD VSS VSS gf180mcu_fd_sc_mcu7t5v0__fill_2
XPHY_EDGE_ROW_8_Left_127 VDD VSS gf180mcu_fd_sc_mcu7t5v0__endcap
X_6219_ _6757_/Q _6229_/A2 _6222_/B1 _6756_/Q _6224_/A1 VDD VDD VSS VSS gf180mcu_fd_sc_mcu7t5v0__oai22_1
XFILLER_77_418 VDD VDD VSS VSS gf180mcu_fd_sc_mcu7t5v0__fill_2
X_7199_ _7199_/D _7216_/CLK _7199_/Q VDD VDD VSS VSS gf180mcu_fd_sc_mcu7t5v0__dffq_1
XFILLER_100_762 VDD VDD VSS VSS gf180mcu_fd_sc_mcu7t5v0__fill_2
XFILLER_73_624 VDD VDD VSS VSS gf180mcu_fd_sc_mcu7t5v0__fill_1
XFILLER_54_871 VDD VDD VSS VSS gf180mcu_fd_sc_mcu7t5v0__fillcap_4
XFILLER_13_212 VDD VDD VSS VSS gf180mcu_fd_sc_mcu7t5v0__fill_1
XTAP_TAPCELL_ROW_11_413 VDD VSS gf180mcu_fd_sc_mcu7t5v0__filltie
XFILLER_10_941 VDD VDD VSS VSS gf180mcu_fd_sc_mcu7t5v0__fillcap_4
XFILLER_5_422 VDD VDD VSS VSS gf180mcu_fd_sc_mcu7t5v0__fill_1
Xclkload19 _7734_/CLK clkload19/ZN VDD VDD VSS VSS gf180mcu_fd_sc_mcu7t5v0__clkinv_3
XTAP_TAPCELL_ROW_56_1042 VDD VSS gf180mcu_fd_sc_mcu7t5v0__filltie
XFILLER_77_941 VDD VDD VSS VSS gf180mcu_fd_sc_mcu7t5v0__fillcap_32
XFILLER_0_182 VDD VDD VSS VSS gf180mcu_fd_sc_mcu7t5v0__fill_1
XFILLER_92_944 VDD VDD VSS VSS gf180mcu_fd_sc_mcu7t5v0__fill_1
XTAP_TAPCELL_ROW_19_524 VDD VSS gf180mcu_fd_sc_mcu7t5v0__filltie
Xclkbuf_3_5__f_clk_i clkbuf_0_clk_i/Z clkload4/I VDD VDD VSS VSS gf180mcu_fd_sc_mcu7t5v0__clkbuf_16
X_3920_ _6292_/A1 _6298_/A1 _3839_/Z _3920_/Z VDD VDD VSS VSS gf180mcu_fd_sc_mcu7t5v0__xor3_1
XFILLER_17_562 VDD VDD VSS VSS gf180mcu_fd_sc_mcu7t5v0__fillcap_64
XTAP_TAPCELL_ROW_67_1193 VDD VSS gf180mcu_fd_sc_mcu7t5v0__filltie
X_3851_ _6679_/I0 _3866_/A2 _3852_/B VDD VDD VSS VSS gf180mcu_fd_sc_mcu7t5v0__nand2_1
X_3782_ _6737_/A1 _7543_/Q _3783_/B VDD VDD VSS VSS gf180mcu_fd_sc_mcu7t5v0__nand2_1
X_6570_ _7705_/Q _7704_/Q _6571_/S _7705_/D VDD VDD VSS VSS gf180mcu_fd_sc_mcu7t5v0__mux2_2
XTAP_TAPCELL_ROW_80_1382 VDD VSS gf180mcu_fd_sc_mcu7t5v0__filltie
X_5521_ _5521_/A1 _5521_/A2 _5521_/B _5522_/B1 VDD VDD VSS VSS gf180mcu_fd_sc_mcu7t5v0__oai21_1
XFILLER_9_772 VDD VDD VSS VSS gf180mcu_fd_sc_mcu7t5v0__fillcap_64
X_5452_ _7319_/Q _5610_/B1 _5609_/B _5459_/A1 VDD VDD VSS VSS gf180mcu_fd_sc_mcu7t5v0__oai21_1
X_4403_ _6916_/Q _4406_/A2 _4404_/B VDD VDD VSS VSS gf180mcu_fd_sc_mcu7t5v0__nand2_1
X_5383_ _7436_/Q _5511_/B1 _5607_/B1 _7282_/Q _5384_/A3 VDD VDD VSS VSS gf180mcu_fd_sc_mcu7t5v0__oai22_1
X_4334_ _4950_/A1 _4336_/A2 _4334_/B _6881_/D VDD VDD VSS VSS gf180mcu_fd_sc_mcu7t5v0__oai21_1
X_7122_ _7122_/D _7196_/CLK _7122_/Q VDD VDD VSS VSS gf180mcu_fd_sc_mcu7t5v0__dffq_1
X_7053_ _7053_/D _7064_/CLK _7053_/Q VDD VDD VSS VSS gf180mcu_fd_sc_mcu7t5v0__dffq_1
XFILLER_101_515 VDD VDD VSS VSS gf180mcu_fd_sc_mcu7t5v0__fill_1
XFILLER_99_587 VDD VDD VSS VSS gf180mcu_fd_sc_mcu7t5v0__fill_2
Xfanout206 _5636_/ZN _5643_/S VDD VDD VSS VSS gf180mcu_fd_sc_mcu7t5v0__dlyd_1
Xfanout228 wire231/Z _5006_/A1 VDD VDD VSS VSS gf180mcu_fd_sc_mcu7t5v0__dlyd_1
X_4265_ _6847_/Q _4266_/A2 _4266_/B VDD VDD VSS VSS gf180mcu_fd_sc_mcu7t5v0__nand2_1
Xfanout239 _3865_/ZN wire241/I VDD VDD VSS VSS gf180mcu_fd_sc_mcu7t5v0__dlyd_1
X_6004_ _7546_/Q _6247_/A2 _6254_/B1 _7699_/Q _5691_/I _7564_/Q _6005_/A3 VDD VDD
+ VSS VSS gf180mcu_fd_sc_mcu7t5v0__aoi222_1
XFILLER_83_900 VDD VDD VSS VSS gf180mcu_fd_sc_mcu7t5v0__fillcap_4
X_4196_ _6651_/A2 _4200_/A2 _5232_/S VDD VDD VSS VSS gf180mcu_fd_sc_mcu7t5v0__nand2_1
XFILLER_39_142 VDD VDD VSS VSS gf180mcu_fd_sc_mcu7t5v0__fill_2
XFILLER_36_871 VDD VDD VSS VSS gf180mcu_fd_sc_mcu7t5v0__fillcap_4
X_7886_ _7886_/I _7886_/Z VDD VDD VSS VSS gf180mcu_fd_sc_mcu7t5v0__buf_1
X_6906_ _6906_/D _7148_/CLK _6906_/Q VDD VDD VSS VSS gf180mcu_fd_sc_mcu7t5v0__dffq_1
X_6837_ _6837_/D _7070_/CLK _6837_/Q VDD VDD VSS VSS gf180mcu_fd_sc_mcu7t5v0__dffq_1
XFILLER_24_25 VDD VDD VSS VSS gf180mcu_fd_sc_mcu7t5v0__fill_1
X_6768_ _6768_/D _7055_/CLK _6768_/Q VDD VDD VSS VSS gf180mcu_fd_sc_mcu7t5v0__dffq_1
XTAP_TAPCELL_ROW_98_1632 VDD VSS gf180mcu_fd_sc_mcu7t5v0__filltie
XFILLER_40_24 VDD VDD VSS VSS gf180mcu_fd_sc_mcu7t5v0__fill_1
X_6699_ _6699_/I _7747_/D VDD VDD VSS VSS gf180mcu_fd_sc_mcu7t5v0__clkinv_1
X_5719_ _6320_/A1 _7674_/Q _5719_/B _5720_/A3 VDD VDD VSS VSS gf180mcu_fd_sc_mcu7t5v0__oai21_1
XFILLER_2_425 VDD VDD VSS VSS gf180mcu_fd_sc_mcu7t5v0__fill_1
Xclkbuf_leaf_9_clk_i clkload0/I _7782_/CLK VDD VDD VSS VSS gf180mcu_fd_sc_mcu7t5v0__clkbuf_8
XFILLER_74_933 VDD VDD VSS VSS gf180mcu_fd_sc_mcu7t5v0__fillcap_8
XFILLER_100_592 VDD VDD VSS VSS gf180mcu_fd_sc_mcu7t5v0__fill_2
XTAP_TAPCELL_ROW_107_1761 VDD VSS gf180mcu_fd_sc_mcu7t5v0__filltie
XTAP_TAPCELL_ROW_107_1750 VDD VSS gf180mcu_fd_sc_mcu7t5v0__filltie
XTAP_TAPCELL_ROW_44_869 VDD VSS gf180mcu_fd_sc_mcu7t5v0__filltie
XTAP_TAPCELL_ROW_24_593 VDD VSS gf180mcu_fd_sc_mcu7t5v0__filltie
XFILLER_6_731 VDD VDD VSS VSS gf180mcu_fd_sc_mcu7t5v0__fillcap_4
XFILLER_2_981 VDD VDD VSS VSS gf180mcu_fd_sc_mcu7t5v0__fill_1
X_4050_ _4141_/A2 _4053_/A2 _4686_/A2 VDD VDD VSS VSS gf180mcu_fd_sc_mcu7t5v0__nand2_1
Xinput6 rst_ni input6/Z VDD VDD VSS VSS gf180mcu_fd_sc_mcu7t5v0__dlyd_1
XTAP_TAPCELL_ROW_69_1222 VDD VSS gf180mcu_fd_sc_mcu7t5v0__filltie
XFILLER_80_903 VDD VDD VSS VSS gf180mcu_fd_sc_mcu7t5v0__fill_1
XFILLER_18_871 VDD VDD VSS VSS gf180mcu_fd_sc_mcu7t5v0__fillcap_4
XTAP_TAPCELL_ROW_82_1411 VDD VSS gf180mcu_fd_sc_mcu7t5v0__filltie
XTAP_TAPCELL_ROW_82_1400 VDD VSS gf180mcu_fd_sc_mcu7t5v0__filltie
XFILLER_80_947 VDD VDD VSS VSS gf180mcu_fd_sc_mcu7t5v0__fillcap_32
X_4952_ _4952_/A1 _4952_/A2 _4952_/B _7190_/D VDD VDD VSS VSS gf180mcu_fd_sc_mcu7t5v0__oai21_1
X_7740_ _7740_/D _7740_/RN _7793_/CLK _7740_/Q VDD VDD VSS VSS gf180mcu_fd_sc_mcu7t5v0__dffrnq_1
X_7671_ _7671_/D _7671_/RN _7671_/CLK _7671_/Q VDD VDD VSS VSS gf180mcu_fd_sc_mcu7t5v0__dffrnq_1
X_3903_ _3903_/A1 _3903_/A2 _7823_/D VDD VDD VSS VSS gf180mcu_fd_sc_mcu7t5v0__and2_1
X_4883_ _7156_/Q _4896_/A2 _4884_/B VDD VDD VSS VSS gf180mcu_fd_sc_mcu7t5v0__nand2_1
X_3834_ _7588_/Q _3824_/Z _3833_/Z _3834_/Z VDD VDD VSS VSS gf180mcu_fd_sc_mcu7t5v0__xor3_1
XFILLER_20_524 VDD VDD VSS VSS gf180mcu_fd_sc_mcu7t5v0__fill_1
X_6622_ _7725_/Q _6621_/C _6622_/B _6623_/B VDD VDD VSS VSS gf180mcu_fd_sc_mcu7t5v0__oai21_1
XFILLER_20_535 VDD VDD VSS VSS gf180mcu_fd_sc_mcu7t5v0__fillcap_32
XPHY_EDGE_ROW_89_Left_208 VDD VSS gf180mcu_fd_sc_mcu7t5v0__endcap
X_3765_ _7653_/Q _5625_/C _7781_/D VDD VDD VSS VSS gf180mcu_fd_sc_mcu7t5v0__or2_1
X_6553_ _6559_/A1 _6553_/A2 _6552_/Z _7693_/D VDD VDD VSS VSS gf180mcu_fd_sc_mcu7t5v0__nor3_1
X_3696_ _3696_/A1 _3696_/A2 _6301_/A2 VDD VDD VSS VSS gf180mcu_fd_sc_mcu7t5v0__nor2_1
X_6484_ _7798_/Q _7798_/D _6485_/C VDD VDD VSS VSS gf180mcu_fd_sc_mcu7t5v0__xnor2_1
X_5504_ _5504_/A1 _5504_/A2 _5519_/B2 VDD VDD VSS VSS gf180mcu_fd_sc_mcu7t5v0__nor2_1
X_5435_ _7459_/Q wire428/Z _5606_/B1 _7361_/Q _5437_/A2 VDD VDD VSS VSS gf180mcu_fd_sc_mcu7t5v0__oai22_1
XTAP_TAPCELL_ROW_93_1562 VDD VSS gf180mcu_fd_sc_mcu7t5v0__filltie
X_5366_ _7544_/Q _5367_/A2 _5366_/Z VDD VDD VSS VSS gf180mcu_fd_sc_mcu7t5v0__and2_1
X_4317_ _6873_/Q _4322_/A2 _4318_/B VDD VDD VSS VSS gf180mcu_fd_sc_mcu7t5v0__nand2_1
X_5297_ _5304_/I0 _7444_/Q _5302_/S _7444_/D VDD VDD VSS VSS gf180mcu_fd_sc_mcu7t5v0__mux2_2
X_7105_ _7105_/D _7196_/CLK _7105_/Q VDD VDD VSS VSS gf180mcu_fd_sc_mcu7t5v0__dffq_1
X_7036_ _7036_/D _7097_/CLK _7036_/Q VDD VDD VSS VSS gf180mcu_fd_sc_mcu7t5v0__dffq_1
X_4248_ _4822_/A1 _4252_/A2 _4248_/B _6838_/D VDD VDD VSS VSS gf180mcu_fd_sc_mcu7t5v0__oai21_1
XPHY_EDGE_ROW_98_Left_217 VDD VSS gf180mcu_fd_sc_mcu7t5v0__endcap
X_4179_ _6653_/A2 _4179_/A2 _5183_/S VDD VDD VSS VSS gf180mcu_fd_sc_mcu7t5v0__nand2_1
XTAP_TAPCELL_ROW_2_288 VDD VSS gf180mcu_fd_sc_mcu7t5v0__filltie
XFILLER_35_68 VDD VDD VSS VSS gf180mcu_fd_sc_mcu7t5v0__fill_2
XTAP_TAPCELL_ROW_41_828 VDD VSS gf180mcu_fd_sc_mcu7t5v0__filltie
XTAP_TAPCELL_ROW_41_839 VDD VSS gf180mcu_fd_sc_mcu7t5v0__filltie
XTAP_TAPCELL_ROW_102_1691 VDD VSS gf180mcu_fd_sc_mcu7t5v0__filltie
XTAP_TAPCELL_ROW_102_1680 VDD VSS gf180mcu_fd_sc_mcu7t5v0__filltie
XPHY_EDGE_ROW_14_Right_14 VDD VSS gf180mcu_fd_sc_mcu7t5v0__endcap
XTAP_TAPCELL_ROW_21_552 VDD VSS gf180mcu_fd_sc_mcu7t5v0__filltie
XFILLER_4_2 VDD VDD VSS VSS gf180mcu_fd_sc_mcu7t5v0__fill_2
XTAP_TAPCELL_ROW_53_1001 VDD VSS gf180mcu_fd_sc_mcu7t5v0__filltie
XFILLER_78_524 VDD VDD VSS VSS gf180mcu_fd_sc_mcu7t5v0__fill_1
Xuart_621 racl_error_o[25] VDD VDD VSS VSS gf180mcu_fd_sc_mcu7t5v0__tiel
Xuart_610 racl_error_o[14] VDD VDD VSS VSS gf180mcu_fd_sc_mcu7t5v0__tiel
XPHY_EDGE_ROW_23_Right_23 VDD VSS gf180mcu_fd_sc_mcu7t5v0__endcap
Xuart_632 racl_error_o[36] VDD VDD VSS VSS gf180mcu_fd_sc_mcu7t5v0__tiel
Xuart_643 tl_o[61] VDD VDD VSS VSS gf180mcu_fd_sc_mcu7t5v0__tiel
XTAP_TAPCELL_ROW_49_939 VDD VSS gf180mcu_fd_sc_mcu7t5v0__filltie
XFILLER_59_760 VDD VDD VSS VSS gf180mcu_fd_sc_mcu7t5v0__fill_2
Xfanout592 _7798_/RN wire593/I VDD VDD VSS VSS gf180mcu_fd_sc_mcu7t5v0__dlyd_1
XTAP_TAPCELL_ROW_29_663 VDD VSS gf180mcu_fd_sc_mcu7t5v0__filltie
XFILLER_46_465 VDD VDD VSS VSS gf180mcu_fd_sc_mcu7t5v0__fill_1
XFILLER_62_947 VDD VDD VSS VSS gf180mcu_fd_sc_mcu7t5v0__fillcap_32
XPHY_EDGE_ROW_32_Right_32 VDD VSS gf180mcu_fd_sc_mcu7t5v0__endcap
XTAP_TAPCELL_ROW_64_1152 VDD VSS gf180mcu_fd_sc_mcu7t5v0__filltie
XFILLER_14_384 VDD VDD VSS VSS gf180mcu_fd_sc_mcu7t5v0__fill_1
XFILLER_30_877 VDD VDD VSS VSS gf180mcu_fd_sc_mcu7t5v0__fillcap_64
XFILLER_10_590 VDD VDD VSS VSS gf180mcu_fd_sc_mcu7t5v0__fillcap_4
X_3550_ input53/Z input47/Z _3550_/Z VDD VDD VSS VSS gf180mcu_fd_sc_mcu7t5v0__xor2_1
XFILLER_115_404 VDD VDD VSS VSS gf180mcu_fd_sc_mcu7t5v0__fill_1
X_5220_ _5332_/I0 _7367_/Q _5225_/S _7367_/D VDD VDD VSS VSS gf180mcu_fd_sc_mcu7t5v0__mux2_2
X_3481_ _7719_/Q _5753_/A1 _3481_/B _3488_/A2 VDD VDD VSS VSS gf180mcu_fd_sc_mcu7t5v0__oai21_1
XPHY_EDGE_ROW_41_Right_41 VDD VSS gf180mcu_fd_sc_mcu7t5v0__endcap
X_5151_ _5228_/I0 _7298_/Q _5155_/S _7298_/D VDD VDD VSS VSS gf180mcu_fd_sc_mcu7t5v0__mux2_2
X_5082_ _5110_/A1 _5092_/A2 _5082_/B _7255_/D VDD VDD VSS VSS gf180mcu_fd_sc_mcu7t5v0__oai21_1
X_4102_ _6785_/Q _4910_/A2 _4103_/B VDD VDD VSS VSS gf180mcu_fd_sc_mcu7t5v0__nand2_1
X_4033_ _6763_/Q _4602_/A2 _4034_/B VDD VDD VSS VSS gf180mcu_fd_sc_mcu7t5v0__nand2_1
XFILLER_84_527 VDD VDD VSS VSS gf180mcu_fd_sc_mcu7t5v0__fill_2
XFILLER_56_229 VDD VDD VSS VSS gf180mcu_fd_sc_mcu7t5v0__fill_1
XFILLER_92_560 VDD VDD VSS VSS gf180mcu_fd_sc_mcu7t5v0__fill_1
XFILLER_80_733 VDD VDD VSS VSS gf180mcu_fd_sc_mcu7t5v0__fill_2
XFILLER_37_487 VDD VDD VSS VSS gf180mcu_fd_sc_mcu7t5v0__fill_2
XPHY_EDGE_ROW_50_Right_50 VDD VSS gf180mcu_fd_sc_mcu7t5v0__endcap
X_7723_ _7723_/D _7798_/RN _7724_/CLK _7723_/Q VDD VDD VSS VSS gf180mcu_fd_sc_mcu7t5v0__dffrnq_1
X_5984_ _7103_/Q _6104_/B1 _6171_/A2 _7110_/Q _7117_/Q _6233_/B1 _5985_/A2 VDD VDD
+ VSS VSS gf180mcu_fd_sc_mcu7t5v0__oai222_1
X_4935_ _7182_/Q _4938_/A2 _4936_/B VDD VDD VSS VSS gf180mcu_fd_sc_mcu7t5v0__nand2_1
XANTENNA_22 _7694_/D VDD VDD VSS VSS gf180mcu_fd_sc_mcu7t5v0__antenna
XANTENNA_11 _5744_/A1 VDD VDD VSS VSS gf180mcu_fd_sc_mcu7t5v0__antenna
X_4866_ wire231/Z _4868_/A2 _4866_/B _7147_/D VDD VDD VSS VSS gf180mcu_fd_sc_mcu7t5v0__oai21_1
X_7654_ _7654_/D _7780_/RN _7782_/CLK _7654_/Q VDD VDD VSS VSS gf180mcu_fd_sc_mcu7t5v0__dffrnq_1
X_3817_ _7612_/Q _7884_/I _3816_/Z _3818_/I VDD VDD VSS VSS gf180mcu_fd_sc_mcu7t5v0__xor3_1
X_7585_ _7585_/D _7595_/RN _7710_/CLK _7585_/Q VDD VDD VSS VSS gf180mcu_fd_sc_mcu7t5v0__dffrnq_1
X_6605_ _6605_/A1 _6605_/A2 _6606_/A2 VDD VDD VSS VSS gf180mcu_fd_sc_mcu7t5v0__nand2_1
X_4797_ _7113_/Q _4798_/A2 _4798_/B VDD VDD VSS VSS gf180mcu_fd_sc_mcu7t5v0__nand2_1
XFILLER_118_242 VDD VDD VSS VSS gf180mcu_fd_sc_mcu7t5v0__fill_1
X_6536_ _7688_/Q _6534_/Z _6538_/A2 VDD VDD VSS VSS gf180mcu_fd_sc_mcu7t5v0__nor2_1
X_3748_ _7798_/D _3750_/A2 _3748_/B1 _3748_/B2 _3749_/A2 VDD VDD VSS VSS gf180mcu_fd_sc_mcu7t5v0__aoi22_1
X_6467_ _6453_/I _6459_/Z _6469_/C _6469_/A2 VDD VDD VSS VSS gf180mcu_fd_sc_mcu7t5v0__nand3_1
X_3679_ _3677_/Z _3679_/A2 _3683_/A2 VDD VDD VSS VSS gf180mcu_fd_sc_mcu7t5v0__nand2_1
X_6398_ _7659_/Q _7525_/Q _6411_/C VDD VDD VSS VSS gf180mcu_fd_sc_mcu7t5v0__and2_1
Xoutput151 _7590_/Q tl_o[34] VDD VDD VSS VSS gf180mcu_fd_sc_mcu7t5v0__dlyd_1
Xoutput140 _7580_/Q tl_o[24] VDD VDD VSS VSS gf180mcu_fd_sc_mcu7t5v0__dlyd_1
X_5418_ _7500_/Q _5516_/C2 _5420_/A2 VDD VDD VSS VSS gf180mcu_fd_sc_mcu7t5v0__nor2_1
Xclkbuf_leaf_74_clk_i clkbuf_3_1__f_clk_i/Z _7754_/CLK VDD VDD VSS VSS gf180mcu_fd_sc_mcu7t5v0__clkbuf_8
Xoutput173 _7610_/Q tl_o[55] VDD VDD VSS VSS gf180mcu_fd_sc_mcu7t5v0__dlyd_1
Xoutput162 _7600_/Q tl_o[44] VDD VDD VSS VSS gf180mcu_fd_sc_mcu7t5v0__dlyd_1
X_5349_ _7643_/Q _7496_/Q _5351_/S _7496_/D VDD VDD VSS VSS gf180mcu_fd_sc_mcu7t5v0__mux2_2
XFILLER_88_877 VDD VDD VSS VSS gf180mcu_fd_sc_mcu7t5v0__fill_2
XFILLER_88_855 VDD VDD VSS VSS gf180mcu_fd_sc_mcu7t5v0__fillcap_8
XTAP_TAPCELL_ROW_7_358 VDD VSS gf180mcu_fd_sc_mcu7t5v0__filltie
Xclkbuf_leaf_89_clk_i clkload0/I _7823_/CLK VDD VDD VSS VSS gf180mcu_fd_sc_mcu7t5v0__clkbuf_8
X_7019_ _7019_/D _7097_/CLK _7019_/Q VDD VDD VSS VSS gf180mcu_fd_sc_mcu7t5v0__dffq_1
XTAP_TAPCELL_ROW_46_909 VDD VSS gf180mcu_fd_sc_mcu7t5v0__filltie
XFILLER_56_785 VDD VDD VSS VSS gf180mcu_fd_sc_mcu7t5v0__fill_1
XTAP_TAPCELL_ROW_26_622 VDD VSS gf180mcu_fd_sc_mcu7t5v0__filltie
XFILLER_44_947 VDD VDD VSS VSS gf180mcu_fd_sc_mcu7t5v0__fillcap_32
Xclkbuf_leaf_12_clk_i clkload2/I _7792_/CLK VDD VDD VSS VSS gf180mcu_fd_sc_mcu7t5v0__clkbuf_8
XFILLER_56_796 VDD VDD VSS VSS gf180mcu_fd_sc_mcu7t5v0__fill_1
XTAP_TAPCELL_ROW_104_1720 VDD VSS gf180mcu_fd_sc_mcu7t5v0__filltie
Xclkbuf_leaf_27_clk_i clkload2/I _7667_/CLK VDD VDD VSS VSS gf180mcu_fd_sc_mcu7t5v0__clkbuf_8
XFILLER_12_877 VDD VDD VSS VSS gf180mcu_fd_sc_mcu7t5v0__fillcap_64
XFILLER_11_354 VDD VDD VSS VSS gf180mcu_fd_sc_mcu7t5v0__fill_1
XTAP_TAPCELL_ROW_115_1871 VDD VSS gf180mcu_fd_sc_mcu7t5v0__filltie
Xload_slew217 _5056_/A1 _5070_/A1 VDD VDD VSS VSS gf180mcu_fd_sc_mcu7t5v0__buf_4
XFILLER_19_487 VDD VDD VSS VSS gf180mcu_fd_sc_mcu7t5v0__fill_2
XFILLER_62_733 VDD VDD VSS VSS gf180mcu_fd_sc_mcu7t5v0__fill_2
XFILLER_34_457 VDD VDD VSS VSS gf180mcu_fd_sc_mcu7t5v0__fill_2
XFILLER_61_243 VDD VDD VSS VSS gf180mcu_fd_sc_mcu7t5v0__fill_2
X_4720_ _4748_/A1 _4728_/A2 _4720_/B _7074_/D VDD VDD VSS VSS gf180mcu_fd_sc_mcu7t5v0__oai21_1
X_4651_ _7040_/Q _4658_/A2 _4652_/B VDD VDD VSS VSS gf180mcu_fd_sc_mcu7t5v0__nand2_1
Xinput20 tl_i[11] input20/Z VDD VDD VSS VSS gf180mcu_fd_sc_mcu7t5v0__dlyd_1
X_3602_ input58/Z input57/Z _3602_/Z VDD VDD VSS VSS gf180mcu_fd_sc_mcu7t5v0__xor2_1
Xinput31 tl_i[30] input31/Z VDD VDD VSS VSS gf180mcu_fd_sc_mcu7t5v0__dlyd_1
X_4582_ _5128_/A1 _4588_/A2 _4582_/B _7005_/D VDD VDD VSS VSS gf180mcu_fd_sc_mcu7t5v0__oai21_1
Xinput64 tl_i[60] input64/Z VDD VDD VSS VSS gf180mcu_fd_sc_mcu7t5v0__dlyd_1
XTAP_TAPCELL_ROW_77_1332 VDD VSS gf180mcu_fd_sc_mcu7t5v0__filltie
Xinput53 tl_i[50] input53/Z VDD VDD VSS VSS gf180mcu_fd_sc_mcu7t5v0__dlyd_1
Xinput42 tl_i[40] input42/Z VDD VDD VSS VSS gf180mcu_fd_sc_mcu7t5v0__dlyd_1
X_7370_ _7370_/D _7472_/CLK _7370_/Q VDD VDD VSS VSS gf180mcu_fd_sc_mcu7t5v0__dffq_1
Xinput97 tl_i[90] input97/Z VDD VDD VSS VSS gf180mcu_fd_sc_mcu7t5v0__dlyd_1
Xinput86 tl_i[80] input86/Z VDD VDD VSS VSS gf180mcu_fd_sc_mcu7t5v0__dlyd_1
Xinput75 tl_i[70] _7882_/I VDD VDD VSS VSS gf180mcu_fd_sc_mcu7t5v0__dlyd_1
XTAP_TAPCELL_ROW_77_1343 VDD VSS gf180mcu_fd_sc_mcu7t5v0__filltie
X_3533_ _3696_/A1 _3682_/C _3532_/Z _3533_/Z VDD VDD VSS VSS gf180mcu_fd_sc_mcu7t5v0__xor3_1
X_6321_ input33/Z _6326_/A2 _6322_/B VDD VDD VSS VSS gf180mcu_fd_sc_mcu7t5v0__nand2_1
X_3464_ _7569_/Q _3897_/A2 VDD VDD VSS VSS gf180mcu_fd_sc_mcu7t5v0__clkinv_1
X_6252_ _7560_/Q _6252_/A2 _5691_/I _7781_/Q _6271_/B1 _7623_/Q _6253_/I VDD VDD VSS
+ VSS gf180mcu_fd_sc_mcu7t5v0__aoi222_1
XTAP_TAPCELL_ROW_90_1521 VDD VSS gf180mcu_fd_sc_mcu7t5v0__filltie
X_5203_ _5245_/I0 _7350_/Q _5204_/S _7350_/D VDD VDD VSS VSS gf180mcu_fd_sc_mcu7t5v0__mux2_2
X_6183_ _6183_/A1 _6183_/A2 _6183_/B1 _6237_/B _6244_/C _6184_/B VDD VDD VSS VSS gf180mcu_fd_sc_mcu7t5v0__oai221_1
XFILLER_112_941 VDD VDD VSS VSS gf180mcu_fd_sc_mcu7t5v0__fillcap_4
X_3395_ _7672_/Q _6490_/A1 VDD VDD VSS VSS gf180mcu_fd_sc_mcu7t5v0__clkinv_1
X_5134_ _5134_/A1 _5134_/A2 _5134_/B _7281_/D VDD VDD VSS VSS gf180mcu_fd_sc_mcu7t5v0__oai21_1
XTAP_TAPCELL_ROW_4_317 VDD VSS gf180mcu_fd_sc_mcu7t5v0__filltie
XFILLER_57_516 VDD VDD VSS VSS gf180mcu_fd_sc_mcu7t5v0__fillcap_4
X_5065_ _7247_/Q _5075_/A2 _5066_/B VDD VDD VSS VSS gf180mcu_fd_sc_mcu7t5v0__nor2_1
XFILLER_57_549 VDD VDD VSS VSS gf180mcu_fd_sc_mcu7t5v0__fillcap_4
X_4016_ _6758_/Q _4532_/A2 _4017_/B VDD VDD VSS VSS gf180mcu_fd_sc_mcu7t5v0__nand2_1
XTAP_TAPCELL_ROW_88_1494 VDD VSS gf180mcu_fd_sc_mcu7t5v0__filltie
XFILLER_26_947 VDD VDD VSS VSS gf180mcu_fd_sc_mcu7t5v0__fillcap_32
XFILLER_65_582 VDD VDD VSS VSS gf180mcu_fd_sc_mcu7t5v0__fill_2
XFILLER_41_906 VDD VDD VSS VSS gf180mcu_fd_sc_mcu7t5v0__fillcap_4
XFILLER_53_766 VDD VDD VSS VSS gf180mcu_fd_sc_mcu7t5v0__fillcap_4
X_5967_ _5967_/A1 _5967_/A2 _5994_/B1 VDD VDD VSS VSS gf180mcu_fd_sc_mcu7t5v0__nor2_1
XFILLER_12_107 VDD VDD VSS VSS gf180mcu_fd_sc_mcu7t5v0__fill_2
X_7706_ _7706_/D _7706_/RN _7781_/CLK _7706_/Q VDD VDD VSS VSS gf180mcu_fd_sc_mcu7t5v0__dffrnq_1
X_4918_ _4918_/A1 _4924_/A2 _4918_/B _7173_/D VDD VDD VSS VSS gf180mcu_fd_sc_mcu7t5v0__oai21_1
X_7637_ _7637_/D _7693_/RN _7693_/CLK _7637_/Q VDD VDD VSS VSS gf180mcu_fd_sc_mcu7t5v0__dffrnq_1
XTAP_TAPCELL_ROW_51_967 VDD VSS gf180mcu_fd_sc_mcu7t5v0__filltie
XTAP_TAPCELL_ROW_51_978 VDD VSS gf180mcu_fd_sc_mcu7t5v0__filltie
X_5898_ _7193_/Q _6098_/A2 _6232_/A2 _7200_/Q _7214_/Q _6097_/A2 _5899_/A2 VDD VDD
+ VSS VSS gf180mcu_fd_sc_mcu7t5v0__oai222_1
XFILLER_20_162 VDD VDD VSS VSS gf180mcu_fd_sc_mcu7t5v0__fill_1
XFILLER_21_696 VDD VDD VSS VSS gf180mcu_fd_sc_mcu7t5v0__fillcap_4
X_4849_ _7139_/Q _4854_/A2 _4850_/B VDD VDD VSS VSS gf180mcu_fd_sc_mcu7t5v0__nand2_1
XTAP_TAPCELL_ROW_31_691 VDD VSS gf180mcu_fd_sc_mcu7t5v0__filltie
X_7568_ _7568_/D _7653_/RN _7794_/CLK _7568_/Q VDD VDD VSS VSS gf180mcu_fd_sc_mcu7t5v0__dffrnq_1
XFILLER_107_746 VDD VDD VSS VSS gf180mcu_fd_sc_mcu7t5v0__fill_2
X_7499_ _7499_/D _7499_/CLK _7499_/Q VDD VDD VSS VSS gf180mcu_fd_sc_mcu7t5v0__dffq_1
X_6519_ _7682_/Q _6516_/Z _6519_/Z VDD VDD VSS VSS gf180mcu_fd_sc_mcu7t5v0__or2_1
XFILLER_0_512 VDD VDD VSS VSS gf180mcu_fd_sc_mcu7t5v0__fillcap_32
XFILLER_102_440 VDD VDD VSS VSS gf180mcu_fd_sc_mcu7t5v0__fill_2
XFILLER_48_516 VDD VDD VSS VSS gf180mcu_fd_sc_mcu7t5v0__fill_1
XFILLER_44_711 VDD VDD VSS VSS gf180mcu_fd_sc_mcu7t5v0__fill_2
XFILLER_31_427 VDD VDD VSS VSS gf180mcu_fd_sc_mcu7t5v0__fill_2
XTAP_TAPCELL_ROW_61_1111 VDD VSS gf180mcu_fd_sc_mcu7t5v0__filltie
XTAP_TAPCELL_ROW_117_1900 VDD VSS gf180mcu_fd_sc_mcu7t5v0__filltie
XFILLER_8_667 VDD VDD VSS VSS gf180mcu_fd_sc_mcu7t5v0__fillcap_64
XTAP_TAPCELL_ROW_59_1084 VDD VSS gf180mcu_fd_sc_mcu7t5v0__filltie
XTAP_TAPCELL_ROW_72_1262 VDD VSS gf180mcu_fd_sc_mcu7t5v0__filltie
XTAP_TAPCELL_ROW_72_1273 VDD VSS gf180mcu_fd_sc_mcu7t5v0__filltie
XFILLER_94_644 VDD VDD VSS VSS gf180mcu_fd_sc_mcu7t5v0__fill_2
XFILLER_94_655 VDD VDD VSS VSS gf180mcu_fd_sc_mcu7t5v0__fill_1
XFILLER_93_165 VDD VDD VSS VSS gf180mcu_fd_sc_mcu7t5v0__fill_2
XFILLER_81_316 VDD VDD VSS VSS gf180mcu_fd_sc_mcu7t5v0__fill_2
X_6870_ _6870_/D _6915_/CLK _6870_/Q VDD VDD VSS VSS gf180mcu_fd_sc_mcu7t5v0__dffq_1
XFILLER_81_349 VDD VDD VSS VSS gf180mcu_fd_sc_mcu7t5v0__fill_1
XFILLER_23_906 VDD VDD VSS VSS gf180mcu_fd_sc_mcu7t5v0__fillcap_4
XFILLER_35_766 VDD VDD VSS VSS gf180mcu_fd_sc_mcu7t5v0__fillcap_4
X_5821_ _5821_/I _7572_/D VDD VDD VSS VSS gf180mcu_fd_sc_mcu7t5v0__clkinv_1
X_5752_ _5753_/A1 _7713_/Q _6242_/B1 VDD VDD VSS VSS gf180mcu_fd_sc_mcu7t5v0__nand2_1
XTAP_TAPCELL_ROW_17_496 VDD VSS gf180mcu_fd_sc_mcu7t5v0__filltie
XFILLER_22_427 VDD VDD VSS VSS gf180mcu_fd_sc_mcu7t5v0__fill_2
X_4703_ _7066_/Q _4714_/A2 _4704_/B VDD VDD VSS VSS gf180mcu_fd_sc_mcu7t5v0__nand2_1
X_5683_ _7557_/Q input36/Z _5687_/S _7557_/D VDD VDD VSS VSS gf180mcu_fd_sc_mcu7t5v0__mux2_2
X_4634_ wire268/Z _4644_/A2 _4634_/B _7031_/D VDD VDD VSS VSS gf180mcu_fd_sc_mcu7t5v0__oai21_1
X_7422_ _7422_/D _7736_/CLK _7422_/Q VDD VDD VSS VSS gf180mcu_fd_sc_mcu7t5v0__dffq_1
X_4565_ _6997_/Q _4574_/A2 _4566_/B VDD VDD VSS VSS gf180mcu_fd_sc_mcu7t5v0__nand2_1
X_7353_ _7353_/D _7378_/CLK _7353_/Q VDD VDD VSS VSS gf180mcu_fd_sc_mcu7t5v0__dffq_1
X_6304_ _7605_/Q _6304_/I1 _6310_/S _7605_/D VDD VDD VSS VSS gf180mcu_fd_sc_mcu7t5v0__mux2_2
X_3516_ _7770_/D _7767_/D _3901_/B VDD VDD VSS VSS gf180mcu_fd_sc_mcu7t5v0__or2_1
X_4496_ _5126_/A1 _4504_/A2 _4496_/B _6962_/D VDD VDD VSS VSS gf180mcu_fd_sc_mcu7t5v0__oai21_1
X_7284_ _7284_/D _7483_/CLK _7284_/Q VDD VDD VSS VSS gf180mcu_fd_sc_mcu7t5v0__dffq_1
XPHY_EDGE_ROW_4_Right_4 VDD VSS gf180mcu_fd_sc_mcu7t5v0__endcap
X_3447_ _7601_/Q _6298_/A1 VDD VDD VSS VSS gf180mcu_fd_sc_mcu7t5v0__clkinv_1
X_6235_ _6797_/Q _6235_/A2 _6235_/B1 _6796_/Q _6237_/A1 VDD VDD VSS VSS gf180mcu_fd_sc_mcu7t5v0__oai22_1
X_6166_ _6166_/A1 _6166_/A2 _6170_/B1 VDD VDD VSS VSS gf180mcu_fd_sc_mcu7t5v0__nor2_1
X_3378_ _3378_/I _3666_/B VDD VDD VSS VSS gf180mcu_fd_sc_mcu7t5v0__clkinv_1
Xload_slew581 _7660_/RN _7664_/RN VDD VDD VSS VSS gf180mcu_fd_sc_mcu7t5v0__buf_4
X_5117_ _7273_/Q _5120_/A2 _5118_/B VDD VDD VSS VSS gf180mcu_fd_sc_mcu7t5v0__nand2_1
X_6097_ _7217_/Q _6097_/A2 _6174_/A2 _7210_/Q _6099_/A1 VDD VDD VSS VSS gf180mcu_fd_sc_mcu7t5v0__oai22_1
Xload_slew570 _7705_/RN _7703_/RN VDD VDD VSS VSS gf180mcu_fd_sc_mcu7t5v0__buf_4
XFILLER_111_292 VDD VDD VSS VSS gf180mcu_fd_sc_mcu7t5v0__fill_2
XFILLER_45_508 VDD VDD VSS VSS gf180mcu_fd_sc_mcu7t5v0__fill_2
X_5048_ _5076_/A1 _5050_/A2 _5048_/B _7238_/D VDD VDD VSS VSS gf180mcu_fd_sc_mcu7t5v0__oai21_1
XFILLER_85_699 VDD VDD VSS VSS gf180mcu_fd_sc_mcu7t5v0__fill_1
XTAP_TAPCELL_ROW_36_761 VDD VSS gf180mcu_fd_sc_mcu7t5v0__filltie
X_6999_ _6999_/D _7003_/CLK _6999_/Q VDD VDD VSS VSS gf180mcu_fd_sc_mcu7t5v0__dffq_1
XPHY_EDGE_ROW_80_Left_199 VDD VSS gf180mcu_fd_sc_mcu7t5v0__endcap
XFILLER_5_626 VDD VDD VSS VSS gf180mcu_fd_sc_mcu7t5v0__fillcap_4
XTAP_TAPCELL_ROW_112_1830 VDD VSS gf180mcu_fd_sc_mcu7t5v0__filltie
XFILLER_49_825 VDD VDD VSS VSS gf180mcu_fd_sc_mcu7t5v0__fill_1
XFILLER_17_766 VDD VDD VSS VSS gf180mcu_fd_sc_mcu7t5v0__fillcap_4
XTAP_TAPCELL_ROW_14_455 VDD VSS gf180mcu_fd_sc_mcu7t5v0__filltie
XFILLER_31_279 VDD VDD VSS VSS gf180mcu_fd_sc_mcu7t5v0__fill_1
XFILLER_9_976 VDD VDD VSS VSS gf180mcu_fd_sc_mcu7t5v0__fillcap_4
X_4350_ _4532_/A1 _4350_/A2 _4350_/B _6889_/D VDD VDD VSS VSS gf180mcu_fd_sc_mcu7t5v0__oai21_1
XFILLER_99_769 VDD VDD VSS VSS gf180mcu_fd_sc_mcu7t5v0__fill_1
X_4281_ _6855_/Q _4294_/A2 _4282_/B VDD VDD VSS VSS gf180mcu_fd_sc_mcu7t5v0__nand2_1
X_6020_ _6020_/A1 _6020_/A2 _6020_/B1 _6020_/B2 _6231_/C _6034_/A1 VDD VDD VSS VSS
+ gf180mcu_fd_sc_mcu7t5v0__oai221_1
XFILLER_66_154 VDD VDD VSS VSS gf180mcu_fd_sc_mcu7t5v0__fill_1
XFILLER_55_839 VDD VDD VSS VSS gf180mcu_fd_sc_mcu7t5v0__fill_1
XFILLER_67_699 VDD VDD VSS VSS gf180mcu_fd_sc_mcu7t5v0__fill_1
X_6922_ _6922_/D _6944_/CLK _6922_/Q VDD VDD VSS VSS gf180mcu_fd_sc_mcu7t5v0__dffq_1
XTAP_TAPCELL_ROW_85_1442 VDD VSS gf180mcu_fd_sc_mcu7t5v0__filltie
X_6853_ _6853_/D _7692_/CLK _6853_/Q VDD VDD VSS VSS gf180mcu_fd_sc_mcu7t5v0__dffq_1
XTAP_TAPCELL_ROW_85_1453 VDD VSS gf180mcu_fd_sc_mcu7t5v0__filltie
X_5804_ _5804_/A1 _5804_/A2 _5926_/B _5805_/B2 VDD VDD VSS VSS gf180mcu_fd_sc_mcu7t5v0__oai21_1
XFILLER_22_213 VDD VDD VSS VSS gf180mcu_fd_sc_mcu7t5v0__fill_2
XTAP_TAPCELL_ROW_33_720 VDD VSS gf180mcu_fd_sc_mcu7t5v0__filltie
X_3996_ _4141_/A2 _3999_/A2 _4448_/A2 VDD VDD VSS VSS gf180mcu_fd_sc_mcu7t5v0__nand2_1
X_6784_ _6784_/D _7453_/CLK _6784_/Q VDD VDD VSS VSS gf180mcu_fd_sc_mcu7t5v0__dffq_1
XFILLER_13_38 VDD VDD VSS VSS gf180mcu_fd_sc_mcu7t5v0__fill_2
X_5735_ input36/Z _5738_/A2 _5735_/B _7566_/D VDD VDD VSS VSS gf180mcu_fd_sc_mcu7t5v0__aoi21_1
X_5666_ input33/Z _7783_/D _5667_/B VDD VDD VSS VSS gf180mcu_fd_sc_mcu7t5v0__nand2_1
X_4617_ _7023_/Q _4630_/A2 _4618_/B VDD VDD VSS VSS gf180mcu_fd_sc_mcu7t5v0__nand2_1
X_7405_ _7405_/D _7500_/CLK _7405_/Q VDD VDD VSS VSS gf180mcu_fd_sc_mcu7t5v0__dffq_1
X_5597_ _6821_/Q _5597_/A2 _5597_/B1 _6819_/Q _5598_/A3 VDD VDD VSS VSS gf180mcu_fd_sc_mcu7t5v0__oai22_1
X_4548_ _4786_/A1 _4560_/A2 _4548_/B _6988_/D VDD VDD VSS VSS gf180mcu_fd_sc_mcu7t5v0__oai21_1
X_7336_ _7336_/D _7378_/CLK _7336_/Q VDD VDD VSS VSS gf180mcu_fd_sc_mcu7t5v0__dffq_1
X_4479_ _6954_/Q _4490_/A2 _4480_/B VDD VDD VSS VSS gf180mcu_fd_sc_mcu7t5v0__nand2_1
XFILLER_104_524 VDD VDD VSS VSS gf180mcu_fd_sc_mcu7t5v0__fill_1
X_7267_ _7267_/D _7267_/CLK _7267_/Q VDD VDD VSS VSS gf180mcu_fd_sc_mcu7t5v0__dffq_1
XFILLER_89_235 VDD VDD VSS VSS gf180mcu_fd_sc_mcu7t5v0__fill_1
X_6218_ _6217_/B _6218_/A2 _6218_/B1 _6218_/B2 _6246_/A2 VDD VDD VSS VSS gf180mcu_fd_sc_mcu7t5v0__oai22_1
X_7198_ _7198_/D _7251_/CLK _7198_/Q VDD VDD VSS VSS gf180mcu_fd_sc_mcu7t5v0__dffq_1
X_6149_ _6149_/A1 _6149_/A2 _6176_/B _6156_/A2 VDD VDD VSS VSS gf180mcu_fd_sc_mcu7t5v0__oai21_1
XPHY_EDGE_ROW_79_Right_79 VDD VSS gf180mcu_fd_sc_mcu7t5v0__endcap
XFILLER_41_511 VDD VDD VSS VSS gf180mcu_fd_sc_mcu7t5v0__fill_1
XPHY_EDGE_ROW_109_Left_228 VDD VSS gf180mcu_fd_sc_mcu7t5v0__endcap
XTAP_TAPCELL_ROW_11_414 VDD VSS gf180mcu_fd_sc_mcu7t5v0__filltie
XFILLER_70_33 VDD VDD VSS VSS gf180mcu_fd_sc_mcu7t5v0__fill_2
XPHY_EDGE_ROW_88_Right_88 VDD VSS gf180mcu_fd_sc_mcu7t5v0__endcap
XFILLER_6_979 VDD VDD VSS VSS gf180mcu_fd_sc_mcu7t5v0__fill_2
XFILLER_108_874 VDD VDD VSS VSS gf180mcu_fd_sc_mcu7t5v0__fill_1
XPHY_EDGE_ROW_118_Left_237 VDD VSS gf180mcu_fd_sc_mcu7t5v0__endcap
XTAP_TAPCELL_ROW_56_1043 VDD VSS gf180mcu_fd_sc_mcu7t5v0__filltie
XFILLER_69_909 VDD VDD VSS VSS gf180mcu_fd_sc_mcu7t5v0__fill_1
XFILLER_89_780 VDD VDD VSS VSS gf180mcu_fd_sc_mcu7t5v0__fillcap_4
XPHY_EDGE_ROW_97_Right_97 VDD VSS gf180mcu_fd_sc_mcu7t5v0__endcap
XFILLER_48_121 VDD VDD VSS VSS gf180mcu_fd_sc_mcu7t5v0__fill_1
XFILLER_49_699 VDD VDD VSS VSS gf180mcu_fd_sc_mcu7t5v0__fill_1
XFILLER_91_422 VDD VDD VSS VSS gf180mcu_fd_sc_mcu7t5v0__fill_1
XTAP_TAPCELL_ROW_19_525 VDD VSS gf180mcu_fd_sc_mcu7t5v0__filltie
XTAP_TAPCELL_ROW_67_1194 VDD VSS gf180mcu_fd_sc_mcu7t5v0__filltie
X_3850_ _7773_/Q _3850_/A2 _3901_/B _3850_/C _7827_/D VDD VDD VSS VSS gf180mcu_fd_sc_mcu7t5v0__aoi211_1
XTAP_TAPCELL_ROW_80_1372 VDD VSS gf180mcu_fd_sc_mcu7t5v0__filltie
X_3781_ _3781_/A1 _3781_/A2 _3781_/B _3783_/A3 VDD VDD VSS VSS gf180mcu_fd_sc_mcu7t5v0__oai21_1
XTAP_TAPCELL_ROW_80_1383 VDD VSS gf180mcu_fd_sc_mcu7t5v0__filltie
X_5520_ _5590_/B _5520_/A2 _5520_/A3 _7730_/Q _5522_/A2 VDD VDD VSS VSS gf180mcu_fd_sc_mcu7t5v0__oai31_1
X_5451_ _7452_/Q _5599_/A2 _5544_/A2 _7445_/Q _7431_/Q _5501_/B1 _5457_/A2 VDD VDD
+ VSS VSS gf180mcu_fd_sc_mcu7t5v0__oai222_1
XFILLER_99_500 VDD VDD VSS VSS gf180mcu_fd_sc_mcu7t5v0__fill_2
X_4402_ _4402_/A1 _4406_/A2 _4402_/B _6915_/D VDD VDD VSS VSS gf180mcu_fd_sc_mcu7t5v0__oai21_1
X_5382_ _7457_/Q wire428/Z _5606_/B1 _7359_/Q _5384_/A2 VDD VDD VSS VSS gf180mcu_fd_sc_mcu7t5v0__oai22_1
X_4333_ _6881_/Q _4336_/A2 _4334_/B VDD VDD VSS VSS gf180mcu_fd_sc_mcu7t5v0__nand2_1
X_7121_ _7121_/D _7250_/CLK _7121_/Q VDD VDD VSS VSS gf180mcu_fd_sc_mcu7t5v0__dffq_1
XFILLER_114_877 VDD VDD VSS VSS gf180mcu_fd_sc_mcu7t5v0__fillcap_64
X_4264_ _5132_/A1 _4266_/A2 _4264_/B _6846_/D VDD VDD VSS VSS gf180mcu_fd_sc_mcu7t5v0__oai21_1
X_7052_ _7052_/D _7062_/CLK _7052_/Q VDD VDD VSS VSS gf180mcu_fd_sc_mcu7t5v0__dffq_1
Xfanout218 wire220/Z _4762_/A1 VDD VDD VSS VSS gf180mcu_fd_sc_mcu7t5v0__dlyd_1
XFILLER_87_739 VDD VDD VSS VSS gf180mcu_fd_sc_mcu7t5v0__fillcap_4
X_6003_ _7618_/Q _6283_/A2 _6252_/A2 _7555_/Q _6005_/A2 VDD VDD VSS VSS gf180mcu_fd_sc_mcu7t5v0__aoi22_1
X_4195_ _4234_/I0 _6814_/Q _5225_/S _6814_/D VDD VDD VSS VSS gf180mcu_fd_sc_mcu7t5v0__mux2_2
XFILLER_83_978 VDD VDD VSS VSS gf180mcu_fd_sc_mcu7t5v0__fill_2
X_6905_ _6905_/D _6939_/CLK _6905_/Q VDD VDD VSS VSS gf180mcu_fd_sc_mcu7t5v0__dffq_1
X_7885_ _7885_/I _7885_/Z VDD VDD VSS VSS gf180mcu_fd_sc_mcu7t5v0__buf_1
X_6836_ _6836_/D _6882_/CLK _6836_/Q VDD VDD VSS VSS gf180mcu_fd_sc_mcu7t5v0__dffq_1
X_6767_ _6767_/D _7055_/CLK _6767_/Q VDD VDD VSS VSS gf180mcu_fd_sc_mcu7t5v0__dffq_1
X_3979_ _6746_/Q _4364_/A2 _3980_/B VDD VDD VSS VSS gf180mcu_fd_sc_mcu7t5v0__nand2_1
X_5718_ _7618_/Q _6499_/A1 _6324_/A1 _7676_/Q _5718_/C _5719_/B VDD VDD VSS VSS gf180mcu_fd_sc_mcu7t5v0__aoi221_1
XTAP_TAPCELL_ROW_98_1633 VDD VSS gf180mcu_fd_sc_mcu7t5v0__filltie
X_6698_ _7747_/Q _6716_/A2 _6714_/B1 _7748_/Q _6699_/I VDD VDD VSS VSS gf180mcu_fd_sc_mcu7t5v0__aoi22_1
X_5649_ _7532_/Q input59/Z _5651_/S _7532_/D VDD VDD VSS VSS gf180mcu_fd_sc_mcu7t5v0__mux2_2
XFILLER_108_159 VDD VDD VSS VSS gf180mcu_fd_sc_mcu7t5v0__fill_1
X_7319_ _7319_/D _7491_/CLK _7319_/Q VDD VDD VSS VSS gf180mcu_fd_sc_mcu7t5v0__dffq_1
XFILLER_105_888 VDD VDD VSS VSS gf180mcu_fd_sc_mcu7t5v0__fill_1
XFILLER_105_877 VDD VDD VSS VSS gf180mcu_fd_sc_mcu7t5v0__fill_1
XFILLER_77_238 VDD VDD VSS VSS gf180mcu_fd_sc_mcu7t5v0__fill_1
XFILLER_58_463 VDD VDD VSS VSS gf180mcu_fd_sc_mcu7t5v0__fill_1
XFILLER_73_422 VDD VDD VSS VSS gf180mcu_fd_sc_mcu7t5v0__fill_2
XFILLER_46_658 VDD VDD VSS VSS gf180mcu_fd_sc_mcu7t5v0__fill_1
XTAP_TAPCELL_ROW_107_1762 VDD VSS gf180mcu_fd_sc_mcu7t5v0__filltie
XTAP_TAPCELL_ROW_107_1751 VDD VSS gf180mcu_fd_sc_mcu7t5v0__filltie
XFILLER_14_522 VDD VDD VSS VSS gf180mcu_fd_sc_mcu7t5v0__fill_2
XFILLER_14_500 VDD VDD VSS VSS gf180mcu_fd_sc_mcu7t5v0__fill_1
XFILLER_61_639 VDD VDD VSS VSS gf180mcu_fd_sc_mcu7t5v0__fill_1
XFILLER_14_588 VDD VDD VSS VSS gf180mcu_fd_sc_mcu7t5v0__fillcap_4
XTAP_TAPCELL_ROW_24_594 VDD VSS gf180mcu_fd_sc_mcu7t5v0__filltie
XFILLER_111_836 VDD VDD VSS VSS gf180mcu_fd_sc_mcu7t5v0__fillcap_4
XFILLER_96_547 VDD VDD VSS VSS gf180mcu_fd_sc_mcu7t5v0__fill_1
XFILLER_1_492 VDD VDD VSS VSS gf180mcu_fd_sc_mcu7t5v0__fillcap_8
XFILLER_77_772 VDD VDD VSS VSS gf180mcu_fd_sc_mcu7t5v0__fill_2
Xinput7 tl_i[0] input7/Z VDD VDD VSS VSS gf180mcu_fd_sc_mcu7t5v0__dlyd_1
XFILLER_65_912 VDD VDD VSS VSS gf180mcu_fd_sc_mcu7t5v0__fill_1
XTAP_TAPCELL_ROW_69_1223 VDD VSS gf180mcu_fd_sc_mcu7t5v0__filltie
XFILLER_65_978 VDD VDD VSS VSS gf180mcu_fd_sc_mcu7t5v0__fill_2
XTAP_TAPCELL_ROW_82_1412 VDD VSS gf180mcu_fd_sc_mcu7t5v0__filltie
XTAP_TAPCELL_ROW_82_1401 VDD VSS gf180mcu_fd_sc_mcu7t5v0__filltie
XFILLER_24_319 VDD VDD VSS VSS gf180mcu_fd_sc_mcu7t5v0__fill_1
X_4951_ _7190_/Q _4952_/A2 _4952_/B VDD VDD VSS VSS gf180mcu_fd_sc_mcu7t5v0__nand2_1
XFILLER_52_639 VDD VDD VSS VSS gf180mcu_fd_sc_mcu7t5v0__fill_1
X_7670_ _7670_/D _7671_/RN _7670_/CLK _7670_/Q VDD VDD VSS VSS gf180mcu_fd_sc_mcu7t5v0__dffrnq_1
X_3902_ _3902_/A1 _3812_/Z _3899_/S _7822_/D _3903_/A2 VDD VDD VSS VSS gf180mcu_fd_sc_mcu7t5v0__oai22_1
XFILLER_33_842 VDD VDD VSS VSS gf180mcu_fd_sc_mcu7t5v0__fillcap_64
X_4882_ _4952_/A1 _4882_/A2 _4882_/B _7155_/D VDD VDD VSS VSS gf180mcu_fd_sc_mcu7t5v0__oai21_1
X_3833_ _7590_/Q _7591_/Q _3833_/Z VDD VDD VSS VSS gf180mcu_fd_sc_mcu7t5v0__xor2_1
X_6621_ _6621_/A1 _6621_/A2 _6621_/B _6621_/C _7724_/D VDD VDD VSS VSS gf180mcu_fd_sc_mcu7t5v0__aoi211_1
X_3764_ _3727_/I _3763_/Z _5625_/C VDD VDD VSS VSS gf180mcu_fd_sc_mcu7t5v0__and2_1
X_6552_ _7693_/Q _6549_/Z _6552_/Z VDD VDD VSS VSS gf180mcu_fd_sc_mcu7t5v0__and2_1
X_6483_ _7797_/Q _3484_/I _6483_/B _6483_/C _6485_/B VDD VDD VSS VSS gf180mcu_fd_sc_mcu7t5v0__aoi211_1
X_5503_ _7391_/Q _5604_/A2 _5572_/C2 _7384_/Q _7377_/Q _5594_/B1 _5504_/A2 VDD VDD
+ VSS VSS gf180mcu_fd_sc_mcu7t5v0__oai222_1
X_3695_ input18/Z input16/Z _3681_/C _3694_/Z _3695_/C _3700_/A3 VDD VDD VSS VSS gf180mcu_fd_sc_mcu7t5v0__aoi221_1
X_5434_ _5434_/A1 _5434_/A2 _7508_/D VDD VDD VSS VSS gf180mcu_fd_sc_mcu7t5v0__nand2_1
XTAP_TAPCELL_ROW_93_1563 VDD VSS gf180mcu_fd_sc_mcu7t5v0__filltie
X_5365_ _7544_/Q _5365_/A2 _7506_/D VDD VDD VSS VSS gf180mcu_fd_sc_mcu7t5v0__nand2_1
X_7104_ _7104_/D _7250_/CLK _7104_/Q VDD VDD VSS VSS gf180mcu_fd_sc_mcu7t5v0__dffq_1
XFILLER_102_836 VDD VDD VSS VSS gf180mcu_fd_sc_mcu7t5v0__fillcap_4
X_4316_ _4946_/A1 _4322_/A2 _4316_/B _6872_/D VDD VDD VSS VSS gf180mcu_fd_sc_mcu7t5v0__oai21_1
X_5296_ _5303_/I0 _7443_/Q _5302_/S _7443_/D VDD VDD VSS VSS gf180mcu_fd_sc_mcu7t5v0__mux2_2
X_7035_ _7035_/D _7060_/CLK _7035_/Q VDD VDD VSS VSS gf180mcu_fd_sc_mcu7t5v0__dffq_1
XFILLER_87_558 VDD VDD VSS VSS gf180mcu_fd_sc_mcu7t5v0__fill_2
X_4247_ _6838_/Q _4252_/A2 _4248_/B VDD VDD VSS VSS gf180mcu_fd_sc_mcu7t5v0__nand2_1
X_4178_ _4221_/A2 _4226_/A3 _6654_/C VDD VDD VSS VSS gf180mcu_fd_sc_mcu7t5v0__nor2_1
XFILLER_67_282 VDD VDD VSS VSS gf180mcu_fd_sc_mcu7t5v0__fill_2
XFILLER_83_764 VDD VDD VSS VSS gf180mcu_fd_sc_mcu7t5v0__fill_1
XTAP_TAPCELL_ROW_2_289 VDD VSS gf180mcu_fd_sc_mcu7t5v0__filltie
XFILLER_43_628 VDD VDD VSS VSS gf180mcu_fd_sc_mcu7t5v0__fill_2
XFILLER_55_488 VDD VDD VSS VSS gf180mcu_fd_sc_mcu7t5v0__fill_2
XFILLER_70_414 VDD VDD VSS VSS gf180mcu_fd_sc_mcu7t5v0__fill_2
X_6819_ _6819_/D _7499_/CLK _6819_/Q VDD VDD VSS VSS gf180mcu_fd_sc_mcu7t5v0__dffq_1
XTAP_TAPCELL_ROW_41_829 VDD VSS gf180mcu_fd_sc_mcu7t5v0__filltie
XFILLER_51_661 VDD VDD VSS VSS gf180mcu_fd_sc_mcu7t5v0__fill_1
XTAP_TAPCELL_ROW_102_1692 VDD VSS gf180mcu_fd_sc_mcu7t5v0__filltie
XTAP_TAPCELL_ROW_102_1681 VDD VSS gf180mcu_fd_sc_mcu7t5v0__filltie
XFILLER_11_558 VDD VDD VSS VSS gf180mcu_fd_sc_mcu7t5v0__fill_2
X_7799_ _7799_/D _7799_/RN _7802_/CLK _7799_/Q VDD VDD VSS VSS gf180mcu_fd_sc_mcu7t5v0__dffrnq_1
XFILLER_7_507 VDD VDD VSS VSS gf180mcu_fd_sc_mcu7t5v0__fill_1
XTAP_TAPCELL_ROW_21_553 VDD VSS gf180mcu_fd_sc_mcu7t5v0__filltie
Xwire449 wire449/I _6191_/B VDD VDD VSS VSS gf180mcu_fd_sc_mcu7t5v0__clkbuf_4
Xwire416 wire416/I wire416/Z VDD VDD VSS VSS gf180mcu_fd_sc_mcu7t5v0__buf_3
XFILLER_3_702 VDD VDD VSS VSS gf180mcu_fd_sc_mcu7t5v0__fillcap_64
XTAP_TAPCELL_ROW_53_1002 VDD VSS gf180mcu_fd_sc_mcu7t5v0__filltie
Xuart_633 racl_error_o[37] VDD VDD VSS VSS gf180mcu_fd_sc_mcu7t5v0__tiel
Xuart_622 racl_error_o[26] VDD VDD VSS VSS gf180mcu_fd_sc_mcu7t5v0__tiel
Xuart_611 racl_error_o[15] VDD VDD VSS VSS gf180mcu_fd_sc_mcu7t5v0__tiel
Xuart_644 tl_o[63] VDD VDD VSS VSS gf180mcu_fd_sc_mcu7t5v0__tiel
Xfanout571 _7612_/RN _7599_/RN VDD VDD VSS VSS gf180mcu_fd_sc_mcu7t5v0__dlyd_1
XFILLER_47_912 VDD VDD VSS VSS gf180mcu_fd_sc_mcu7t5v0__fillcap_64
XFILLER_86_580 VDD VDD VSS VSS gf180mcu_fd_sc_mcu7t5v0__fill_1
XTAP_TAPCELL_ROW_29_664 VDD VSS gf180mcu_fd_sc_mcu7t5v0__filltie
XFILLER_73_274 VDD VDD VSS VSS gf180mcu_fd_sc_mcu7t5v0__fill_1
XFILLER_15_842 VDD VDD VSS VSS gf180mcu_fd_sc_mcu7t5v0__fillcap_64
XFILLER_30_801 VDD VDD VSS VSS gf180mcu_fd_sc_mcu7t5v0__fillcap_4
XFILLER_42_661 VDD VDD VSS VSS gf180mcu_fd_sc_mcu7t5v0__fillcap_4
XTAP_TAPCELL_ROW_64_1153 VDD VSS gf180mcu_fd_sc_mcu7t5v0__filltie
XFILLER_70_981 VDD VDD VSS VSS gf180mcu_fd_sc_mcu7t5v0__fill_1
X_3480_ _3488_/A1 _3480_/A2 _5746_/A2 VDD VDD VSS VSS gf180mcu_fd_sc_mcu7t5v0__nand2_1
XFILLER_97_834 VDD VDD VSS VSS gf180mcu_fd_sc_mcu7t5v0__fillcap_4
X_5150_ _5304_/I0 _7297_/Q _5155_/S _7297_/D VDD VDD VSS VSS gf180mcu_fd_sc_mcu7t5v0__mux2_2
X_5081_ _7255_/Q _5092_/A2 _5082_/B VDD VDD VSS VSS gf180mcu_fd_sc_mcu7t5v0__nand2_1
X_4101_ _4129_/A1 _4110_/A2 _4910_/A2 VDD VDD VSS VSS gf180mcu_fd_sc_mcu7t5v0__nand2_1
X_4032_ _4114_/A1 _4053_/A2 _4602_/A2 VDD VDD VSS VSS gf180mcu_fd_sc_mcu7t5v0__nand2_1
XFILLER_49_282 VDD VDD VSS VSS gf180mcu_fd_sc_mcu7t5v0__fill_2
XFILLER_65_731 VDD VDD VSS VSS gf180mcu_fd_sc_mcu7t5v0__fillcap_4
XFILLER_53_904 VDD VDD VSS VSS gf180mcu_fd_sc_mcu7t5v0__fillcap_4
XFILLER_92_594 VDD VDD VSS VSS gf180mcu_fd_sc_mcu7t5v0__fill_1
X_5983_ _7124_/Q _6233_/A2 _6214_/B _5985_/A1 VDD VDD VSS VSS gf180mcu_fd_sc_mcu7t5v0__oai21_1
X_4934_ _4948_/A1 _4938_/A2 _4934_/B _7181_/D VDD VDD VSS VSS gf180mcu_fd_sc_mcu7t5v0__oai21_1
X_7722_ _7722_/D wire593/Z _7724_/CLK _7722_/Q VDD VDD VSS VSS gf180mcu_fd_sc_mcu7t5v0__dffrnq_1
XANTENNA_23 _7884_/I VDD VDD VSS VSS gf180mcu_fd_sc_mcu7t5v0__antenna
XANTENNA_12 _5630_/A1 VDD VDD VSS VSS gf180mcu_fd_sc_mcu7t5v0__antenna
X_4865_ _7147_/Q _4868_/A2 _4866_/B VDD VDD VSS VSS gf180mcu_fd_sc_mcu7t5v0__nand2_1
X_7653_ _7653_/D _7653_/RN _7794_/CLK _7653_/Q VDD VDD VSS VSS gf180mcu_fd_sc_mcu7t5v0__dffrnq_1
X_7584_ _7584_/D _7589_/RN _7613_/CLK _7584_/Q VDD VDD VSS VSS gf180mcu_fd_sc_mcu7t5v0__dffrnq_1
X_3816_ _7516_/Q _7885_/I _3816_/Z VDD VDD VSS VSS gf180mcu_fd_sc_mcu7t5v0__xor2_1
Xclkbuf_leaf_8_clk_i clkload1/I _7780_/CLK VDD VDD VSS VSS gf180mcu_fd_sc_mcu7t5v0__clkbuf_8
X_6604_ _6585_/Z _6604_/A2 _6604_/B _7717_/D VDD VDD VSS VSS gf180mcu_fd_sc_mcu7t5v0__aoi21_1
X_4796_ _4824_/A1 _4798_/A2 _4796_/B _7112_/D VDD VDD VSS VSS gf180mcu_fd_sc_mcu7t5v0__oai21_1
X_6535_ _6538_/A1 _6535_/A2 _6534_/Z _7687_/D VDD VDD VSS VSS gf180mcu_fd_sc_mcu7t5v0__nor3_1
X_3747_ _7545_/Q _3476_/I _3747_/B _3747_/C _3748_/B2 VDD VDD VSS VSS gf180mcu_fd_sc_mcu7t5v0__oai211_1
X_6466_ _7669_/Q _7535_/Q _6466_/Z VDD VDD VSS VSS gf180mcu_fd_sc_mcu7t5v0__or2_1
X_3678_ _3681_/C _3685_/A2 _3679_/A2 VDD VDD VSS VSS gf180mcu_fd_sc_mcu7t5v0__nand2_1
Xoutput141 _7581_/Q tl_o[25] VDD VDD VSS VSS gf180mcu_fd_sc_mcu7t5v0__dlyd_1
Xoutput130 _5630_/A1 tl_o[14] VDD VDD VSS VSS gf180mcu_fd_sc_mcu7t5v0__dlyd_1
Xoutput152 _7591_/Q tl_o[35] VDD VDD VSS VSS gf180mcu_fd_sc_mcu7t5v0__dlyd_1
X_6397_ _6451_/A2 _6395_/Z _6397_/B _7658_/D VDD VDD VSS VSS gf180mcu_fd_sc_mcu7t5v0__oai21_1
X_5417_ _5584_/S _5417_/A2 _5417_/A3 _5417_/B1 _5417_/B2 _5431_/I0 VDD VDD VSS VSS
+ gf180mcu_fd_sc_mcu7t5v0__oai32_1
Xoutput174 _7611_/Q tl_o[56] VDD VDD VSS VSS gf180mcu_fd_sc_mcu7t5v0__dlyd_1
Xoutput163 _7601_/Q tl_o[45] VDD VDD VSS VSS gf180mcu_fd_sc_mcu7t5v0__dlyd_1
XFILLER_88_812 VDD VDD VSS VSS gf180mcu_fd_sc_mcu7t5v0__fillcap_4
X_5348_ _7642_/Q _7495_/Q _5351_/S _7495_/D VDD VDD VSS VSS gf180mcu_fd_sc_mcu7t5v0__mux2_2
XFILLER_0_716 VDD VDD VSS VSS gf180mcu_fd_sc_mcu7t5v0__fillcap_32
XTAP_TAPCELL_ROW_7_359 VDD VSS gf180mcu_fd_sc_mcu7t5v0__filltie
X_7018_ _7018_/D _7060_/CLK _7018_/Q VDD VDD VSS VSS gf180mcu_fd_sc_mcu7t5v0__dffq_1
XFILLER_29_912 VDD VDD VSS VSS gf180mcu_fd_sc_mcu7t5v0__fillcap_64
X_5279_ wire521/I _7426_/Q _5281_/S _7426_/D VDD VDD VSS VSS gf180mcu_fd_sc_mcu7t5v0__mux2_2
XFILLER_75_539 VDD VDD VSS VSS gf180mcu_fd_sc_mcu7t5v0__fill_1
XFILLER_56_742 VDD VDD VSS VSS gf180mcu_fd_sc_mcu7t5v0__fill_2
XTAP_TAPCELL_ROW_104_1710 VDD VSS gf180mcu_fd_sc_mcu7t5v0__filltie
XFILLER_71_712 VDD VDD VSS VSS gf180mcu_fd_sc_mcu7t5v0__fill_1
XTAP_TAPCELL_ROW_104_1721 VDD VSS gf180mcu_fd_sc_mcu7t5v0__filltie
XTAP_TAPCELL_ROW_26_623 VDD VSS gf180mcu_fd_sc_mcu7t5v0__filltie
XFILLER_43_436 VDD VDD VSS VSS gf180mcu_fd_sc_mcu7t5v0__fill_2
XFILLER_70_244 VDD VDD VSS VSS gf180mcu_fd_sc_mcu7t5v0__fill_1
XFILLER_12_801 VDD VDD VSS VSS gf180mcu_fd_sc_mcu7t5v0__fillcap_4
XFILLER_24_661 VDD VDD VSS VSS gf180mcu_fd_sc_mcu7t5v0__fillcap_4
XFILLER_52_981 VDD VDD VSS VSS gf180mcu_fd_sc_mcu7t5v0__fill_1
XFILLER_71_778 VDD VDD VSS VSS gf180mcu_fd_sc_mcu7t5v0__fill_1
XFILLER_11_333 VDD VDD VSS VSS gf180mcu_fd_sc_mcu7t5v0__fill_2
Xwire268 wire268/I wire268/Z VDD VDD VSS VSS gf180mcu_fd_sc_mcu7t5v0__clkbuf_4
XFILLER_3_510 VDD VDD VSS VSS gf180mcu_fd_sc_mcu7t5v0__fill_2
XTAP_TAPCELL_ROW_115_1872 VDD VSS gf180mcu_fd_sc_mcu7t5v0__filltie
Xload_slew207 _5653_/S _5651_/S VDD VDD VSS VSS gf180mcu_fd_sc_mcu7t5v0__clkbuf_4
Xload_slew229 _5006_/A1 _4964_/A1 VDD VDD VSS VSS gf180mcu_fd_sc_mcu7t5v0__clkbuf_4
XFILLER_38_208 VDD VDD VSS VSS gf180mcu_fd_sc_mcu7t5v0__fill_2
XFILLER_19_422 VDD VDD VSS VSS gf180mcu_fd_sc_mcu7t5v0__fill_1
XFILLER_47_731 VDD VDD VSS VSS gf180mcu_fd_sc_mcu7t5v0__fill_2
X_4650_ _4748_/A1 _4658_/A2 _4650_/B _7039_/D VDD VDD VSS VSS gf180mcu_fd_sc_mcu7t5v0__oai21_1
Xinput10 tl_i[102] input10/Z VDD VDD VSS VSS gf180mcu_fd_sc_mcu7t5v0__dlyd_1
Xinput21 tl_i[12] input21/Z VDD VDD VSS VSS gf180mcu_fd_sc_mcu7t5v0__dlyd_1
X_3601_ input53/Z input51/Z _3601_/Z VDD VDD VSS VSS gf180mcu_fd_sc_mcu7t5v0__xor2_1
X_4581_ _7005_/Q _4588_/A2 _4582_/B VDD VDD VSS VSS gf180mcu_fd_sc_mcu7t5v0__nand2_1
X_6320_ _6320_/A1 _6326_/A2 _6320_/B _7617_/D VDD VDD VSS VSS gf180mcu_fd_sc_mcu7t5v0__oai21_1
Xinput32 tl_i[31] input32/Z VDD VDD VSS VSS gf180mcu_fd_sc_mcu7t5v0__dlyd_1
Xinput43 tl_i[41] input43/Z VDD VDD VSS VSS gf180mcu_fd_sc_mcu7t5v0__dlyd_1
Xinput54 tl_i[51] input54/Z VDD VDD VSS VSS gf180mcu_fd_sc_mcu7t5v0__dlyd_1
Xinput98 tl_i[91] input98/Z VDD VDD VSS VSS gf180mcu_fd_sc_mcu7t5v0__dlyd_1
X_3532_ input16/Z input76/Z input77/Z _3532_/Z VDD VDD VSS VSS gf180mcu_fd_sc_mcu7t5v0__xor3_1
Xinput87 tl_i[81] input87/Z VDD VDD VSS VSS gf180mcu_fd_sc_mcu7t5v0__dlyd_1
Xinput76 tl_i[71] input76/Z VDD VDD VSS VSS gf180mcu_fd_sc_mcu7t5v0__dlyd_1
XTAP_TAPCELL_ROW_77_1333 VDD VSS gf180mcu_fd_sc_mcu7t5v0__filltie
Xinput65 tl_i[61] _3386_/I VDD VDD VSS VSS gf180mcu_fd_sc_mcu7t5v0__dlyd_1
X_6251_ _6251_/A1 _6300_/A2 _6302_/B1 _6250_/Z _7579_/D VDD VDD VSS VSS gf180mcu_fd_sc_mcu7t5v0__aoi22_1
X_3463_ _7599_/Q _6294_/A1 VDD VDD VSS VSS gf180mcu_fd_sc_mcu7t5v0__clkinv_1
XTAP_TAPCELL_ROW_90_1522 VDD VSS gf180mcu_fd_sc_mcu7t5v0__filltie
X_5202_ _5244_/I0 _7349_/Q _5204_/S _7349_/D VDD VDD VSS VSS gf180mcu_fd_sc_mcu7t5v0__mux2_2
X_6182_ _6182_/A1 _6182_/A2 _6182_/B _6183_/B1 VDD VDD VSS VSS gf180mcu_fd_sc_mcu7t5v0__oai21_1
X_5133_ _7281_/Q _5134_/A2 _5134_/B VDD VDD VSS VSS gf180mcu_fd_sc_mcu7t5v0__nand2_1
X_3394_ _7542_/Q _3892_/B2 VDD VDD VSS VSS gf180mcu_fd_sc_mcu7t5v0__clkinv_1
XFILLER_69_344 VDD VDD VSS VSS gf180mcu_fd_sc_mcu7t5v0__fill_1
XTAP_TAPCELL_ROW_4_318 VDD VSS gf180mcu_fd_sc_mcu7t5v0__filltie
XFILLER_96_174 VDD VDD VSS VSS gf180mcu_fd_sc_mcu7t5v0__fill_1
XFILLER_38_731 VDD VDD VSS VSS gf180mcu_fd_sc_mcu7t5v0__fillcap_4
X_5064_ _5078_/A1 _5064_/A2 _5064_/B _7246_/D VDD VDD VSS VSS gf180mcu_fd_sc_mcu7t5v0__oai21_1
X_4015_ _4129_/A1 _4027_/A2 _4532_/A2 VDD VDD VSS VSS gf180mcu_fd_sc_mcu7t5v0__nand2_1
XTAP_TAPCELL_ROW_88_1484 VDD VSS gf180mcu_fd_sc_mcu7t5v0__filltie
XTAP_TAPCELL_ROW_88_1495 VDD VSS gf180mcu_fd_sc_mcu7t5v0__filltie
X_5966_ _6977_/Q _6092_/A2 _6092_/B1 _6984_/Q _7005_/Q _6092_/C2 _5967_/A2 VDD VDD
+ VSS VSS gf180mcu_fd_sc_mcu7t5v0__oai222_1
XFILLER_34_981 VDD VDD VSS VSS gf180mcu_fd_sc_mcu7t5v0__fill_1
XFILLER_80_597 VDD VDD VSS VSS gf180mcu_fd_sc_mcu7t5v0__fill_2
X_5897_ _7207_/Q wire353/Z _6174_/B _5899_/A1 VDD VDD VSS VSS gf180mcu_fd_sc_mcu7t5v0__oai21_1
X_7705_ _7705_/D _7705_/RN _7781_/CLK _7705_/Q VDD VDD VSS VSS gf180mcu_fd_sc_mcu7t5v0__dffrnq_1
X_4917_ _7173_/Q _4924_/A2 _4918_/B VDD VDD VSS VSS gf180mcu_fd_sc_mcu7t5v0__nand2_1
X_7636_ _7636_/D _7708_/RN _7693_/CLK _7636_/Q VDD VDD VSS VSS gf180mcu_fd_sc_mcu7t5v0__dffrnq_1
XTAP_TAPCELL_ROW_51_968 VDD VSS gf180mcu_fd_sc_mcu7t5v0__filltie
XTAP_TAPCELL_ROW_51_979 VDD VSS gf180mcu_fd_sc_mcu7t5v0__filltie
X_4848_ _4918_/A1 _4854_/A2 _4848_/B _7138_/D VDD VDD VSS VSS gf180mcu_fd_sc_mcu7t5v0__oai21_1
XTAP_TAPCELL_ROW_31_692 VDD VSS gf180mcu_fd_sc_mcu7t5v0__filltie
X_7567_ _7567_/D _7780_/RN _7794_/CLK _7567_/Q VDD VDD VSS VSS gf180mcu_fd_sc_mcu7t5v0__dffrnq_1
X_4779_ _7104_/Q _4784_/A2 _4780_/B VDD VDD VSS VSS gf180mcu_fd_sc_mcu7t5v0__nand2_1
X_6518_ _6538_/A1 _6517_/Z _7681_/D VDD VDD VSS VSS gf180mcu_fd_sc_mcu7t5v0__nor2_1
X_7498_ _7498_/D _7504_/CLK _7498_/Q VDD VDD VSS VSS gf180mcu_fd_sc_mcu7t5v0__dffq_1
X_6449_ _7666_/Q _7532_/Q _6449_/A3 _6449_/Z VDD VDD VSS VSS gf180mcu_fd_sc_mcu7t5v0__xor3_1
XFILLER_0_546 VDD VDD VSS VSS gf180mcu_fd_sc_mcu7t5v0__fillcap_32
XFILLER_76_804 VDD VDD VSS VSS gf180mcu_fd_sc_mcu7t5v0__fill_1
XFILLER_56_550 VDD VDD VSS VSS gf180mcu_fd_sc_mcu7t5v0__fill_2
XFILLER_113_62 VDD VDD VSS VSS gf180mcu_fd_sc_mcu7t5v0__fill_1
XFILLER_44_734 VDD VDD VSS VSS gf180mcu_fd_sc_mcu7t5v0__fill_1
XTAP_TAPCELL_ROW_61_1112 VDD VSS gf180mcu_fd_sc_mcu7t5v0__filltie
XTAP_TAPCELL_ROW_117_1901 VDD VSS gf180mcu_fd_sc_mcu7t5v0__filltie
XTAP_TAPCELL_ROW_59_1085 VDD VSS gf180mcu_fd_sc_mcu7t5v0__filltie
XFILLER_79_620 VDD VDD VSS VSS gf180mcu_fd_sc_mcu7t5v0__fillcap_8
XTAP_TAPCELL_ROW_72_1263 VDD VSS gf180mcu_fd_sc_mcu7t5v0__filltie
XFILLER_78_174 VDD VDD VSS VSS gf180mcu_fd_sc_mcu7t5v0__fill_1
XFILLER_66_314 VDD VDD VSS VSS gf180mcu_fd_sc_mcu7t5v0__fill_1
XFILLER_82_807 VDD VDD VSS VSS gf180mcu_fd_sc_mcu7t5v0__fillcap_4
XFILLER_94_689 VDD VDD VSS VSS gf180mcu_fd_sc_mcu7t5v0__fill_2
X_5820_ _7572_/Q _6303_/S _5883_/B _5820_/B2 _5821_/I VDD VDD VSS VSS gf180mcu_fd_sc_mcu7t5v0__oai22_1
Xclkbuf_leaf_73_clk_i clkbuf_3_1__f_clk_i/Z _7748_/CLK VDD VDD VSS VSS gf180mcu_fd_sc_mcu7t5v0__clkbuf_8
XFILLER_50_704 VDD VDD VSS VSS gf180mcu_fd_sc_mcu7t5v0__fill_1
XFILLER_50_726 VDD VDD VSS VSS gf180mcu_fd_sc_mcu7t5v0__fill_1
X_5751_ _7093_/Q _6097_/A2 _6191_/B _5758_/A1 VDD VDD VSS VSS gf180mcu_fd_sc_mcu7t5v0__oai21_1
XFILLER_16_981 VDD VDD VSS VSS gf180mcu_fd_sc_mcu7t5v0__fill_1
XTAP_TAPCELL_ROW_17_497 VDD VSS gf180mcu_fd_sc_mcu7t5v0__filltie
XFILLER_50_737 VDD VDD VSS VSS gf180mcu_fd_sc_mcu7t5v0__fill_1
XFILLER_62_597 VDD VDD VSS VSS gf180mcu_fd_sc_mcu7t5v0__fillcap_4
X_4702_ _4786_/A1 _4714_/A2 _4702_/B _7065_/D VDD VDD VSS VSS gf180mcu_fd_sc_mcu7t5v0__oai21_1
X_7421_ _7421_/D _7451_/CLK _7421_/Q VDD VDD VSS VSS gf180mcu_fd_sc_mcu7t5v0__dffq_1
X_5682_ _7556_/Q input37/Z _5687_/S _7556_/D VDD VDD VSS VSS gf180mcu_fd_sc_mcu7t5v0__mux2_2
X_4633_ _7031_/Q _4644_/A2 _4634_/B VDD VDD VSS VSS gf180mcu_fd_sc_mcu7t5v0__nand2_1
Xclkbuf_leaf_88_clk_i clkload0/I _7822_/CLK VDD VDD VSS VSS gf180mcu_fd_sc_mcu7t5v0__clkbuf_8
X_4564_ _5124_/A1 _4574_/A2 _4564_/B _6996_/D VDD VDD VSS VSS gf180mcu_fd_sc_mcu7t5v0__oai21_1
X_7352_ _7352_/D _7804_/CLK _7352_/Q VDD VDD VSS VSS gf180mcu_fd_sc_mcu7t5v0__dffq_1
XFILLER_104_706 VDD VDD VSS VSS gf180mcu_fd_sc_mcu7t5v0__fillcap_16
X_6303_ _7604_/Q _6303_/I1 _6303_/S _7604_/D VDD VDD VSS VSS gf180mcu_fd_sc_mcu7t5v0__mux2_2
X_7283_ _7283_/D _7482_/CLK _7283_/Q VDD VDD VSS VSS gf180mcu_fd_sc_mcu7t5v0__dffq_1
X_3515_ _7770_/D _7767_/D _3903_/A1 VDD VDD VSS VSS gf180mcu_fd_sc_mcu7t5v0__nor2_1
XFILLER_116_566 VDD VDD VSS VSS gf180mcu_fd_sc_mcu7t5v0__fillcap_4
X_4495_ _6962_/Q _4504_/A2 _4496_/B VDD VDD VSS VSS gf180mcu_fd_sc_mcu7t5v0__nand2_1
X_6234_ _6234_/A1 _6234_/A2 _6244_/A1 VDD VDD VSS VSS gf180mcu_fd_sc_mcu7t5v0__nor2_1
Xclkbuf_leaf_11_clk_i clkbuf_3_1__f_clk_i/Z _7793_/CLK VDD VDD VSS VSS gf180mcu_fd_sc_mcu7t5v0__clkbuf_8
X_3446_ _7597_/Q _6290_/A1 VDD VDD VSS VSS gf180mcu_fd_sc_mcu7t5v0__clkinv_1
XFILLER_103_238 VDD VDD VSS VSS gf180mcu_fd_sc_mcu7t5v0__fill_2
X_6165_ _6910_/Q _6229_/A2 _6228_/A2 _6903_/Q _6896_/Q _6228_/B1 _6166_/A2 VDD VDD
+ VSS VSS gf180mcu_fd_sc_mcu7t5v0__oai222_1
X_3377_ _7886_/I _5744_/A1 VDD VDD VSS VSS gf180mcu_fd_sc_mcu7t5v0__clkinv_1
X_6096_ _6096_/A1 _6096_/A2 _6124_/I0 VDD VDD VSS VSS gf180mcu_fd_sc_mcu7t5v0__nand2_1
Xclkbuf_leaf_26_clk_i clkload2/I _7668_/CLK VDD VDD VSS VSS gf180mcu_fd_sc_mcu7t5v0__clkbuf_8
X_5116_ _5130_/A1 _5120_/A2 _5116_/B _7272_/D VDD VDD VSS VSS gf180mcu_fd_sc_mcu7t5v0__oai21_1
XFILLER_97_483 VDD VDD VSS VSS gf180mcu_fd_sc_mcu7t5v0__fill_2
Xload_slew582 _7711_/RN _7660_/RN VDD VDD VSS VSS gf180mcu_fd_sc_mcu7t5v0__buf_3
Xload_slew560 _7742_/RN _7740_/RN VDD VDD VSS VSS gf180mcu_fd_sc_mcu7t5v0__buf_4
X_5047_ _7238_/Q _5050_/A2 _5048_/B VDD VDD VSS VSS gf180mcu_fd_sc_mcu7t5v0__nand2_1
XFILLER_38_594 VDD VDD VSS VSS gf180mcu_fd_sc_mcu7t5v0__fill_1
X_6998_ _6998_/D _7687_/CLK _6998_/Q VDD VDD VSS VSS gf180mcu_fd_sc_mcu7t5v0__dffq_1
XTAP_TAPCELL_ROW_36_762 VDD VSS gf180mcu_fd_sc_mcu7t5v0__filltie
X_5949_ _6837_/Q _6212_/B1 _6207_/B1 _6914_/Q _6084_/C _5950_/A2 VDD VDD VSS VSS gf180mcu_fd_sc_mcu7t5v0__oai221_1
X_7619_ _7619_/D _7703_/RN _7703_/CLK _7619_/Q VDD VDD VSS VSS gf180mcu_fd_sc_mcu7t5v0__dffrnq_1
XFILLER_107_500 VDD VDD VSS VSS gf180mcu_fd_sc_mcu7t5v0__fill_1
XTAP_TAPCELL_ROW_112_1820 VDD VSS gf180mcu_fd_sc_mcu7t5v0__filltie
XTAP_TAPCELL_ROW_112_1831 VDD VSS gf180mcu_fd_sc_mcu7t5v0__filltie
XFILLER_0_310 VDD VDD VSS VSS gf180mcu_fd_sc_mcu7t5v0__fill_1
XFILLER_16_255 VDD VDD VSS VSS gf180mcu_fd_sc_mcu7t5v0__fill_2
XFILLER_72_873 VDD VDD VSS VSS gf180mcu_fd_sc_mcu7t5v0__fill_2
XFILLER_32_737 VDD VDD VSS VSS gf180mcu_fd_sc_mcu7t5v0__fillcap_64
XFILLER_44_597 VDD VDD VSS VSS gf180mcu_fd_sc_mcu7t5v0__fill_2
XTAP_TAPCELL_ROW_14_456 VDD VSS gf180mcu_fd_sc_mcu7t5v0__filltie
XFILLER_8_476 VDD VDD VSS VSS gf180mcu_fd_sc_mcu7t5v0__fill_1
X_4280_ _4336_/A1 _4280_/A2 _4280_/B _6854_/D VDD VDD VSS VSS gf180mcu_fd_sc_mcu7t5v0__oai21_1
XFILLER_79_472 VDD VDD VSS VSS gf180mcu_fd_sc_mcu7t5v0__fill_2
XFILLER_95_954 VDD VDD VSS VSS gf180mcu_fd_sc_mcu7t5v0__fillcap_16
X_6921_ _6921_/D _7259_/CLK _6921_/Q VDD VDD VSS VSS gf180mcu_fd_sc_mcu7t5v0__dffq_1
X_6852_ _6852_/D _7279_/CLK _6852_/Q VDD VDD VSS VSS gf180mcu_fd_sc_mcu7t5v0__dffq_1
XTAP_TAPCELL_ROW_85_1454 VDD VSS gf180mcu_fd_sc_mcu7t5v0__filltie
XTAP_TAPCELL_ROW_85_1443 VDD VSS gf180mcu_fd_sc_mcu7t5v0__filltie
XFILLER_35_542 VDD VDD VSS VSS gf180mcu_fd_sc_mcu7t5v0__fillcap_16
X_5803_ _6995_/Q _6091_/A2 _6089_/B1 _6981_/Q _6090_/C _5804_/A2 VDD VDD VSS VSS gf180mcu_fd_sc_mcu7t5v0__oai221_1
XTAP_TAPCELL_ROW_33_721 VDD VSS gf180mcu_fd_sc_mcu7t5v0__filltie
X_3995_ _4143_/A1 _4434_/A2 _3995_/B _6751_/D VDD VDD VSS VSS gf180mcu_fd_sc_mcu7t5v0__oai21_1
X_6783_ _6783_/D _7453_/CLK _6783_/Q VDD VDD VSS VSS gf180mcu_fd_sc_mcu7t5v0__dffq_1
XFILLER_50_556 VDD VDD VSS VSS gf180mcu_fd_sc_mcu7t5v0__fillcap_4
X_5734_ input36/Z _6373_/S _6483_/B _7566_/Q _5735_/B VDD VDD VSS VSS gf180mcu_fd_sc_mcu7t5v0__aoi211_1
X_5665_ _5665_/A1 _7783_/D _5665_/B _7545_/D VDD VDD VSS VSS gf180mcu_fd_sc_mcu7t5v0__oai21_1
X_4616_ wire291/Z _4616_/A2 _4616_/B _7022_/D VDD VDD VSS VSS gf180mcu_fd_sc_mcu7t5v0__oai21_1
X_7404_ _7404_/D _7418_/CLK _7404_/Q VDD VDD VSS VSS gf180mcu_fd_sc_mcu7t5v0__dffq_1
XFILLER_117_842 VDD VDD VSS VSS gf180mcu_fd_sc_mcu7t5v0__fillcap_64
XPHY_EDGE_ROW_111_Right_111 VDD VSS gf180mcu_fd_sc_mcu7t5v0__endcap
X_7335_ _7335_/D clkload9/I _7335_/Q VDD VDD VSS VSS gf180mcu_fd_sc_mcu7t5v0__dffq_1
X_5596_ _6820_/Q _5596_/A2 _5596_/B1 _6818_/Q _5598_/A2 VDD VDD VSS VSS gf180mcu_fd_sc_mcu7t5v0__oai22_1
X_4547_ _6988_/Q _4560_/A2 _4548_/B VDD VDD VSS VSS gf180mcu_fd_sc_mcu7t5v0__nand2_1
X_4478_ _4506_/A1 _4490_/A2 _4478_/B _6953_/D VDD VDD VSS VSS gf180mcu_fd_sc_mcu7t5v0__oai21_1
X_7266_ _7266_/D _7266_/CLK _7266_/Q VDD VDD VSS VSS gf180mcu_fd_sc_mcu7t5v0__dffq_1
X_6217_ _6217_/A1 _6217_/A2 _6217_/B _6218_/B2 VDD VDD VSS VSS gf180mcu_fd_sc_mcu7t5v0__oai21_1
X_3429_ _7537_/Q _5655_/A1 VDD VDD VSS VSS gf180mcu_fd_sc_mcu7t5v0__clkinv_1
X_7197_ _7197_/D _7218_/CLK _7197_/Q VDD VDD VSS VSS gf180mcu_fd_sc_mcu7t5v0__dffq_1
XFILLER_86_943 VDD VDD VSS VSS gf180mcu_fd_sc_mcu7t5v0__fill_2
X_6148_ _7127_/Q _6214_/A2 _6174_/A2 _7120_/Q _7106_/Q _6175_/A2 _6149_/A2 VDD VDD
+ VSS VSS gf180mcu_fd_sc_mcu7t5v0__oai222_1
Xload_slew390 _4012_/A1 _4123_/A1 VDD VDD VSS VSS gf180mcu_fd_sc_mcu7t5v0__buf_4
X_6079_ _6079_/I _6080_/C VDD VDD VSS VSS gf180mcu_fd_sc_mcu7t5v0__clkinv_1
XFILLER_100_786 VDD VDD VSS VSS gf180mcu_fd_sc_mcu7t5v0__fillcap_4
XFILLER_100_764 VDD VDD VSS VSS gf180mcu_fd_sc_mcu7t5v0__fill_1
XFILLER_26_564 VDD VDD VSS VSS gf180mcu_fd_sc_mcu7t5v0__fillcap_16
XFILLER_14_737 VDD VDD VSS VSS gf180mcu_fd_sc_mcu7t5v0__fillcap_64
XFILLER_13_203 VDD VDD VSS VSS gf180mcu_fd_sc_mcu7t5v0__fill_1
XFILLER_26_597 VDD VDD VSS VSS gf180mcu_fd_sc_mcu7t5v0__fillcap_64
XTAP_TAPCELL_ROW_11_415 VDD VSS gf180mcu_fd_sc_mcu7t5v0__filltie
XFILLER_6_947 VDD VDD VSS VSS gf180mcu_fd_sc_mcu7t5v0__fillcap_32
XTAP_TAPCELL_ROW_56_1044 VDD VSS gf180mcu_fd_sc_mcu7t5v0__filltie
XFILLER_103_580 VDD VDD VSS VSS gf180mcu_fd_sc_mcu7t5v0__fill_1
XFILLER_0_140 VDD VDD VSS VSS gf180mcu_fd_sc_mcu7t5v0__fill_1
XFILLER_1_696 VDD VDD VSS VSS gf180mcu_fd_sc_mcu7t5v0__fillcap_4
XFILLER_92_913 VDD VDD VSS VSS gf180mcu_fd_sc_mcu7t5v0__fill_2
XFILLER_36_317 VDD VDD VSS VSS gf180mcu_fd_sc_mcu7t5v0__fill_2
XTAP_TAPCELL_ROW_19_526 VDD VSS gf180mcu_fd_sc_mcu7t5v0__filltie
XFILLER_92_979 VDD VDD VSS VSS gf180mcu_fd_sc_mcu7t5v0__fill_2
XFILLER_32_523 VDD VDD VSS VSS gf180mcu_fd_sc_mcu7t5v0__fill_2
XTAP_TAPCELL_ROW_67_1195 VDD VSS gf180mcu_fd_sc_mcu7t5v0__filltie
X_3780_ _7790_/D _5655_/A1 _7789_/D _3781_/B VDD VDD VSS VSS gf180mcu_fd_sc_mcu7t5v0__oai21_1
XTAP_TAPCELL_ROW_80_1384 VDD VSS gf180mcu_fd_sc_mcu7t5v0__filltie
XTAP_TAPCELL_ROW_80_1373 VDD VSS gf180mcu_fd_sc_mcu7t5v0__filltie
X_5450_ _7424_/Q _5600_/A2 _5599_/B _5457_/A1 VDD VDD VSS VSS gf180mcu_fd_sc_mcu7t5v0__oai21_1
X_4401_ _6915_/Q _4406_/A2 _4402_/B VDD VDD VSS VSS gf180mcu_fd_sc_mcu7t5v0__nand2_1
X_5381_ _5381_/A1 _5381_/A2 _5385_/A2 VDD VDD VSS VSS gf180mcu_fd_sc_mcu7t5v0__nor2_1
XFILLER_5_40 VDD VDD VSS VSS gf180mcu_fd_sc_mcu7t5v0__fill_1
X_4332_ _5130_/A1 _4336_/A2 _4332_/B _6880_/D VDD VDD VSS VSS gf180mcu_fd_sc_mcu7t5v0__oai21_1
X_7120_ _7120_/D _7217_/CLK _7120_/Q VDD VDD VSS VSS gf180mcu_fd_sc_mcu7t5v0__dffq_1
X_7051_ _7051_/D _7055_/CLK _7051_/Q VDD VDD VSS VSS gf180mcu_fd_sc_mcu7t5v0__dffq_1
X_4263_ _6846_/Q _4266_/A2 _4264_/B VDD VDD VSS VSS gf180mcu_fd_sc_mcu7t5v0__nand2_1
X_6002_ _7794_/D _5625_/C _5809_/I _6005_/A1 VDD VDD VSS VSS gf180mcu_fd_sc_mcu7t5v0__nand3_1
X_4194_ _4235_/A1 _4200_/A2 _5225_/S VDD VDD VSS VSS gf180mcu_fd_sc_mcu7t5v0__nand2_1
XFILLER_28_807 VDD VDD VSS VSS gf180mcu_fd_sc_mcu7t5v0__fillcap_64
X_6904_ _6904_/D _7008_/CLK _6904_/Q VDD VDD VSS VSS gf180mcu_fd_sc_mcu7t5v0__dffq_1
X_7884_ _7884_/I _7884_/Z VDD VDD VSS VSS gf180mcu_fd_sc_mcu7t5v0__buf_1
X_6835_ _6835_/D _6915_/CLK _6835_/Q VDD VDD VSS VSS gf180mcu_fd_sc_mcu7t5v0__dffq_1
X_3978_ _3999_/A2 _4150_/A2 _4364_/A2 VDD VDD VSS VSS gf180mcu_fd_sc_mcu7t5v0__nand2_1
X_6766_ _6766_/D _7097_/CLK _6766_/Q VDD VDD VSS VSS gf180mcu_fd_sc_mcu7t5v0__dffq_1
X_5717_ _6340_/A1 _7687_/Q _7614_/Q _5717_/C _5720_/A2 VDD VDD VSS VSS gf180mcu_fd_sc_mcu7t5v0__oai211_1
XFILLER_109_628 VDD VDD VSS VSS gf180mcu_fd_sc_mcu7t5v0__fill_2
XTAP_TAPCELL_ROW_98_1634 VDD VSS gf180mcu_fd_sc_mcu7t5v0__filltie
X_6697_ _6697_/A1 _6716_/A2 _6714_/B1 VDD VDD VSS VSS gf180mcu_fd_sc_mcu7t5v0__nor2_1
X_5648_ _7531_/Q input58/Z _5651_/S _7531_/D VDD VDD VSS VSS gf180mcu_fd_sc_mcu7t5v0__mux2_2
XFILLER_117_661 VDD VDD VSS VSS gf180mcu_fd_sc_mcu7t5v0__fill_2
XFILLER_3_906 VDD VDD VSS VSS gf180mcu_fd_sc_mcu7t5v0__fillcap_4
X_5579_ _7421_/Q _5579_/A2 _5373_/Z _7407_/Q _5581_/A2 VDD VDD VSS VSS gf180mcu_fd_sc_mcu7t5v0__oai22_1
X_7318_ _7318_/D _7418_/CLK _7318_/Q VDD VDD VSS VSS gf180mcu_fd_sc_mcu7t5v0__dffq_1
X_7249_ _7249_/D _7251_/CLK _7249_/Q VDD VDD VSS VSS gf180mcu_fd_sc_mcu7t5v0__dffq_1
XFILLER_46_626 VDD VDD VSS VSS gf180mcu_fd_sc_mcu7t5v0__fillcap_4
XFILLER_59_976 VDD VDD VSS VSS gf180mcu_fd_sc_mcu7t5v0__fillcap_4
XFILLER_100_594 VDD VDD VSS VSS gf180mcu_fd_sc_mcu7t5v0__fill_1
XTAP_TAPCELL_ROW_107_1752 VDD VSS gf180mcu_fd_sc_mcu7t5v0__filltie
XFILLER_74_979 VDD VDD VSS VSS gf180mcu_fd_sc_mcu7t5v0__fill_2
XTAP_TAPCELL_ROW_107_1763 VDD VSS gf180mcu_fd_sc_mcu7t5v0__filltie
XFILLER_14_556 VDD VDD VSS VSS gf180mcu_fd_sc_mcu7t5v0__fillcap_32
XTAP_TAPCELL_ROW_24_595 VDD VSS gf180mcu_fd_sc_mcu7t5v0__filltie
XFILLER_108_672 VDD VDD VSS VSS gf180mcu_fd_sc_mcu7t5v0__fill_1
XFILLER_5_243 VDD VDD VSS VSS gf180mcu_fd_sc_mcu7t5v0__fill_1
XFILLER_68_206 VDD VDD VSS VSS gf180mcu_fd_sc_mcu7t5v0__fill_2
Xinput8 tl_i[100] input8/Z VDD VDD VSS VSS gf180mcu_fd_sc_mcu7t5v0__dlyd_1
XFILLER_83_209 VDD VDD VSS VSS gf180mcu_fd_sc_mcu7t5v0__fill_1
XFILLER_37_626 VDD VDD VSS VSS gf180mcu_fd_sc_mcu7t5v0__fillcap_4
XTAP_TAPCELL_ROW_69_1224 VDD VSS gf180mcu_fd_sc_mcu7t5v0__filltie
XFILLER_91_297 VDD VDD VSS VSS gf180mcu_fd_sc_mcu7t5v0__fill_1
XTAP_TAPCELL_ROW_82_1413 VDD VSS gf180mcu_fd_sc_mcu7t5v0__filltie
XTAP_TAPCELL_ROW_82_1402 VDD VSS gf180mcu_fd_sc_mcu7t5v0__filltie
XFILLER_45_670 VDD VDD VSS VSS gf180mcu_fd_sc_mcu7t5v0__fillcap_4
X_4950_ _4950_/A1 _4952_/A2 _4950_/B _7189_/D VDD VDD VSS VSS gf180mcu_fd_sc_mcu7t5v0__oai21_1
X_3901_ _3901_/A1 _3901_/A2 _3901_/B _7824_/D VDD VDD VSS VSS gf180mcu_fd_sc_mcu7t5v0__aoi21_1
X_4881_ _7155_/Q _4882_/A2 _4882_/B VDD VDD VSS VSS gf180mcu_fd_sc_mcu7t5v0__nand2_1
X_3832_ _6130_/A1 _6007_/A1 _3831_/Z _3832_/Z VDD VDD VSS VSS gf180mcu_fd_sc_mcu7t5v0__xor3_1
X_6620_ _6621_/B _6619_/Z _7723_/D VDD VDD VSS VSS gf180mcu_fd_sc_mcu7t5v0__nor2_1
XTAP_TAPCELL_ROW_43_860 VDD VSS gf180mcu_fd_sc_mcu7t5v0__filltie
XFILLER_60_651 VDD VDD VSS VSS gf180mcu_fd_sc_mcu7t5v0__fillcap_4
X_6551_ _7693_/Q _6549_/Z _6553_/A2 VDD VDD VSS VSS gf180mcu_fd_sc_mcu7t5v0__nor2_1
X_5502_ _7370_/Q wire420/Z _5549_/C _5504_/A1 VDD VDD VSS VSS gf180mcu_fd_sc_mcu7t5v0__oai21_1
X_3763_ _3712_/Z _3713_/Z _3715_/Z _3763_/A4 _3763_/Z VDD VDD VSS VSS gf180mcu_fd_sc_mcu7t5v0__and4_1
X_6482_ _7797_/Q _3484_/I _6482_/B _7614_/Q _6483_/C VDD VDD VSS VSS gf180mcu_fd_sc_mcu7t5v0__oai211_1
X_3694_ _3677_/S _3683_/C _3694_/Z VDD VDD VSS VSS gf180mcu_fd_sc_mcu7t5v0__or2_1
X_5433_ _7509_/Q _6732_/A1 _6728_/B _5433_/C _5434_/A2 VDD VDD VSS VSS gf180mcu_fd_sc_mcu7t5v0__oai211_1
X_5364_ _7507_/Q _5359_/Z _6733_/A4 _7506_/Q _5365_/A2 VDD VDD VSS VSS gf180mcu_fd_sc_mcu7t5v0__aoi22_1
XFILLER_114_664 VDD VDD VSS VSS gf180mcu_fd_sc_mcu7t5v0__fill_1
X_4315_ _6872_/Q _4322_/A2 _4316_/B VDD VDD VSS VSS gf180mcu_fd_sc_mcu7t5v0__nand2_1
XTAP_TAPCELL_ROW_93_1564 VDD VSS gf180mcu_fd_sc_mcu7t5v0__filltie
X_7103_ _7103_/D _7217_/CLK _7103_/Q VDD VDD VSS VSS gf180mcu_fd_sc_mcu7t5v0__dffq_1
X_5295_ _5344_/I0 _7442_/Q _5295_/S _7442_/D VDD VDD VSS VSS gf180mcu_fd_sc_mcu7t5v0__mux2_2
X_7034_ _7034_/D _7062_/CLK _7034_/Q VDD VDD VSS VSS gf180mcu_fd_sc_mcu7t5v0__dffq_1
X_4246_ _5100_/A1 _4252_/A2 _4246_/B _6837_/D VDD VDD VSS VSS gf180mcu_fd_sc_mcu7t5v0__oai21_1
X_4177_ _4238_/I0 _6807_/Q _5176_/S _6807_/D VDD VDD VSS VSS gf180mcu_fd_sc_mcu7t5v0__mux2_2
XFILLER_43_607 VDD VDD VSS VSS gf180mcu_fd_sc_mcu7t5v0__fillcap_8
XFILLER_56_979 VDD VDD VSS VSS gf180mcu_fd_sc_mcu7t5v0__fill_2
X_6818_ _6818_/D _7499_/CLK _6818_/Q VDD VDD VSS VSS gf180mcu_fd_sc_mcu7t5v0__dffq_1
XTAP_TAPCELL_ROW_102_1682 VDD VSS gf180mcu_fd_sc_mcu7t5v0__filltie
X_7798_ _7798_/D _7798_/RN _7802_/CLK _7798_/Q VDD VDD VSS VSS gf180mcu_fd_sc_mcu7t5v0__dffrnq_1
XTAP_TAPCELL_ROW_102_1693 VDD VSS gf180mcu_fd_sc_mcu7t5v0__filltie
X_6749_ _6749_/D _7070_/CLK _6749_/Q VDD VDD VSS VSS gf180mcu_fd_sc_mcu7t5v0__dffq_1
XTAP_TAPCELL_ROW_21_554 VDD VSS gf180mcu_fd_sc_mcu7t5v0__filltie
Xwire428 wire428/I wire428/Z VDD VDD VSS VSS gf180mcu_fd_sc_mcu7t5v0__clkbuf_4
XFILLER_118_970 VDD VDD VSS VSS gf180mcu_fd_sc_mcu7t5v0__fillcap_8
XFILLER_2_213 VDD VDD VSS VSS gf180mcu_fd_sc_mcu7t5v0__fill_1
XFILLER_4_4 VDD VDD VSS VSS gf180mcu_fd_sc_mcu7t5v0__fill_1
XTAP_TAPCELL_ROW_53_1003 VDD VSS gf180mcu_fd_sc_mcu7t5v0__filltie
Xuart_623 racl_error_o[27] VDD VDD VSS VSS gf180mcu_fd_sc_mcu7t5v0__tiel
Xuart_601 racl_error_o[1] VDD VDD VSS VSS gf180mcu_fd_sc_mcu7t5v0__tiel
Xuart_612 racl_error_o[16] VDD VDD VSS VSS gf180mcu_fd_sc_mcu7t5v0__tiel
Xuart_645 tl_o[64] VDD VDD VSS VSS gf180mcu_fd_sc_mcu7t5v0__tiel
Xuart_634 racl_error_o[38] VDD VDD VSS VSS gf180mcu_fd_sc_mcu7t5v0__tiel
Xfanout550 _7653_/RN _7760_/RN VDD VDD VSS VSS gf180mcu_fd_sc_mcu7t5v0__dlyd_1
Xfanout583 _7560_/RN _7601_/RN VDD VDD VSS VSS gf180mcu_fd_sc_mcu7t5v0__dlyd_1
Xfanout561 wire565/I _7791_/RN VDD VDD VSS VSS gf180mcu_fd_sc_mcu7t5v0__dlyd_1
XFILLER_74_732 VDD VDD VSS VSS gf180mcu_fd_sc_mcu7t5v0__fill_2
XFILLER_19_626 VDD VDD VSS VSS gf180mcu_fd_sc_mcu7t5v0__fillcap_4
XTAP_TAPCELL_ROW_29_665 VDD VSS gf180mcu_fd_sc_mcu7t5v0__filltie
XFILLER_62_938 VDD VDD VSS VSS gf180mcu_fd_sc_mcu7t5v0__fillcap_4
XTAP_TAPCELL_ROW_64_1154 VDD VSS gf180mcu_fd_sc_mcu7t5v0__filltie
XFILLER_6_585 VDD VDD VSS VSS gf180mcu_fd_sc_mcu7t5v0__fillcap_8
X_5080_ _5080_/A1 _5092_/A2 _5080_/B _7254_/D VDD VDD VSS VSS gf180mcu_fd_sc_mcu7t5v0__oai21_1
XTAP_TAPCELL_ROW_9_390 VDD VSS gf180mcu_fd_sc_mcu7t5v0__filltie
X_4100_ _4112_/A1 _4896_/A2 _4100_/B _6784_/D VDD VDD VSS VSS gf180mcu_fd_sc_mcu7t5v0__oai21_1
XFILLER_69_559 VDD VDD VSS VSS gf180mcu_fd_sc_mcu7t5v0__fill_1
XFILLER_84_529 VDD VDD VSS VSS gf180mcu_fd_sc_mcu7t5v0__fill_1
X_4031_ _4085_/A1 _4059_/A2 _4053_/A2 VDD VDD VSS VSS gf180mcu_fd_sc_mcu7t5v0__nor2_1
XFILLER_1_290 VDD VDD VSS VSS gf180mcu_fd_sc_mcu7t5v0__fill_2
XTAP_TAPCELL_ROW_48_930 VDD VSS gf180mcu_fd_sc_mcu7t5v0__filltie
XFILLER_38_979 VDD VDD VSS VSS gf180mcu_fd_sc_mcu7t5v0__fill_2
X_5982_ _5982_/A1 _5982_/A2 _6122_/C _5997_/B2 VDD VDD VSS VSS gf180mcu_fd_sc_mcu7t5v0__oai21_1
XFILLER_37_489 VDD VDD VSS VSS gf180mcu_fd_sc_mcu7t5v0__fill_1
X_4933_ _7181_/Q _4938_/A2 _4934_/B VDD VDD VSS VSS gf180mcu_fd_sc_mcu7t5v0__nand2_1
X_7721_ _7721_/D wire593/Z _7724_/CLK _7721_/Q VDD VDD VSS VSS gf180mcu_fd_sc_mcu7t5v0__dffrnq_1
XANTENNA_13 _7662_/Q VDD VDD VSS VSS gf180mcu_fd_sc_mcu7t5v0__antenna
X_4864_ _5102_/A1 _4868_/A2 _4864_/B _7146_/D VDD VDD VSS VSS gf180mcu_fd_sc_mcu7t5v0__oai21_1
XFILLER_32_172 VDD VDD VSS VSS gf180mcu_fd_sc_mcu7t5v0__fill_2
X_7652_ _7652_/D _7652_/RN _7790_/CLK _7652_/Q VDD VDD VSS VSS gf180mcu_fd_sc_mcu7t5v0__dffrnq_1
X_7583_ _7583_/D _7710_/RN _7613_/CLK _7583_/Q VDD VDD VSS VSS gf180mcu_fd_sc_mcu7t5v0__dffrnq_1
X_3815_ _3901_/A1 _3815_/A2 _7772_/D VDD VDD VSS VSS gf180mcu_fd_sc_mcu7t5v0__nand2_1
X_6603_ _6603_/A1 _6603_/A2 _6604_/A2 VDD VDD VSS VSS gf180mcu_fd_sc_mcu7t5v0__nand2_1
X_4795_ _7112_/Q _4798_/A2 _4796_/B VDD VDD VSS VSS gf180mcu_fd_sc_mcu7t5v0__nand2_1
X_6534_ _7685_/Q _7686_/Q _7687_/Q _6526_/Z _6534_/Z VDD VDD VSS VSS gf180mcu_fd_sc_mcu7t5v0__and4_1
X_3746_ _7799_/D _3750_/B1 _3751_/B1 VDD VDD VSS VSS gf180mcu_fd_sc_mcu7t5v0__nand2_1
X_6465_ _7669_/Q _7535_/Q _6473_/B VDD VDD VSS VSS gf180mcu_fd_sc_mcu7t5v0__and2_1
X_3677_ input67/Z input68/Z _3677_/S _3677_/Z VDD VDD VSS VSS gf180mcu_fd_sc_mcu7t5v0__mux2_2
X_5416_ _5508_/C _5416_/A2 _5416_/A3 _5417_/A3 VDD VDD VSS VSS gf180mcu_fd_sc_mcu7t5v0__nor3_1
Xoutput142 _7582_/Q tl_o[26] VDD VDD VSS VSS gf180mcu_fd_sc_mcu7t5v0__dlyd_1
Xoutput131 _7572_/Q tl_o[16] VDD VDD VSS VSS gf180mcu_fd_sc_mcu7t5v0__dlyd_1
X_6396_ _7658_/Q _6451_/A2 _6397_/B VDD VDD VSS VSS gf180mcu_fd_sc_mcu7t5v0__nand2_1
Xoutput120 _7795_/Q lsio_trigger_o VDD VDD VSS VSS gf180mcu_fd_sc_mcu7t5v0__dlyd_1
Xoutput164 _7602_/Q tl_o[46] VDD VDD VSS VSS gf180mcu_fd_sc_mcu7t5v0__dlyd_1
Xoutput153 _7592_/Q tl_o[36] VDD VDD VSS VSS gf180mcu_fd_sc_mcu7t5v0__dlyd_1
Xoutput175 _7612_/Q tl_o[57] VDD VDD VSS VSS gf180mcu_fd_sc_mcu7t5v0__dlyd_1
XFILLER_88_824 VDD VDD VSS VSS gf180mcu_fd_sc_mcu7t5v0__fillcap_4
X_5347_ _5347_/I0 _7494_/Q _5351_/S _7494_/D VDD VDD VSS VSS gf180mcu_fd_sc_mcu7t5v0__mux2_2
XFILLER_102_634 VDD VDD VSS VSS gf180mcu_fd_sc_mcu7t5v0__fill_2
X_5278_ wire525/I _7425_/Q _5281_/S _7425_/D VDD VDD VSS VSS gf180mcu_fd_sc_mcu7t5v0__mux2_2
XFILLER_88_879 VDD VDD VSS VSS gf180mcu_fd_sc_mcu7t5v0__fill_1
X_7017_ _7017_/D _7099_/CLK _7017_/Q VDD VDD VSS VSS gf180mcu_fd_sc_mcu7t5v0__dffq_1
X_4229_ _6651_/A2 _4233_/A2 _5330_/S VDD VDD VSS VSS gf180mcu_fd_sc_mcu7t5v0__nand2_1
XFILLER_47_209 VDD VDD VSS VSS gf180mcu_fd_sc_mcu7t5v0__fill_1
XTAP_TAPCELL_ROW_104_1711 VDD VSS gf180mcu_fd_sc_mcu7t5v0__filltie
XTAP_TAPCELL_ROW_26_624 VDD VSS gf180mcu_fd_sc_mcu7t5v0__filltie
XPHY_EDGE_ROW_12_Left_131 VDD VSS gf180mcu_fd_sc_mcu7t5v0__endcap
XTAP_TAPCELL_ROW_115_1862 VDD VSS gf180mcu_fd_sc_mcu7t5v0__filltie
XTAP_TAPCELL_ROW_115_1873 VDD VSS gf180mcu_fd_sc_mcu7t5v0__filltie
Xload_slew208 _5643_/S _5653_/S VDD VDD VSS VSS gf180mcu_fd_sc_mcu7t5v0__buf_3
Xload_slew219 _4762_/A1 _4748_/A1 VDD VDD VSS VSS gf180mcu_fd_sc_mcu7t5v0__buf_4
Xfanout391 _5744_/B _6300_/A2 VDD VDD VSS VSS gf180mcu_fd_sc_mcu7t5v0__dlyd_1
XPHY_EDGE_ROW_21_Left_140 VDD VSS gf180mcu_fd_sc_mcu7t5v0__endcap
Xfanout380 _5613_/A2 _5593_/A2 VDD VDD VSS VSS gf180mcu_fd_sc_mcu7t5v0__dlyd_1
XFILLER_93_348 VDD VDD VSS VSS gf180mcu_fd_sc_mcu7t5v0__fill_2
XFILLER_19_489 VDD VDD VSS VSS gf180mcu_fd_sc_mcu7t5v0__fill_1
XFILLER_34_459 VDD VDD VSS VSS gf180mcu_fd_sc_mcu7t5v0__fill_1
XFILLER_61_245 VDD VDD VSS VSS gf180mcu_fd_sc_mcu7t5v0__fill_1
Xinput11 tl_i[103] input11/Z VDD VDD VSS VSS gf180mcu_fd_sc_mcu7t5v0__dlyd_1
X_4580_ _5014_/A1 _4588_/A2 _4580_/B _7004_/D VDD VDD VSS VSS gf180mcu_fd_sc_mcu7t5v0__oai21_1
Xinput22 tl_i[13] input22/Z VDD VDD VSS VSS gf180mcu_fd_sc_mcu7t5v0__dlyd_1
X_3600_ input50/Z input59/Z _3600_/Z VDD VDD VSS VSS gf180mcu_fd_sc_mcu7t5v0__xor2_1
Xinput55 tl_i[52] input55/Z VDD VDD VSS VSS gf180mcu_fd_sc_mcu7t5v0__dlyd_1
Xinput44 tl_i[42] input44/Z VDD VDD VSS VSS gf180mcu_fd_sc_mcu7t5v0__dlyd_1
Xinput33 tl_i[32] input33/Z VDD VDD VSS VSS gf180mcu_fd_sc_mcu7t5v0__dlyd_1
X_3531_ _3378_/I _3691_/B2 _3676_/B VDD VDD VSS VSS gf180mcu_fd_sc_mcu7t5v0__and2_1
Xinput88 tl_i[82] input88/Z VDD VDD VSS VSS gf180mcu_fd_sc_mcu7t5v0__dlyd_1
Xinput77 tl_i[72] input77/Z VDD VDD VSS VSS gf180mcu_fd_sc_mcu7t5v0__dlyd_1
Xinput66 tl_i[62] _3385_/I VDD VDD VSS VSS gf180mcu_fd_sc_mcu7t5v0__dlyd_1
XTAP_TAPCELL_ROW_77_1334 VDD VSS gf180mcu_fd_sc_mcu7t5v0__filltie
X_3462_ _7600_/Q _6296_/A1 VDD VDD VSS VSS gf180mcu_fd_sc_mcu7t5v0__clkinv_1
Xinput99 tl_i[92] input99/Z VDD VDD VSS VSS gf180mcu_fd_sc_mcu7t5v0__dlyd_1
X_6250_ _6250_/A1 _6250_/A2 _6250_/A3 _6250_/A4 _6250_/Z VDD VDD VSS VSS gf180mcu_fd_sc_mcu7t5v0__and4_1
XTAP_TAPCELL_ROW_90_1523 VDD VSS gf180mcu_fd_sc_mcu7t5v0__filltie
XTAP_TAPCELL_ROW_90_1512 VDD VSS gf180mcu_fd_sc_mcu7t5v0__filltie
X_5201_ _5243_/I0 _7348_/Q _5204_/S _7348_/D VDD VDD VSS VSS gf180mcu_fd_sc_mcu7t5v0__mux2_2
X_3393_ _7794_/Q _5736_/A1 VDD VDD VSS VSS gf180mcu_fd_sc_mcu7t5v0__clkinv_1
X_6181_ _7162_/Q _6235_/A2 _6241_/A2 _7134_/Q _6238_/B _6182_/A2 VDD VDD VSS VSS gf180mcu_fd_sc_mcu7t5v0__oai221_1
X_5132_ _5132_/A1 _5134_/A2 _5132_/B _7280_/D VDD VDD VSS VSS gf180mcu_fd_sc_mcu7t5v0__oai21_1
XFILLER_85_816 VDD VDD VSS VSS gf180mcu_fd_sc_mcu7t5v0__fillcap_4
XTAP_TAPCELL_ROW_4_308 VDD VSS gf180mcu_fd_sc_mcu7t5v0__filltie
XTAP_TAPCELL_ROW_4_319 VDD VSS gf180mcu_fd_sc_mcu7t5v0__filltie
X_5063_ _7246_/Q _5064_/A2 _5064_/B VDD VDD VSS VSS gf180mcu_fd_sc_mcu7t5v0__nand2_1
X_4014_ wire248/Z _4518_/A2 _4014_/B _6757_/D VDD VDD VSS VSS gf180mcu_fd_sc_mcu7t5v0__oai21_1
XFILLER_93_893 VDD VDD VSS VSS gf180mcu_fd_sc_mcu7t5v0__fillcap_4
XTAP_TAPCELL_ROW_88_1485 VDD VSS gf180mcu_fd_sc_mcu7t5v0__filltie
XTAP_TAPCELL_ROW_88_1496 VDD VSS gf180mcu_fd_sc_mcu7t5v0__filltie
X_5965_ _6998_/Q _5969_/B1 _6090_/C _5967_/A1 VDD VDD VSS VSS gf180mcu_fd_sc_mcu7t5v0__oai21_1
XFILLER_12_109 VDD VDD VSS VSS gf180mcu_fd_sc_mcu7t5v0__fill_1
X_5896_ _5896_/A1 _5896_/A2 _5896_/B _5934_/B1 VDD VDD VSS VSS gf180mcu_fd_sc_mcu7t5v0__oai21_1
X_4916_ _5098_/A1 _4924_/A2 _4916_/B _7172_/D VDD VDD VSS VSS gf180mcu_fd_sc_mcu7t5v0__oai21_1
X_7704_ _7704_/D _7705_/RN _7781_/CLK _7704_/Q VDD VDD VSS VSS gf180mcu_fd_sc_mcu7t5v0__dffrnq_1
X_7635_ _7635_/D _7657_/RN _7695_/CLK _7635_/Q VDD VDD VSS VSS gf180mcu_fd_sc_mcu7t5v0__dffrnq_1
XFILLER_21_632 VDD VDD VSS VSS gf180mcu_fd_sc_mcu7t5v0__fillcap_64
XTAP_TAPCELL_ROW_51_969 VDD VSS gf180mcu_fd_sc_mcu7t5v0__filltie
X_4847_ _7138_/Q _4854_/A2 _4848_/B VDD VDD VSS VSS gf180mcu_fd_sc_mcu7t5v0__nand2_1
XTAP_TAPCELL_ROW_31_693 VDD VSS gf180mcu_fd_sc_mcu7t5v0__filltie
X_7566_ _7566_/D _7705_/RN _7703_/CLK _7566_/Q VDD VDD VSS VSS gf180mcu_fd_sc_mcu7t5v0__dffrnq_1
X_4778_ _4988_/A1 _4784_/A2 _4778_/B _7103_/D VDD VDD VSS VSS gf180mcu_fd_sc_mcu7t5v0__oai21_1
X_6517_ _7681_/Q _6517_/A2 _6517_/Z VDD VDD VSS VSS gf180mcu_fd_sc_mcu7t5v0__xor2_1
X_7497_ _7497_/D _7504_/CLK _7497_/Q VDD VDD VSS VSS gf180mcu_fd_sc_mcu7t5v0__dffq_1
X_3729_ _3712_/Z _3729_/A2 _3729_/Z VDD VDD VSS VSS gf180mcu_fd_sc_mcu7t5v0__xor2_1
X_6448_ _6448_/I _6454_/B VDD VDD VSS VSS gf180mcu_fd_sc_mcu7t5v0__clkinv_1
X_6379_ _7655_/Q _6379_/A2 _7655_/D VDD VDD VSS VSS gf180mcu_fd_sc_mcu7t5v0__xnor2_1
XFILLER_103_976 VDD VDD VSS VSS gf180mcu_fd_sc_mcu7t5v0__fillcap_4
XTAP_TAPCELL_ROW_110_1792 VDD VSS gf180mcu_fd_sc_mcu7t5v0__filltie
XFILLER_84_871 VDD VDD VSS VSS gf180mcu_fd_sc_mcu7t5v0__fillcap_4
XFILLER_31_429 VDD VDD VSS VSS gf180mcu_fd_sc_mcu7t5v0__fill_1
XTAP_TAPCELL_ROW_61_1113 VDD VSS gf180mcu_fd_sc_mcu7t5v0__filltie
XFILLER_40_941 VDD VDD VSS VSS gf180mcu_fd_sc_mcu7t5v0__fillcap_4
XFILLER_11_142 VDD VDD VSS VSS gf180mcu_fd_sc_mcu7t5v0__fill_1
XFILLER_7_102 VDD VDD VSS VSS gf180mcu_fd_sc_mcu7t5v0__fill_2
XTAP_TAPCELL_ROW_117_1902 VDD VSS gf180mcu_fd_sc_mcu7t5v0__filltie
XFILLER_3_352 VDD VDD VSS VSS gf180mcu_fd_sc_mcu7t5v0__fill_2
XTAP_TAPCELL_ROW_59_1086 VDD VSS gf180mcu_fd_sc_mcu7t5v0__filltie
XFILLER_79_632 VDD VDD VSS VSS gf180mcu_fd_sc_mcu7t5v0__fill_1
XFILLER_39_507 VDD VDD VSS VSS gf180mcu_fd_sc_mcu7t5v0__fillcap_8
XTAP_TAPCELL_ROW_72_1264 VDD VSS gf180mcu_fd_sc_mcu7t5v0__filltie
Xclkbuf_leaf_7_clk_i clkload1/I _7794_/CLK VDD VDD VSS VSS gf180mcu_fd_sc_mcu7t5v0__clkbuf_8
XFILLER_94_646 VDD VDD VSS VSS gf180mcu_fd_sc_mcu7t5v0__fill_1
XFILLER_81_318 VDD VDD VSS VSS gf180mcu_fd_sc_mcu7t5v0__fill_1
XFILLER_75_871 VDD VDD VSS VSS gf180mcu_fd_sc_mcu7t5v0__fillcap_8
XFILLER_35_702 VDD VDD VSS VSS gf180mcu_fd_sc_mcu7t5v0__fillcap_64
XFILLER_47_562 VDD VDD VSS VSS gf180mcu_fd_sc_mcu7t5v0__fill_2
X_5750_ _7712_/Q _7713_/Q wire416/I VDD VDD VSS VSS gf180mcu_fd_sc_mcu7t5v0__nand2_1
X_4701_ _7065_/Q _4714_/A2 _4702_/B VDD VDD VSS VSS gf180mcu_fd_sc_mcu7t5v0__nand2_1
XTAP_TAPCELL_ROW_17_498 VDD VSS gf180mcu_fd_sc_mcu7t5v0__filltie
X_5681_ _7555_/Q input33/Z _5687_/S _7555_/D VDD VDD VSS VSS gf180mcu_fd_sc_mcu7t5v0__mux2_2
X_4632_ _5094_/A1 _4644_/A2 _4632_/B _7030_/D VDD VDD VSS VSS gf180mcu_fd_sc_mcu7t5v0__oai21_1
X_7420_ _7420_/D _7456_/CLK _7420_/Q VDD VDD VSS VSS gf180mcu_fd_sc_mcu7t5v0__dffq_1
X_4563_ _6996_/Q _4574_/A2 _4564_/B VDD VDD VSS VSS gf180mcu_fd_sc_mcu7t5v0__nand2_1
X_7351_ _7351_/D _7804_/CLK _7351_/Q VDD VDD VSS VSS gf180mcu_fd_sc_mcu7t5v0__dffq_1
X_6302_ _6302_/A1 _5883_/C _6302_/B1 _6302_/B2 _7603_/D VDD VDD VSS VSS gf180mcu_fd_sc_mcu7t5v0__aoi22_1
X_4494_ _5124_/A1 _4504_/A2 _4494_/B _6961_/D VDD VDD VSS VSS gf180mcu_fd_sc_mcu7t5v0__oai21_1
X_7282_ _7282_/D _7482_/CLK _7282_/Q VDD VDD VSS VSS gf180mcu_fd_sc_mcu7t5v0__dffq_1
X_3514_ _3514_/A1 _5633_/B _7766_/D _7767_/D VDD VDD VSS VSS gf180mcu_fd_sc_mcu7t5v0__aoi21_1
X_3445_ _7598_/Q _6292_/A1 VDD VDD VSS VSS gf180mcu_fd_sc_mcu7t5v0__clkinv_1
X_6233_ _6792_/Q _6233_/A2 _6233_/B1 _6791_/Q _6789_/Q _6236_/A2 _6234_/A2 VDD VDD
+ VSS VSS gf180mcu_fd_sc_mcu7t5v0__oai222_1
X_6164_ _6889_/Q _6229_/B1 _6212_/C _6166_/A1 VDD VDD VSS VSS gf180mcu_fd_sc_mcu7t5v0__oai21_1
X_3376_ _7518_/Q _5634_/A1 VDD VDD VSS VSS gf180mcu_fd_sc_mcu7t5v0__clkinv_1
X_5115_ _7272_/Q _5120_/A2 _5116_/B VDD VDD VSS VSS gf180mcu_fd_sc_mcu7t5v0__nand2_1
Xload_slew572 _7611_/RN _7668_/RN VDD VDD VSS VSS gf180mcu_fd_sc_mcu7t5v0__buf_4
X_6095_ _6224_/B _6095_/A2 _6095_/B1 _6095_/B2 _6122_/C _6096_/A2 VDD VDD VSS VSS
+ gf180mcu_fd_sc_mcu7t5v0__oai221_1
XFILLER_100_979 VDD VDD VSS VSS gf180mcu_fd_sc_mcu7t5v0__fill_2
X_5046_ wire241/Z _5050_/A2 _5046_/B _7237_/D VDD VDD VSS VSS gf180mcu_fd_sc_mcu7t5v0__oai21_1
Xload_slew594 wire593/I _7799_/RN VDD VDD VSS VSS gf180mcu_fd_sc_mcu7t5v0__clkbuf_4
X_6997_ _6997_/D _7276_/CLK _6997_/Q VDD VDD VSS VSS gf180mcu_fd_sc_mcu7t5v0__dffq_1
XTAP_TAPCELL_ROW_36_763 VDD VSS gf180mcu_fd_sc_mcu7t5v0__filltie
XFILLER_53_554 VDD VDD VSS VSS gf180mcu_fd_sc_mcu7t5v0__fill_1
X_5948_ _7068_/Q _6225_/A2 wire355/I _6991_/Q _5950_/A1 VDD VDD VSS VSS gf180mcu_fd_sc_mcu7t5v0__oai22_1
XFILLER_22_941 VDD VDD VSS VSS gf180mcu_fd_sc_mcu7t5v0__fillcap_4
X_5879_ _7540_/Q _6256_/A2 _5691_/I _7780_/Q _5677_/I _7558_/Q _5880_/A2 VDD VDD VSS
+ VSS gf180mcu_fd_sc_mcu7t5v0__aoi222_1
X_7618_ _7618_/D _7701_/RN _7802_/CLK _7618_/Q VDD VDD VSS VSS gf180mcu_fd_sc_mcu7t5v0__dffrnq_1
X_7549_ _7549_/D _7733_/RN _7780_/CLK _7549_/Q VDD VDD VSS VSS gf180mcu_fd_sc_mcu7t5v0__dffrnq_1
XTAP_TAPCELL_ROW_112_1832 VDD VSS gf180mcu_fd_sc_mcu7t5v0__filltie
XTAP_TAPCELL_ROW_112_1821 VDD VSS gf180mcu_fd_sc_mcu7t5v0__filltie
XFILLER_103_751 VDD VDD VSS VSS gf180mcu_fd_sc_mcu7t5v0__fillcap_4
XFILLER_89_952 VDD VDD VSS VSS gf180mcu_fd_sc_mcu7t5v0__fillcap_16
XFILLER_49_838 VDD VDD VSS VSS gf180mcu_fd_sc_mcu7t5v0__fill_2
XFILLER_17_702 VDD VDD VSS VSS gf180mcu_fd_sc_mcu7t5v0__fillcap_64
XFILLER_29_562 VDD VDD VSS VSS gf180mcu_fd_sc_mcu7t5v0__fillcap_64
XFILLER_9_912 VDD VDD VSS VSS gf180mcu_fd_sc_mcu7t5v0__fillcap_64
XTAP_TAPCELL_ROW_14_457 VDD VSS gf180mcu_fd_sc_mcu7t5v0__filltie
XFILLER_12_462 VDD VDD VSS VSS gf180mcu_fd_sc_mcu7t5v0__fill_2
XFILLER_8_444 VDD VDD VSS VSS gf180mcu_fd_sc_mcu7t5v0__fill_1
XFILLER_4_661 VDD VDD VSS VSS gf180mcu_fd_sc_mcu7t5v0__fillcap_4
XFILLER_95_922 VDD VDD VSS VSS gf180mcu_fd_sc_mcu7t5v0__fillcap_32
X_6920_ _6920_/D _7259_/CLK _6920_/Q VDD VDD VSS VSS gf180mcu_fd_sc_mcu7t5v0__dffq_1
X_6851_ _6851_/D _7687_/CLK _6851_/Q VDD VDD VSS VSS gf180mcu_fd_sc_mcu7t5v0__dffq_1
XTAP_TAPCELL_ROW_85_1455 VDD VSS gf180mcu_fd_sc_mcu7t5v0__filltie
XTAP_TAPCELL_ROW_85_1444 VDD VSS gf180mcu_fd_sc_mcu7t5v0__filltie
X_5802_ _7002_/Q _6073_/A2 _6198_/C2 _6974_/Q _5804_/A1 VDD VDD VSS VSS gf180mcu_fd_sc_mcu7t5v0__oai22_1
XFILLER_50_513 VDD VDD VSS VSS gf180mcu_fd_sc_mcu7t5v0__fillcap_4
X_3994_ _6751_/Q _4434_/A2 _3995_/B VDD VDD VSS VSS gf180mcu_fd_sc_mcu7t5v0__nand2_1
X_6782_ _6782_/D _7259_/CLK _6782_/Q VDD VDD VSS VSS gf180mcu_fd_sc_mcu7t5v0__dffq_1
XTAP_TAPCELL_ROW_33_722 VDD VSS gf180mcu_fd_sc_mcu7t5v0__filltie
X_5733_ _5733_/I _6483_/B VDD VDD VSS VSS gf180mcu_fd_sc_mcu7t5v0__clkinv_1
X_5664_ input32/Z _7783_/D _5665_/B VDD VDD VSS VSS gf180mcu_fd_sc_mcu7t5v0__nand2_1
X_4615_ _7022_/Q _4616_/A2 _4616_/B VDD VDD VSS VSS gf180mcu_fd_sc_mcu7t5v0__nand2_1
X_5595_ _5549_/C _5595_/A2 _5595_/A3 _5602_/A3 VDD VDD VSS VSS gf180mcu_fd_sc_mcu7t5v0__nor3_1
X_7403_ _7403_/D _7499_/CLK _7403_/Q VDD VDD VSS VSS gf180mcu_fd_sc_mcu7t5v0__dffq_1
X_4546_ _5134_/A1 _4546_/A2 _4546_/B _6987_/D VDD VDD VSS VSS gf180mcu_fd_sc_mcu7t5v0__oai21_1
X_7334_ _7334_/D clkload9/I _7334_/Q VDD VDD VSS VSS gf180mcu_fd_sc_mcu7t5v0__dffq_1
X_4477_ _6953_/Q _4490_/A2 _4478_/B VDD VDD VSS VSS gf180mcu_fd_sc_mcu7t5v0__nand2_1
X_7265_ _7265_/D _7267_/CLK _7265_/Q VDD VDD VSS VSS gf180mcu_fd_sc_mcu7t5v0__dffq_1
X_3428_ _7790_/Q _3781_/A1 VDD VDD VSS VSS gf180mcu_fd_sc_mcu7t5v0__clkinv_1
X_7196_ _7196_/D _7196_/CLK _7196_/Q VDD VDD VSS VSS gf180mcu_fd_sc_mcu7t5v0__dffq_1
X_6216_ _6216_/A1 _6216_/A2 _6216_/B _6217_/A2 VDD VDD VSS VSS gf180mcu_fd_sc_mcu7t5v0__oai21_1
XFILLER_86_911 VDD VDD VSS VSS gf180mcu_fd_sc_mcu7t5v0__fillcap_32
X_3359_ _7647_/Q _6363_/A1 VDD VDD VSS VSS gf180mcu_fd_sc_mcu7t5v0__clkinv_1
X_6147_ _7113_/Q _6215_/B1 _6147_/B _6149_/A1 VDD VDD VSS VSS gf180mcu_fd_sc_mcu7t5v0__oai21_1
XFILLER_100_754 VDD VDD VSS VSS gf180mcu_fd_sc_mcu7t5v0__fillcap_8
XFILLER_100_732 VDD VDD VSS VSS gf180mcu_fd_sc_mcu7t5v0__fill_2
X_6078_ _6937_/Q wire355/Z _6167_/B1 _6923_/Q _6227_/C _6079_/I VDD VDD VSS VSS gf180mcu_fd_sc_mcu7t5v0__oai221_1
XFILLER_26_532 VDD VDD VSS VSS gf180mcu_fd_sc_mcu7t5v0__fillcap_32
X_5029_ _7229_/Q _5036_/A2 _5030_/B VDD VDD VSS VSS gf180mcu_fd_sc_mcu7t5v0__nand2_1
XFILLER_80_192 VDD VDD VSS VSS gf180mcu_fd_sc_mcu7t5v0__fill_2
XFILLER_41_557 VDD VDD VSS VSS gf180mcu_fd_sc_mcu7t5v0__fill_2
XTAP_TAPCELL_ROW_11_416 VDD VSS gf180mcu_fd_sc_mcu7t5v0__filltie
XTAP_TAPCELL_ROW_56_1045 VDD VSS gf180mcu_fd_sc_mcu7t5v0__filltie
Xclkbuf_leaf_72_clk_i clkload3/I _7453_/CLK VDD VDD VSS VSS gf180mcu_fd_sc_mcu7t5v0__clkbuf_8
XFILLER_92_936 VDD VDD VSS VSS gf180mcu_fd_sc_mcu7t5v0__fillcap_8
XFILLER_77_977 VDD VDD VSS VSS gf180mcu_fd_sc_mcu7t5v0__fill_2
Xclkbuf_leaf_87_clk_i clkload0/I _7483_/CLK VDD VDD VSS VSS gf180mcu_fd_sc_mcu7t5v0__clkbuf_8
XFILLER_64_605 VDD VDD VSS VSS gf180mcu_fd_sc_mcu7t5v0__fillcap_4
XFILLER_92_947 VDD VDD VSS VSS gf180mcu_fd_sc_mcu7t5v0__fillcap_32
XTAP_TAPCELL_ROW_19_527 VDD VSS gf180mcu_fd_sc_mcu7t5v0__filltie
Xclkbuf_leaf_10_clk_i clkbuf_3_1__f_clk_i/Z _7734_/CLK VDD VDD VSS VSS gf180mcu_fd_sc_mcu7t5v0__clkbuf_8
XFILLER_44_384 VDD VDD VSS VSS gf180mcu_fd_sc_mcu7t5v0__fill_1
XTAP_TAPCELL_ROW_67_1196 VDD VSS gf180mcu_fd_sc_mcu7t5v0__filltie
XPHY_EDGE_ROW_4_Left_123 VDD VSS gf180mcu_fd_sc_mcu7t5v0__endcap
XFILLER_32_579 VDD VDD VSS VSS gf180mcu_fd_sc_mcu7t5v0__fillcap_16
XFILLER_60_877 VDD VDD VSS VSS gf180mcu_fd_sc_mcu7t5v0__fillcap_64
XTAP_TAPCELL_ROW_80_1385 VDD VSS gf180mcu_fd_sc_mcu7t5v0__filltie
XTAP_TAPCELL_ROW_80_1374 VDD VSS gf180mcu_fd_sc_mcu7t5v0__filltie
Xclkbuf_leaf_25_clk_i clkload2/I _7695_/CLK VDD VDD VSS VSS gf180mcu_fd_sc_mcu7t5v0__clkbuf_8
X_4400_ _5100_/A1 _4406_/A2 _4400_/B _6914_/D VDD VDD VSS VSS gf180mcu_fd_sc_mcu7t5v0__oai21_1
XFILLER_99_502 VDD VDD VSS VSS gf180mcu_fd_sc_mcu7t5v0__fill_1
X_5380_ _7464_/Q _5507_/B1 _5511_/C2 _7471_/Q _7485_/Q wire428/I _5381_/A2 VDD VDD
+ VSS VSS gf180mcu_fd_sc_mcu7t5v0__oai222_1
X_4331_ _6880_/Q _4336_/A2 _4332_/B VDD VDD VSS VSS gf180mcu_fd_sc_mcu7t5v0__nand2_1
X_7050_ _7050_/D _7064_/CLK _7050_/Q VDD VDD VSS VSS gf180mcu_fd_sc_mcu7t5v0__dffq_1
X_4262_ _4584_/A1 _4266_/A2 _4262_/B _6845_/D VDD VDD VSS VSS gf180mcu_fd_sc_mcu7t5v0__oai21_1
X_6001_ _6001_/I _6006_/B VDD VDD VSS VSS gf180mcu_fd_sc_mcu7t5v0__clkinv_1
X_4193_ _4226_/A3 _4193_/A2 _4200_/A2 VDD VDD VSS VSS gf180mcu_fd_sc_mcu7t5v0__nor2_1
XFILLER_83_958 VDD VDD VSS VSS gf180mcu_fd_sc_mcu7t5v0__fillcap_16
X_6903_ _6903_/D _6939_/CLK _6903_/Q VDD VDD VSS VSS gf180mcu_fd_sc_mcu7t5v0__dffq_1
X_7883_ _7884_/I _7883_/Z VDD VDD VSS VSS gf180mcu_fd_sc_mcu7t5v0__buf_1
X_6834_ _6834_/D _7070_/CLK _6834_/Q VDD VDD VSS VSS gf180mcu_fd_sc_mcu7t5v0__dffq_1
XFILLER_23_535 VDD VDD VSS VSS gf180mcu_fd_sc_mcu7t5v0__fillcap_16
XPHY_EDGE_ROW_59_Left_178 VDD VSS gf180mcu_fd_sc_mcu7t5v0__endcap
X_6765_ _6765_/D _7261_/CLK _6765_/Q VDD VDD VSS VSS gf180mcu_fd_sc_mcu7t5v0__dffq_1
X_3977_ _6609_/A1 _7720_/Q _7721_/Q _4150_/A2 VDD VDD VSS VSS gf180mcu_fd_sc_mcu7t5v0__nor3_4
X_5716_ _7629_/Q _5716_/A2 _6343_/A1 _7689_/Q _5716_/C _5717_/C VDD VDD VSS VSS gf180mcu_fd_sc_mcu7t5v0__aoi221_1
XFILLER_50_387 VDD VDD VSS VSS gf180mcu_fd_sc_mcu7t5v0__fill_2
XTAP_TAPCELL_ROW_98_1635 VDD VSS gf180mcu_fd_sc_mcu7t5v0__filltie
XTAP_TAPCELL_ROW_98_1624 VDD VSS gf180mcu_fd_sc_mcu7t5v0__filltie
X_6696_ _6697_/A1 _6672_/Z _6696_/B _6716_/A2 VDD VDD VSS VSS gf180mcu_fd_sc_mcu7t5v0__oai21_1
X_5647_ _7530_/Q input57/Z _5651_/S _7530_/D VDD VDD VSS VSS gf180mcu_fd_sc_mcu7t5v0__mux2_2
X_5578_ _7428_/Q _5578_/A2 _5373_/Z _7435_/Q _7449_/Q _5596_/A2 _5582_/A2 VDD VDD
+ VSS VSS gf180mcu_fd_sc_mcu7t5v0__oai222_1
X_4529_ _6979_/Q _4532_/A2 _4530_/B VDD VDD VSS VSS gf180mcu_fd_sc_mcu7t5v0__nand2_1
XFILLER_105_824 VDD VDD VSS VSS gf180mcu_fd_sc_mcu7t5v0__fill_1
X_7317_ _7317_/D _7499_/CLK _7317_/Q VDD VDD VSS VSS gf180mcu_fd_sc_mcu7t5v0__dffq_1
XFILLER_105_857 VDD VDD VSS VSS gf180mcu_fd_sc_mcu7t5v0__fillcap_16
X_7248_ _7248_/D _7248_/CLK _7248_/Q VDD VDD VSS VSS gf180mcu_fd_sc_mcu7t5v0__dffq_1
XPHY_EDGE_ROW_68_Left_187 VDD VSS gf180mcu_fd_sc_mcu7t5v0__endcap
X_7179_ _7179_/D _7719_/CLK _7179_/Q VDD VDD VSS VSS gf180mcu_fd_sc_mcu7t5v0__dffq_1
XFILLER_74_947 VDD VDD VSS VSS gf180mcu_fd_sc_mcu7t5v0__fillcap_32
XTAP_TAPCELL_ROW_107_1753 VDD VSS gf180mcu_fd_sc_mcu7t5v0__filltie
XPHY_EDGE_ROW_77_Left_196 VDD VSS gf180mcu_fd_sc_mcu7t5v0__endcap
XFILLER_14_524 VDD VDD VSS VSS gf180mcu_fd_sc_mcu7t5v0__fill_1
XFILLER_42_877 VDD VDD VSS VSS gf180mcu_fd_sc_mcu7t5v0__fillcap_64
XTAP_TAPCELL_ROW_24_596 VDD VSS gf180mcu_fd_sc_mcu7t5v0__filltie
XFILLER_14_94 VDD VDD VSS VSS gf180mcu_fd_sc_mcu7t5v0__fill_1
Xinput9 tl_i[101] input9/Z VDD VDD VSS VSS gf180mcu_fd_sc_mcu7t5v0__dlyd_1
XFILLER_65_958 VDD VDD VSS VSS gf180mcu_fd_sc_mcu7t5v0__fillcap_16
XTAP_TAPCELL_ROW_69_1225 VDD VSS gf180mcu_fd_sc_mcu7t5v0__filltie
XTAP_TAPCELL_ROW_82_1403 VDD VSS gf180mcu_fd_sc_mcu7t5v0__filltie
X_3900_ _3900_/I _3901_/A2 VDD VDD VSS VSS gf180mcu_fd_sc_mcu7t5v0__clkinv_1
X_4880_ _4880_/A1 _4882_/A2 _4880_/B _7154_/D VDD VDD VSS VSS gf180mcu_fd_sc_mcu7t5v0__oai21_1
X_3831_ _6300_/A1 _6288_/A1 _3830_/Z _3831_/Z VDD VDD VSS VSS gf180mcu_fd_sc_mcu7t5v0__xor3_1
XTAP_TAPCELL_ROW_43_861 VDD VSS gf180mcu_fd_sc_mcu7t5v0__filltie
XFILLER_60_663 VDD VDD VSS VSS gf180mcu_fd_sc_mcu7t5v0__fill_2
X_3762_ _3719_/I _5815_/C2 _3763_/A4 VDD VDD VSS VSS gf180mcu_fd_sc_mcu7t5v0__nor2_1
X_6550_ _6559_/A1 _6550_/A2 _6549_/Z _7692_/D VDD VDD VSS VSS gf180mcu_fd_sc_mcu7t5v0__nor3_1
X_5501_ _7398_/Q _5578_/A2 _5501_/B1 _7405_/Q _7419_/Q _5597_/A2 _5520_/A3 VDD VDD
+ VSS VSS gf180mcu_fd_sc_mcu7t5v0__oai222_1
X_3693_ input25/Z _3693_/A2 input26/Z _3693_/A4 _3700_/A2 VDD VDD VSS VSS gf180mcu_fd_sc_mcu7t5v0__nor4_1
X_6481_ _7796_/Q _3476_/I _6482_/B VDD VDD VSS VSS gf180mcu_fd_sc_mcu7t5v0__xor2_1
X_5432_ _5366_/Z _5431_/Z _5433_/C VDD VDD VSS VSS gf180mcu_fd_sc_mcu7t5v0__nand2_1
XFILLER_114_621 VDD VDD VSS VSS gf180mcu_fd_sc_mcu7t5v0__fill_1
X_5363_ _5359_/Z _6732_/A1 _6728_/B VDD VDD VSS VSS gf180mcu_fd_sc_mcu7t5v0__or2_1
XTAP_TAPCELL_ROW_93_1565 VDD VSS gf180mcu_fd_sc_mcu7t5v0__filltie
XTAP_TAPCELL_ROW_93_1554 VDD VSS gf180mcu_fd_sc_mcu7t5v0__filltie
X_7102_ _7102_/D _7217_/CLK _7102_/Q VDD VDD VSS VSS gf180mcu_fd_sc_mcu7t5v0__dffq_1
X_4314_ _4832_/A1 _4322_/A2 _4314_/B _6871_/D VDD VDD VSS VSS gf180mcu_fd_sc_mcu7t5v0__oai21_1
X_5294_ _5343_/I0 _7441_/Q _5295_/S _7441_/D VDD VDD VSS VSS gf180mcu_fd_sc_mcu7t5v0__mux2_2
XFILLER_102_849 VDD VDD VSS VSS gf180mcu_fd_sc_mcu7t5v0__fill_1
X_4245_ _6837_/Q _4252_/A2 _4246_/B VDD VDD VSS VSS gf180mcu_fd_sc_mcu7t5v0__nand2_1
X_7033_ _7033_/D _7097_/CLK _7033_/Q VDD VDD VSS VSS gf180mcu_fd_sc_mcu7t5v0__dffq_1
XFILLER_110_871 VDD VDD VSS VSS gf180mcu_fd_sc_mcu7t5v0__fillcap_4
X_4176_ _6651_/A1 _4179_/A2 _5176_/S VDD VDD VSS VSS gf180mcu_fd_sc_mcu7t5v0__nand2_1
XFILLER_68_774 VDD VDD VSS VSS gf180mcu_fd_sc_mcu7t5v0__fillcap_16
XFILLER_56_947 VDD VDD VSS VSS gf180mcu_fd_sc_mcu7t5v0__fillcap_32
XFILLER_27_148 VDD VDD VSS VSS gf180mcu_fd_sc_mcu7t5v0__fill_1
XFILLER_24_877 VDD VDD VSS VSS gf180mcu_fd_sc_mcu7t5v0__fillcap_64
X_6817_ _6817_/D _7736_/CLK _6817_/Q VDD VDD VSS VSS gf180mcu_fd_sc_mcu7t5v0__dffq_1
XTAP_TAPCELL_ROW_102_1683 VDD VSS gf180mcu_fd_sc_mcu7t5v0__filltie
X_7797_ _7797_/D _7802_/RN _7802_/CLK _7797_/Q VDD VDD VSS VSS gf180mcu_fd_sc_mcu7t5v0__dffrnq_1
XFILLER_11_538 VDD VDD VSS VSS gf180mcu_fd_sc_mcu7t5v0__fillcap_16
X_6748_ _6748_/D _7008_/CLK _6748_/Q VDD VDD VSS VSS gf180mcu_fd_sc_mcu7t5v0__dffq_1
XTAP_TAPCELL_ROW_21_555 VDD VSS gf180mcu_fd_sc_mcu7t5v0__filltie
X_6679_ _6679_/I0 _6679_/I1 _6679_/S _6679_/Z VDD VDD VSS VSS gf180mcu_fd_sc_mcu7t5v0__mux2_2
XFILLER_105_621 VDD VDD VSS VSS gf180mcu_fd_sc_mcu7t5v0__fill_1
XFILLER_117_492 VDD VDD VSS VSS gf180mcu_fd_sc_mcu7t5v0__fill_1
XFILLER_2_247 VDD VDD VSS VSS gf180mcu_fd_sc_mcu7t5v0__fill_1
XTAP_TAPCELL_ROW_53_1004 VDD VSS gf180mcu_fd_sc_mcu7t5v0__filltie
XFILLER_78_505 VDD VDD VSS VSS gf180mcu_fd_sc_mcu7t5v0__fill_2
Xuart_613 racl_error_o[17] VDD VDD VSS VSS gf180mcu_fd_sc_mcu7t5v0__tiel
Xuart_602 racl_error_o[6] VDD VDD VSS VSS gf180mcu_fd_sc_mcu7t5v0__tiel
Xuart_624 racl_error_o[28] VDD VDD VSS VSS gf180mcu_fd_sc_mcu7t5v0__tiel
XFILLER_105_698 VDD VDD VSS VSS gf180mcu_fd_sc_mcu7t5v0__fill_2
Xuart_646 racl_error_o[43] VDD VDD VSS VSS gf180mcu_fd_sc_mcu7t5v0__tiel
Xuart_635 racl_error_o[39] VDD VDD VSS VSS gf180mcu_fd_sc_mcu7t5v0__tiel
Xfanout540 _7538_/Q _6679_/I0 VDD VDD VSS VSS gf180mcu_fd_sc_mcu7t5v0__dlyd_1
XFILLER_47_903 VDD VDD VSS VSS gf180mcu_fd_sc_mcu7t5v0__fillcap_4
Xfanout595 _7661_/RN _7690_/RN VDD VDD VSS VSS gf180mcu_fd_sc_mcu7t5v0__dlyd_1
XPHY_EDGE_ROW_85_Left_204 VDD VSS gf180mcu_fd_sc_mcu7t5v0__endcap
XFILLER_62_906 VDD VDD VSS VSS gf180mcu_fd_sc_mcu7t5v0__fillcap_32
XFILLER_92_33 VDD VDD VSS VSS gf180mcu_fd_sc_mcu7t5v0__fill_2
XFILLER_74_788 VDD VDD VSS VSS gf180mcu_fd_sc_mcu7t5v0__fillcap_4
XTAP_TAPCELL_ROW_29_666 VDD VSS gf180mcu_fd_sc_mcu7t5v0__filltie
XFILLER_46_479 VDD VDD VSS VSS gf180mcu_fd_sc_mcu7t5v0__fill_2
XFILLER_14_332 VDD VDD VSS VSS gf180mcu_fd_sc_mcu7t5v0__fill_2
XTAP_TAPCELL_ROW_64_1155 VDD VSS gf180mcu_fd_sc_mcu7t5v0__filltie
XFILLER_14_387 VDD VDD VSS VSS gf180mcu_fd_sc_mcu7t5v0__fill_1
XTAP_TAPCELL_ROW_40_820 VDD VSS gf180mcu_fd_sc_mcu7t5v0__filltie
XPHY_EDGE_ROW_94_Left_213 VDD VSS gf180mcu_fd_sc_mcu7t5v0__endcap
XFILLER_41_81 VDD VDD VSS VSS gf180mcu_fd_sc_mcu7t5v0__fill_2
XFILLER_6_597 VDD VDD VSS VSS gf180mcu_fd_sc_mcu7t5v0__fillcap_64
XTAP_TAPCELL_ROW_9_391 VDD VSS gf180mcu_fd_sc_mcu7t5v0__filltie
XTAP_TAPCELL_ROW_9_380 VDD VSS gf180mcu_fd_sc_mcu7t5v0__filltie
X_4030_ _6619_/A1 _7724_/Q _4059_/A2 VDD VDD VSS VSS gf180mcu_fd_sc_mcu7t5v0__nand2_1
XPHY_EDGE_ROW_10_Right_10 VDD VSS gf180mcu_fd_sc_mcu7t5v0__endcap
XFILLER_38_947 VDD VDD VSS VSS gf180mcu_fd_sc_mcu7t5v0__fillcap_32
XTAP_TAPCELL_ROW_48_931 VDD VSS gf180mcu_fd_sc_mcu7t5v0__filltie
X_5981_ _5981_/A1 _5981_/A2 _5997_/B1 VDD VDD VSS VSS gf180mcu_fd_sc_mcu7t5v0__nor2_1
X_7720_ _7720_/D wire593/Z _7724_/CLK _7720_/Q VDD VDD VSS VSS gf180mcu_fd_sc_mcu7t5v0__dffrnq_1
X_4932_ _4946_/A1 _4938_/A2 _4932_/B _7180_/D VDD VDD VSS VSS gf180mcu_fd_sc_mcu7t5v0__oai21_1
X_7651_ _7651_/D _7742_/RN _7792_/CLK _7651_/Q VDD VDD VSS VSS gf180mcu_fd_sc_mcu7t5v0__dffrnq_1
XANTENNA_14 _6986_/Q VDD VDD VSS VSS gf180mcu_fd_sc_mcu7t5v0__antenna
X_4863_ _7146_/Q _4868_/A2 _4864_/B VDD VDD VSS VSS gf180mcu_fd_sc_mcu7t5v0__nand2_1
XFILLER_21_836 VDD VDD VSS VSS gf180mcu_fd_sc_mcu7t5v0__fillcap_4
XFILLER_33_696 VDD VDD VSS VSS gf180mcu_fd_sc_mcu7t5v0__fillcap_4
X_6602_ _6603_/A1 _6602_/A2 _6604_/B VDD VDD VSS VSS gf180mcu_fd_sc_mcu7t5v0__nor2_1
X_7582_ _7582_/D _7595_/RN _7671_/CLK _7582_/Q VDD VDD VSS VSS gf180mcu_fd_sc_mcu7t5v0__dffrnq_1
X_3814_ _7775_/Q _3901_/B _3815_/A2 VDD VDD VSS VSS gf180mcu_fd_sc_mcu7t5v0__nor2_1
X_4794_ _4822_/A1 _4798_/A2 _4794_/B _7111_/D VDD VDD VSS VSS gf180mcu_fd_sc_mcu7t5v0__oai21_1
X_6533_ _7687_/Q _6531_/Z _6535_/A2 VDD VDD VSS VSS gf180mcu_fd_sc_mcu7t5v0__nor2_1
X_3745_ _7547_/Q _7545_/Q _7546_/Q _3750_/B1 VDD VDD VSS VSS gf180mcu_fd_sc_mcu7t5v0__oai21_1
X_6464_ _7668_/Q _6463_/Z _6479_/S _7668_/D VDD VDD VSS VSS gf180mcu_fd_sc_mcu7t5v0__mux2_2
XFILLER_107_908 VDD VDD VSS VSS gf180mcu_fd_sc_mcu7t5v0__fill_2
X_3676_ _3688_/A2 _3676_/A2 _3676_/B _3701_/B VDD VDD VSS VSS gf180mcu_fd_sc_mcu7t5v0__oai21_1
X_5415_ _7458_/Q wire428/Z _5511_/B1 _7437_/Q _7360_/Q _5511_/C2 _5416_/A3 VDD VDD
+ VSS VSS gf180mcu_fd_sc_mcu7t5v0__oai222_1
Xoutput110 _3848_/Z cio_tx_o VDD VDD VSS VSS gf180mcu_fd_sc_mcu7t5v0__dlyd_1
X_6395_ _7658_/Q _7524_/Q _6400_/A2 _6395_/Z VDD VDD VSS VSS gf180mcu_fd_sc_mcu7t5v0__xor3_1
Xoutput132 _7573_/Q tl_o[17] VDD VDD VSS VSS gf180mcu_fd_sc_mcu7t5v0__dlyd_1
Xoutput143 _7583_/Q tl_o[27] VDD VDD VSS VSS gf180mcu_fd_sc_mcu7t5v0__dlyd_1
Xoutput121 _7879_/Z racl_error_o[2] VDD VDD VSS VSS gf180mcu_fd_sc_mcu7t5v0__dlyd_1
Xoutput165 _7603_/Q tl_o[47] VDD VDD VSS VSS gf180mcu_fd_sc_mcu7t5v0__dlyd_1
Xoutput176 _7885_/I tl_o[58] VDD VDD VSS VSS gf180mcu_fd_sc_mcu7t5v0__dlyd_1
Xoutput154 _7593_/Q tl_o[37] VDD VDD VSS VSS gf180mcu_fd_sc_mcu7t5v0__dlyd_1
X_5346_ _7640_/Q _7493_/Q _5351_/S _7493_/D VDD VDD VSS VSS gf180mcu_fd_sc_mcu7t5v0__mux2_2
X_5277_ _5354_/I0 _7424_/Q _5281_/S _7424_/D VDD VDD VSS VSS gf180mcu_fd_sc_mcu7t5v0__mux2_2
X_7016_ _7016_/D _7062_/CLK _7016_/Q VDD VDD VSS VSS gf180mcu_fd_sc_mcu7t5v0__dffq_1
X_4228_ wire507/Z _6828_/Q _5323_/S _6828_/D VDD VDD VSS VSS gf180mcu_fd_sc_mcu7t5v0__mux2_2
XFILLER_68_593 VDD VDD VSS VSS gf180mcu_fd_sc_mcu7t5v0__fill_2
XPHY_EDGE_ROW_106_Right_106 VDD VSS gf180mcu_fd_sc_mcu7t5v0__endcap
X_4159_ wire507/Z _6802_/Q _5141_/S _6802_/D VDD VDD VSS VSS gf180mcu_fd_sc_mcu7t5v0__mux2_2
XTAP_TAPCELL_ROW_104_1712 VDD VSS gf180mcu_fd_sc_mcu7t5v0__filltie
XTAP_TAPCELL_ROW_26_625 VDD VSS gf180mcu_fd_sc_mcu7t5v0__filltie
XFILLER_43_438 VDD VDD VSS VSS gf180mcu_fd_sc_mcu7t5v0__fill_1
XFILLER_8_807 VDD VDD VSS VSS gf180mcu_fd_sc_mcu7t5v0__fillcap_64
Xwire204 _5661_/S _5663_/S VDD VDD VSS VSS gf180mcu_fd_sc_mcu7t5v0__buf_4
Xwire248 wire248/I wire248/Z VDD VDD VSS VSS gf180mcu_fd_sc_mcu7t5v0__clkbuf_4
XFILLER_3_512 VDD VDD VSS VSS gf180mcu_fd_sc_mcu7t5v0__fill_1
XTAP_TAPCELL_ROW_115_1863 VDD VSS gf180mcu_fd_sc_mcu7t5v0__filltie
XTAP_TAPCELL_ROW_115_1874 VDD VSS gf180mcu_fd_sc_mcu7t5v0__filltie
XFILLER_2_2 VDD VDD VSS VSS gf180mcu_fd_sc_mcu7t5v0__fill_2
Xload_slew209 _7783_/D _5675_/S VDD VDD VSS VSS gf180mcu_fd_sc_mcu7t5v0__buf_4
XFILLER_87_880 VDD VDD VSS VSS gf180mcu_fd_sc_mcu7t5v0__fill_1
Xfanout370 _5612_/B1 _5559_/B1 VDD VDD VSS VSS gf180mcu_fd_sc_mcu7t5v0__dlyd_1
XFILLER_35_906 VDD VDD VSS VSS gf180mcu_fd_sc_mcu7t5v0__fillcap_4
XFILLER_46_287 VDD VDD VSS VSS gf180mcu_fd_sc_mcu7t5v0__fill_2
XFILLER_15_696 VDD VDD VSS VSS gf180mcu_fd_sc_mcu7t5v0__fillcap_4
Xinput12 tl_i[104] input12/Z VDD VDD VSS VSS gf180mcu_fd_sc_mcu7t5v0__dlyd_1
Xinput45 tl_i[43] input45/Z VDD VDD VSS VSS gf180mcu_fd_sc_mcu7t5v0__dlyd_1
X_3530_ _7886_/I input18/Z _3695_/C _3691_/B2 VDD VDD VSS VSS gf180mcu_fd_sc_mcu7t5v0__nor3_1
Xinput23 tl_i[14] input23/Z VDD VDD VSS VSS gf180mcu_fd_sc_mcu7t5v0__dlyd_1
Xinput34 tl_i[33] input34/Z VDD VDD VSS VSS gf180mcu_fd_sc_mcu7t5v0__dlyd_1
Xinput78 tl_i[73] input78/Z VDD VDD VSS VSS gf180mcu_fd_sc_mcu7t5v0__dlyd_1
Xinput89 tl_i[83] input89/Z VDD VDD VSS VSS gf180mcu_fd_sc_mcu7t5v0__dlyd_1
Xinput67 tl_i[63] input67/Z VDD VDD VSS VSS gf180mcu_fd_sc_mcu7t5v0__dlyd_1
XTAP_TAPCELL_ROW_77_1335 VDD VSS gf180mcu_fd_sc_mcu7t5v0__filltie
Xinput56 tl_i[53] input56/Z VDD VDD VSS VSS gf180mcu_fd_sc_mcu7t5v0__dlyd_1
X_3461_ _7586_/Q _6267_/A1 VDD VDD VSS VSS gf180mcu_fd_sc_mcu7t5v0__clkinv_1
XFILLER_97_600 VDD VDD VSS VSS gf180mcu_fd_sc_mcu7t5v0__fill_2
XTAP_TAPCELL_ROW_90_1524 VDD VSS gf180mcu_fd_sc_mcu7t5v0__filltie
XTAP_TAPCELL_ROW_90_1513 VDD VSS gf180mcu_fd_sc_mcu7t5v0__filltie
X_5200_ _5235_/I0 _7347_/Q _5204_/S _7347_/D VDD VDD VSS VSS gf180mcu_fd_sc_mcu7t5v0__mux2_2
X_3392_ _7736_/Q _4161_/A2 VDD VDD VSS VSS gf180mcu_fd_sc_mcu7t5v0__clkinv_1
X_6180_ _7155_/Q _6235_/B1 _6236_/B1 _7141_/Q _6182_/A1 VDD VDD VSS VSS gf180mcu_fd_sc_mcu7t5v0__oai22_1
X_5131_ _7280_/Q _5134_/A2 _5132_/B VDD VDD VSS VSS gf180mcu_fd_sc_mcu7t5v0__nand2_1
XTAP_TAPCELL_ROW_4_309 VDD VSS gf180mcu_fd_sc_mcu7t5v0__filltie
X_5062_ _5076_/A1 _5064_/A2 _5062_/B _7245_/D VDD VDD VSS VSS gf180mcu_fd_sc_mcu7t5v0__oai21_1
X_4013_ _6757_/Q _4518_/A2 _4014_/B VDD VDD VSS VSS gf180mcu_fd_sc_mcu7t5v0__nand2_1
XTAP_TAPCELL_ROW_88_1497 VDD VSS gf180mcu_fd_sc_mcu7t5v0__filltie
XTAP_TAPCELL_ROW_88_1486 VDD VSS gf180mcu_fd_sc_mcu7t5v0__filltie
XFILLER_65_596 VDD VDD VSS VSS gf180mcu_fd_sc_mcu7t5v0__fillcap_4
X_5964_ _5964_/A1 _5964_/A2 _6122_/C _5994_/A2 VDD VDD VSS VSS gf180mcu_fd_sc_mcu7t5v0__oai21_1
X_7703_ _7703_/D _7703_/RN _7703_/CLK _7703_/Q VDD VDD VSS VSS gf180mcu_fd_sc_mcu7t5v0__dffrnq_1
X_5895_ _7025_/Q _6144_/A2 _6153_/B1 _7011_/Q _6208_/C _5896_/A2 VDD VDD VSS VSS gf180mcu_fd_sc_mcu7t5v0__oai221_1
X_4915_ _7172_/Q _4924_/A2 _4916_/B VDD VDD VSS VSS gf180mcu_fd_sc_mcu7t5v0__nand2_1
X_7634_ _7634_/D _7709_/RN _7711_/CLK _7634_/Q VDD VDD VSS VSS gf180mcu_fd_sc_mcu7t5v0__dffrnq_1
X_4846_ _5098_/A1 _4854_/A2 _4846_/B _7137_/D VDD VDD VSS VSS gf180mcu_fd_sc_mcu7t5v0__oai21_1
X_7565_ _7565_/D _7780_/RN _7780_/CLK _7565_/Q VDD VDD VSS VSS gf180mcu_fd_sc_mcu7t5v0__dffrnq_1
X_6516_ _7679_/Q _7680_/Q _7681_/Q _6516_/A4 _6516_/Z VDD VDD VSS VSS gf180mcu_fd_sc_mcu7t5v0__and4_1
XTAP_TAPCELL_ROW_31_694 VDD VSS gf180mcu_fd_sc_mcu7t5v0__filltie
X_4777_ _7103_/Q _4784_/A2 _4778_/B VDD VDD VSS VSS gf180mcu_fd_sc_mcu7t5v0__nand2_1
X_7496_ _7496_/D _7500_/CLK _7496_/Q VDD VDD VSS VSS gf180mcu_fd_sc_mcu7t5v0__dffq_1
X_3728_ _3728_/A1 _3727_/I _3728_/Z VDD VDD VSS VSS gf180mcu_fd_sc_mcu7t5v0__xor2_1
X_6447_ _7666_/Q _7532_/Q _6448_/I VDD VDD VSS VSS gf180mcu_fd_sc_mcu7t5v0__nor2_1
X_3659_ _3583_/Z _3626_/Z _3659_/A3 _3651_/Z _3665_/A2 VDD VDD VSS VSS gf180mcu_fd_sc_mcu7t5v0__nand4_1
X_6378_ _7521_/Q _6479_/S _6379_/A2 VDD VDD VSS VSS gf180mcu_fd_sc_mcu7t5v0__nand2_1
XFILLER_102_421 VDD VDD VSS VSS gf180mcu_fd_sc_mcu7t5v0__fill_2
X_5329_ _5343_/I0 _7476_/Q _5330_/S _7476_/D VDD VDD VSS VSS gf180mcu_fd_sc_mcu7t5v0__mux2_2
XTAP_TAPCELL_ROW_110_1793 VDD VSS gf180mcu_fd_sc_mcu7t5v0__filltie
XFILLER_17_906 VDD VDD VSS VSS gf180mcu_fd_sc_mcu7t5v0__fillcap_4
XFILLER_29_766 VDD VDD VSS VSS gf180mcu_fd_sc_mcu7t5v0__fillcap_4
XFILLER_56_552 VDD VDD VSS VSS gf180mcu_fd_sc_mcu7t5v0__fill_1
XFILLER_43_235 VDD VDD VSS VSS gf180mcu_fd_sc_mcu7t5v0__fill_2
XTAP_TAPCELL_ROW_61_1114 VDD VSS gf180mcu_fd_sc_mcu7t5v0__filltie
XFILLER_71_588 VDD VDD VSS VSS gf180mcu_fd_sc_mcu7t5v0__fill_2
XTAP_TAPCELL_ROW_117_1903 VDD VSS gf180mcu_fd_sc_mcu7t5v0__filltie
XTAP_TAPCELL_ROW_59_1087 VDD VSS gf180mcu_fd_sc_mcu7t5v0__filltie
XTAP_TAPCELL_ROW_72_1265 VDD VSS gf180mcu_fd_sc_mcu7t5v0__filltie
X_4700_ wire291/Z _4700_/A2 _4700_/B _7064_/D VDD VDD VSS VSS gf180mcu_fd_sc_mcu7t5v0__oai21_1
XTAP_TAPCELL_ROW_17_499 VDD VSS gf180mcu_fd_sc_mcu7t5v0__filltie
X_5680_ _7554_/Q input34/Z _5687_/S _7554_/D VDD VDD VSS VSS gf180mcu_fd_sc_mcu7t5v0__mux2_2
X_4631_ _7030_/Q _4644_/A2 _4632_/B VDD VDD VSS VSS gf180mcu_fd_sc_mcu7t5v0__nand2_1
XFILLER_30_452 VDD VDD VSS VSS gf180mcu_fd_sc_mcu7t5v0__fill_2
X_4562_ _5122_/A1 _4574_/A2 _4562_/B _6995_/D VDD VDD VSS VSS gf180mcu_fd_sc_mcu7t5v0__oai21_1
X_7350_ _7350_/D _7782_/CLK _7350_/Q VDD VDD VSS VSS gf180mcu_fd_sc_mcu7t5v0__dffq_1
X_4493_ _6961_/Q _4504_/A2 _4494_/B VDD VDD VSS VSS gf180mcu_fd_sc_mcu7t5v0__nand2_1
XFILLER_116_535 VDD VDD VSS VSS gf180mcu_fd_sc_mcu7t5v0__fill_2
X_6301_ _7614_/Q _6301_/A2 _6301_/B1 _7536_/Q _6302_/B2 VDD VDD VSS VSS gf180mcu_fd_sc_mcu7t5v0__aoi22_1
X_7281_ _7281_/D _7683_/CLK _7281_/Q VDD VDD VSS VSS gf180mcu_fd_sc_mcu7t5v0__dffq_1
X_3513_ _7518_/Q _7768_/Q _5633_/B VDD VDD VSS VSS gf180mcu_fd_sc_mcu7t5v0__nand2_1
X_3444_ _7589_/Q _6274_/A1 VDD VDD VSS VSS gf180mcu_fd_sc_mcu7t5v0__clkinv_1
X_6232_ _6790_/Q _6232_/A2 _6232_/B _6234_/A1 VDD VDD VSS VSS gf180mcu_fd_sc_mcu7t5v0__oai21_1
X_6163_ _6163_/A1 _6163_/A2 _6170_/A3 VDD VDD VSS VSS gf180mcu_fd_sc_mcu7t5v0__nor2_1
X_3375_ _7767_/Q _3514_/A1 VDD VDD VSS VSS gf180mcu_fd_sc_mcu7t5v0__clkinv_1
Xload_slew573 _7599_/RN _7611_/RN VDD VDD VSS VSS gf180mcu_fd_sc_mcu7t5v0__buf_4
X_6094_ _6094_/A1 _6094_/A2 _6224_/B _6095_/B2 VDD VDD VSS VSS gf180mcu_fd_sc_mcu7t5v0__oai21_1
X_5114_ _5128_/A1 _5120_/A2 _5114_/B _7271_/D VDD VDD VSS VSS gf180mcu_fd_sc_mcu7t5v0__oai21_1
Xload_slew562 _7791_/RN _7736_/RN VDD VDD VSS VSS gf180mcu_fd_sc_mcu7t5v0__clkbuf_4
Xload_slew551 _7760_/RN _7785_/RN VDD VDD VSS VSS gf180mcu_fd_sc_mcu7t5v0__buf_4
XFILLER_100_947 VDD VDD VSS VSS gf180mcu_fd_sc_mcu7t5v0__fillcap_32
Xload_slew584 _7601_/RN _7671_/RN VDD VDD VSS VSS gf180mcu_fd_sc_mcu7t5v0__clkbuf_4
X_5045_ _7237_/Q _5050_/A2 _5046_/B VDD VDD VSS VSS gf180mcu_fd_sc_mcu7t5v0__nand2_1
XFILLER_38_574 VDD VDD VSS VSS gf180mcu_fd_sc_mcu7t5v0__fillcap_16
XFILLER_93_691 VDD VDD VSS VSS gf180mcu_fd_sc_mcu7t5v0__fill_1
XFILLER_81_831 VDD VDD VSS VSS gf180mcu_fd_sc_mcu7t5v0__fill_1
X_6996_ _6996_/D _7668_/CLK _6996_/Q VDD VDD VSS VSS gf180mcu_fd_sc_mcu7t5v0__dffq_1
XPHY_EDGE_ROW_40_Left_159 VDD VSS gf180mcu_fd_sc_mcu7t5v0__endcap
X_5947_ _5947_/I _7574_/D VDD VDD VSS VSS gf180mcu_fd_sc_mcu7t5v0__clkinv_1
XFILLER_13_419 VDD VDD VSS VSS gf180mcu_fd_sc_mcu7t5v0__fill_1
XTAP_TAPCELL_ROW_36_764 VDD VSS gf180mcu_fd_sc_mcu7t5v0__filltie
X_5878_ _7569_/Q _5878_/A2 _6254_/B1 _7697_/Q _7616_/Q _6271_/B1 _5880_/A1 VDD VDD
+ VSS VSS gf180mcu_fd_sc_mcu7t5v0__aoi222_1
X_7617_ _7617_/D _7701_/RN _7796_/CLK _7617_/Q VDD VDD VSS VSS gf180mcu_fd_sc_mcu7t5v0__dffrnq_1
X_4829_ _7129_/Q _4840_/A2 _4830_/B VDD VDD VSS VSS gf180mcu_fd_sc_mcu7t5v0__nand2_1
X_7548_ _7548_/D _7800_/RN _7796_/CLK _7548_/Q VDD VDD VSS VSS gf180mcu_fd_sc_mcu7t5v0__dffrnq_1
X_7479_ _7479_/D _7489_/CLK _7479_/Q VDD VDD VSS VSS gf180mcu_fd_sc_mcu7t5v0__dffq_1
XTAP_TAPCELL_ROW_112_1833 VDD VSS gf180mcu_fd_sc_mcu7t5v0__filltie
XTAP_TAPCELL_ROW_112_1822 VDD VSS gf180mcu_fd_sc_mcu7t5v0__filltie
XFILLER_89_920 VDD VDD VSS VSS gf180mcu_fd_sc_mcu7t5v0__fillcap_32
XFILLER_88_452 VDD VDD VSS VSS gf180mcu_fd_sc_mcu7t5v0__fill_2
XFILLER_16_257 VDD VDD VSS VSS gf180mcu_fd_sc_mcu7t5v0__fill_1
XFILLER_44_544 VDD VDD VSS VSS gf180mcu_fd_sc_mcu7t5v0__fillcap_4
XFILLER_72_886 VDD VDD VSS VSS gf180mcu_fd_sc_mcu7t5v0__fill_2
XTAP_TAPCELL_ROW_14_458 VDD VSS gf180mcu_fd_sc_mcu7t5v0__filltie
XFILLER_79_474 VDD VDD VSS VSS gf180mcu_fd_sc_mcu7t5v0__fill_1
XFILLER_95_978 VDD VDD VSS VSS gf180mcu_fd_sc_mcu7t5v0__fill_2
XFILLER_63_831 VDD VDD VSS VSS gf180mcu_fd_sc_mcu7t5v0__fillcap_8
XTAP_TAPCELL_ROW_85_1445 VDD VSS gf180mcu_fd_sc_mcu7t5v0__filltie
X_6850_ _6850_/D _7724_/CLK _6850_/Q VDD VDD VSS VSS gf180mcu_fd_sc_mcu7t5v0__dffq_1
XFILLER_63_842 VDD VDD VSS VSS gf180mcu_fd_sc_mcu7t5v0__fillcap_4
X_5801_ _5801_/A1 _5801_/A2 _5805_/B1 VDD VDD VSS VSS gf180mcu_fd_sc_mcu7t5v0__nor2_1
XPHY_EDGE_ROW_8_Right_8 VDD VSS gf180mcu_fd_sc_mcu7t5v0__endcap
X_6781_ _6781_/D _7453_/CLK _6781_/Q VDD VDD VSS VSS gf180mcu_fd_sc_mcu7t5v0__dffq_1
X_3993_ _4132_/A1 _3999_/A2 _4434_/A2 VDD VDD VSS VSS gf180mcu_fd_sc_mcu7t5v0__nand2_1
X_5732_ _5732_/A1 _5732_/A2 _5732_/A3 _5732_/A4 _5733_/I VDD VDD VSS VSS gf180mcu_fd_sc_mcu7t5v0__nand4_1
XTAP_TAPCELL_ROW_33_723 VDD VSS gf180mcu_fd_sc_mcu7t5v0__filltie
XFILLER_31_772 VDD VDD VSS VSS gf180mcu_fd_sc_mcu7t5v0__fillcap_64
X_5663_ _7544_/Q input29/Z _5663_/S _7544_/D VDD VDD VSS VSS gf180mcu_fd_sc_mcu7t5v0__mux2_2
X_4614_ _4964_/A1 _4616_/A2 _4614_/B _7021_/D VDD VDD VSS VSS gf180mcu_fd_sc_mcu7t5v0__oai21_1
X_7402_ _7402_/D _7500_/CLK _7402_/Q VDD VDD VSS VSS gf180mcu_fd_sc_mcu7t5v0__dffq_1
X_5594_ _6812_/Q _6632_/A1 _5594_/B1 _6810_/Q _5595_/A3 VDD VDD VSS VSS gf180mcu_fd_sc_mcu7t5v0__oai22_1
X_4545_ _6987_/Q _4546_/A2 _4546_/B VDD VDD VSS VSS gf180mcu_fd_sc_mcu7t5v0__nand2_1
X_7333_ _7333_/D _7378_/CLK _7333_/Q VDD VDD VSS VSS gf180mcu_fd_sc_mcu7t5v0__dffq_1
XTAP_TAPCELL_ROW_96_1596 VDD VSS gf180mcu_fd_sc_mcu7t5v0__filltie
X_4476_ _4532_/A1 _4476_/A2 _4476_/B _6952_/D VDD VDD VSS VSS gf180mcu_fd_sc_mcu7t5v0__oai21_1
X_7264_ _7264_/D _7266_/CLK _7264_/Q VDD VDD VSS VSS gf180mcu_fd_sc_mcu7t5v0__dffq_1
X_3427_ _7765_/Q _6737_/A1 VDD VDD VSS VSS gf180mcu_fd_sc_mcu7t5v0__clkinv_1
XPHY_EDGE_ROW_39_Right_39 VDD VSS gf180mcu_fd_sc_mcu7t5v0__endcap
X_7195_ _7195_/D _7216_/CLK _7195_/Q VDD VDD VSS VSS gf180mcu_fd_sc_mcu7t5v0__dffq_1
X_6215_ _6776_/Q _6215_/A2 _6215_/B1 _6777_/Q _6778_/Q wire353/I _6216_/A2 VDD VDD
+ VSS VSS gf180mcu_fd_sc_mcu7t5v0__oai222_1
X_6146_ _6146_/A1 _6146_/A2 _6156_/A1 VDD VDD VSS VSS gf180mcu_fd_sc_mcu7t5v0__nor2_1
X_3358_ _7754_/Q _3862_/A2 VDD VDD VSS VSS gf180mcu_fd_sc_mcu7t5v0__clkinv_1
Xload_slew392 _6300_/A2 _6284_/A2 VDD VDD VSS VSS gf180mcu_fd_sc_mcu7t5v0__buf_4
XFILLER_85_422 VDD VDD VSS VSS gf180mcu_fd_sc_mcu7t5v0__fill_1
Xload_slew381 _5593_/A2 _5572_/C2 VDD VDD VSS VSS gf180mcu_fd_sc_mcu7t5v0__buf_4
X_6077_ _6909_/Q _6162_/A2 wire322/Z _6888_/Q _6212_/C _6081_/A2 VDD VDD VSS VSS gf180mcu_fd_sc_mcu7t5v0__oai221_1
X_5028_ _5056_/A1 _5036_/A2 _5028_/B _7228_/D VDD VDD VSS VSS gf180mcu_fd_sc_mcu7t5v0__oai21_1
XFILLER_26_588 VDD VDD VSS VSS gf180mcu_fd_sc_mcu7t5v0__fillcap_4
X_6979_ _6979_/D _7276_/CLK _6979_/Q VDD VDD VSS VSS gf180mcu_fd_sc_mcu7t5v0__dffq_1
XPHY_EDGE_ROW_48_Right_48 VDD VSS gf180mcu_fd_sc_mcu7t5v0__endcap
XTAP_TAPCELL_ROW_11_417 VDD VSS gf180mcu_fd_sc_mcu7t5v0__filltie
XTAP_TAPCELL_ROW_11_406 VDD VSS gf180mcu_fd_sc_mcu7t5v0__filltie
XFILLER_21_282 VDD VDD VSS VSS gf180mcu_fd_sc_mcu7t5v0__fill_1
Xclkbuf_leaf_6_clk_i clkload0/I _7790_/CLK VDD VDD VSS VSS gf180mcu_fd_sc_mcu7t5v0__clkbuf_8
XTAP_TAPCELL_ROW_56_1046 VDD VSS gf180mcu_fd_sc_mcu7t5v0__filltie
XPHY_EDGE_ROW_57_Right_57 VDD VSS gf180mcu_fd_sc_mcu7t5v0__endcap
XFILLER_1_632 VDD VDD VSS VSS gf180mcu_fd_sc_mcu7t5v0__fillcap_64
XFILLER_89_772 VDD VDD VSS VSS gf180mcu_fd_sc_mcu7t5v0__fillcap_8
XTAP_TAPCELL_ROW_19_528 VDD VSS gf180mcu_fd_sc_mcu7t5v0__filltie
XFILLER_29_360 VDD VDD VSS VSS gf180mcu_fd_sc_mcu7t5v0__fill_1
XFILLER_45_842 VDD VDD VSS VSS gf180mcu_fd_sc_mcu7t5v0__fillcap_64
XFILLER_60_801 VDD VDD VSS VSS gf180mcu_fd_sc_mcu7t5v0__fillcap_4
XPHY_EDGE_ROW_66_Right_66 VDD VSS gf180mcu_fd_sc_mcu7t5v0__endcap
XFILLER_32_547 VDD VDD VSS VSS gf180mcu_fd_sc_mcu7t5v0__fillcap_32
XTAP_TAPCELL_ROW_67_1197 VDD VSS gf180mcu_fd_sc_mcu7t5v0__filltie
XTAP_TAPCELL_ROW_80_1375 VDD VSS gf180mcu_fd_sc_mcu7t5v0__filltie
XFILLER_13_772 VDD VDD VSS VSS gf180mcu_fd_sc_mcu7t5v0__fillcap_64
XFILLER_40_591 VDD VDD VSS VSS gf180mcu_fd_sc_mcu7t5v0__fillcap_4
XFILLER_8_297 VDD VDD VSS VSS gf180mcu_fd_sc_mcu7t5v0__fill_2
XPHY_EDGE_ROW_75_Right_75 VDD VSS gf180mcu_fd_sc_mcu7t5v0__endcap
X_4330_ _4946_/A1 _4336_/A2 _4330_/B _6879_/D VDD VDD VSS VSS gf180mcu_fd_sc_mcu7t5v0__oai21_1
X_4261_ _6845_/Q _4266_/A2 _4262_/B VDD VDD VSS VSS gf180mcu_fd_sc_mcu7t5v0__nand2_1
XPHY_EDGE_ROW_105_Left_224 VDD VSS gf180mcu_fd_sc_mcu7t5v0__endcap
X_6000_ _6136_/B _6000_/A2 _6000_/B _6246_/C _6001_/I VDD VDD VSS VSS gf180mcu_fd_sc_mcu7t5v0__oai211_1
XFILLER_79_282 VDD VDD VSS VSS gf180mcu_fd_sc_mcu7t5v0__fill_1
X_4192_ wire507/Z _6813_/Q _5218_/S _6813_/D VDD VDD VSS VSS gf180mcu_fd_sc_mcu7t5v0__mux2_2
XFILLER_67_422 VDD VDD VSS VSS gf180mcu_fd_sc_mcu7t5v0__fill_2
XFILLER_83_926 VDD VDD VSS VSS gf180mcu_fd_sc_mcu7t5v0__fillcap_32
XPHY_EDGE_ROW_84_Right_84 VDD VSS gf180mcu_fd_sc_mcu7t5v0__endcap
XFILLER_55_628 VDD VDD VSS VSS gf180mcu_fd_sc_mcu7t5v0__fill_2
X_6902_ _6902_/D _7008_/CLK _6902_/Q VDD VDD VSS VSS gf180mcu_fd_sc_mcu7t5v0__dffq_1
X_7882_ _7882_/I _7882_/Z VDD VDD VSS VSS gf180mcu_fd_sc_mcu7t5v0__buf_1
X_6833_ _6833_/D _7504_/CLK _6833_/Q VDD VDD VSS VSS gf180mcu_fd_sc_mcu7t5v0__dffq_1
XFILLER_35_352 VDD VDD VSS VSS gf180mcu_fd_sc_mcu7t5v0__fill_2
XPHY_EDGE_ROW_114_Left_233 VDD VSS gf180mcu_fd_sc_mcu7t5v0__endcap
X_3976_ wire248/Z _4350_/A2 _3976_/B _6745_/D VDD VDD VSS VSS gf180mcu_fd_sc_mcu7t5v0__oai21_1
X_6764_ _6764_/D _7261_/CLK _6764_/Q VDD VDD VSS VSS gf180mcu_fd_sc_mcu7t5v0__dffq_1
X_5715_ _5715_/A1 _5715_/A2 _5720_/A1 VDD VDD VSS VSS gf180mcu_fd_sc_mcu7t5v0__nand2_1
X_6695_ _7540_/Q _6695_/A2 _6696_/B VDD VDD VSS VSS gf180mcu_fd_sc_mcu7t5v0__nand2_1
X_5646_ _7529_/Q input56/Z _5651_/S _7529_/D VDD VDD VSS VSS gf180mcu_fd_sc_mcu7t5v0__mux2_2
XTAP_TAPCELL_ROW_98_1636 VDD VSS gf180mcu_fd_sc_mcu7t5v0__filltie
XTAP_TAPCELL_ROW_98_1625 VDD VSS gf180mcu_fd_sc_mcu7t5v0__filltie
XPHY_EDGE_ROW_93_Right_93 VDD VSS gf180mcu_fd_sc_mcu7t5v0__endcap
XFILLER_117_663 VDD VDD VSS VSS gf180mcu_fd_sc_mcu7t5v0__fill_1
X_5577_ _7456_/Q _5597_/A2 _5577_/B _5582_/A1 VDD VDD VSS VSS gf180mcu_fd_sc_mcu7t5v0__oai21_1
X_4528_ _4584_/A1 _4532_/A2 _4528_/B _6978_/D VDD VDD VSS VSS gf180mcu_fd_sc_mcu7t5v0__oai21_1
X_7316_ _7316_/D _7491_/CLK _7316_/Q VDD VDD VSS VSS gf180mcu_fd_sc_mcu7t5v0__dffq_1
X_4459_ _6944_/Q _4462_/A2 _4460_/B VDD VDD VSS VSS gf180mcu_fd_sc_mcu7t5v0__nand2_1
X_7247_ _7247_/D _7247_/CLK _7247_/Q VDD VDD VSS VSS gf180mcu_fd_sc_mcu7t5v0__dffq_1
XFILLER_59_912 VDD VDD VSS VSS gf180mcu_fd_sc_mcu7t5v0__fillcap_64
X_7178_ _7178_/D _7748_/CLK _7178_/Q VDD VDD VSS VSS gf180mcu_fd_sc_mcu7t5v0__dffq_1
X_6129_ _6129_/A1 _6129_/A2 _6129_/A3 _6129_/A4 _6129_/Z VDD VDD VSS VSS gf180mcu_fd_sc_mcu7t5v0__and4_1
XFILLER_105_98 VDD VDD VSS VSS gf180mcu_fd_sc_mcu7t5v0__fill_1
XFILLER_27_842 VDD VDD VSS VSS gf180mcu_fd_sc_mcu7t5v0__fillcap_64
XTAP_TAPCELL_ROW_107_1754 VDD VSS gf180mcu_fd_sc_mcu7t5v0__filltie
XFILLER_82_981 VDD VDD VSS VSS gf180mcu_fd_sc_mcu7t5v0__fill_1
XFILLER_42_801 VDD VDD VSS VSS gf180mcu_fd_sc_mcu7t5v0__fillcap_4
XFILLER_10_731 VDD VDD VSS VSS gf180mcu_fd_sc_mcu7t5v0__fillcap_4
XTAP_TAPCELL_ROW_24_597 VDD VSS gf180mcu_fd_sc_mcu7t5v0__filltie
XFILLER_5_212 VDD VDD VSS VSS gf180mcu_fd_sc_mcu7t5v0__fill_2
XFILLER_2_941 VDD VDD VSS VSS gf180mcu_fd_sc_mcu7t5v0__fillcap_4
XFILLER_104_891 VDD VDD VSS VSS gf180mcu_fd_sc_mcu7t5v0__fillcap_8
XFILLER_49_422 VDD VDD VSS VSS gf180mcu_fd_sc_mcu7t5v0__fill_2
XFILLER_65_926 VDD VDD VSS VSS gf180mcu_fd_sc_mcu7t5v0__fillcap_32
XTAP_TAPCELL_ROW_69_1226 VDD VSS gf180mcu_fd_sc_mcu7t5v0__filltie
XTAP_TAPCELL_ROW_82_1404 VDD VSS gf180mcu_fd_sc_mcu7t5v0__filltie
XFILLER_55_91 VDD VDD VSS VSS gf180mcu_fd_sc_mcu7t5v0__fill_2
X_3830_ _7593_/Q _7592_/Q _3830_/Z VDD VDD VSS VSS gf180mcu_fd_sc_mcu7t5v0__xor2_1
XTAP_TAPCELL_ROW_43_862 VDD VSS gf180mcu_fd_sc_mcu7t5v0__filltie
X_3761_ _7561_/Q _7779_/D _7803_/D VDD VDD VSS VSS gf180mcu_fd_sc_mcu7t5v0__and2_1
XFILLER_9_562 VDD VDD VSS VSS gf180mcu_fd_sc_mcu7t5v0__fillcap_64
X_5500_ _7412_/Q _5542_/A2 _5520_/A2 VDD VDD VSS VSS gf180mcu_fd_sc_mcu7t5v0__nor2_1
X_6480_ _7802_/Q _7802_/D _6521_/A1 VDD VDD VSS VSS gf180mcu_fd_sc_mcu7t5v0__xnor2_1
X_3692_ _3378_/I input24/Z _3693_/A4 VDD VDD VSS VSS gf180mcu_fd_sc_mcu7t5v0__nand2_1
X_5431_ _5431_/I0 _5431_/I1 _5493_/S _5431_/Z VDD VDD VSS VSS gf180mcu_fd_sc_mcu7t5v0__mux2_2
X_5362_ _5359_/Z _6732_/A1 _6733_/A4 VDD VDD VSS VSS gf180mcu_fd_sc_mcu7t5v0__nor2_1
XTAP_TAPCELL_ROW_93_1566 VDD VSS gf180mcu_fd_sc_mcu7t5v0__filltie
XTAP_TAPCELL_ROW_93_1555 VDD VSS gf180mcu_fd_sc_mcu7t5v0__filltie
X_4313_ _6871_/Q _4322_/A2 _4314_/B VDD VDD VSS VSS gf180mcu_fd_sc_mcu7t5v0__nand2_1
X_7101_ _7101_/D _7101_/CLK _7101_/Q VDD VDD VSS VSS gf180mcu_fd_sc_mcu7t5v0__dffq_1
X_7032_ _7032_/D _7060_/CLK _7032_/Q VDD VDD VSS VSS gf180mcu_fd_sc_mcu7t5v0__dffq_1
X_5293_ _5342_/I0 _7440_/Q _5295_/S _7440_/D VDD VDD VSS VSS gf180mcu_fd_sc_mcu7t5v0__mux2_2
X_4244_ _4832_/A1 _4252_/A2 _4244_/B _6836_/D VDD VDD VSS VSS gf180mcu_fd_sc_mcu7t5v0__oai21_1
X_4175_ _4238_/I0 _6806_/Q _5169_/S _6806_/D VDD VDD VSS VSS gf180mcu_fd_sc_mcu7t5v0__mux2_2
XFILLER_24_801 VDD VDD VSS VSS gf180mcu_fd_sc_mcu7t5v0__fillcap_4
XFILLER_36_661 VDD VDD VSS VSS gf180mcu_fd_sc_mcu7t5v0__fillcap_4
XFILLER_64_981 VDD VDD VSS VSS gf180mcu_fd_sc_mcu7t5v0__fill_1
XFILLER_35_171 VDD VDD VSS VSS gf180mcu_fd_sc_mcu7t5v0__fill_2
X_6816_ _6816_/D _7735_/CLK _6816_/Q VDD VDD VSS VSS gf180mcu_fd_sc_mcu7t5v0__dffq_1
Xclkbuf_leaf_71_clk_i clkload3/I _7451_/CLK VDD VDD VSS VSS gf180mcu_fd_sc_mcu7t5v0__clkbuf_8
XFILLER_51_675 VDD VDD VSS VSS gf180mcu_fd_sc_mcu7t5v0__fillcap_4
X_7796_ _7796_/D _7799_/RN _7796_/CLK _7796_/Q VDD VDD VSS VSS gf180mcu_fd_sc_mcu7t5v0__dffrnq_1
X_6747_ _6747_/D _6939_/CLK _6747_/Q VDD VDD VSS VSS gf180mcu_fd_sc_mcu7t5v0__dffq_1
XTAP_TAPCELL_ROW_102_1684 VDD VSS gf180mcu_fd_sc_mcu7t5v0__filltie
X_3959_ _4150_/A1 _4132_/A1 _4308_/A2 VDD VDD VSS VSS gf180mcu_fd_sc_mcu7t5v0__nand2_1
XFILLER_109_438 VDD VDD VSS VSS gf180mcu_fd_sc_mcu7t5v0__fill_1
XTAP_TAPCELL_ROW_21_556 VDD VSS gf180mcu_fd_sc_mcu7t5v0__filltie
X_6678_ _6678_/I _6717_/A2 VDD VDD VSS VSS gf180mcu_fd_sc_mcu7t5v0__clkinv_1
Xclkbuf_leaf_86_clk_i clkload0/I _7482_/CLK VDD VDD VSS VSS gf180mcu_fd_sc_mcu7t5v0__clkbuf_8
X_5629_ _5629_/I _7515_/D VDD VDD VSS VSS gf180mcu_fd_sc_mcu7t5v0__clkinv_1
Xuart_614 racl_error_o[18] VDD VDD VSS VSS gf180mcu_fd_sc_mcu7t5v0__tiel
Xuart_603 racl_error_o[7] VDD VDD VSS VSS gf180mcu_fd_sc_mcu7t5v0__tiel
XTAP_TAPCELL_ROW_53_1005 VDD VSS gf180mcu_fd_sc_mcu7t5v0__filltie
Xfanout541 _7827_/RN _7823_/RN VDD VDD VSS VSS gf180mcu_fd_sc_mcu7t5v0__dlyd_1
Xuart_636 racl_error_o[40] VDD VDD VSS VSS gf180mcu_fd_sc_mcu7t5v0__tiel
Xuart_647 cio_tx_en_o VDD VDD VSS VSS gf180mcu_fd_sc_mcu7t5v0__tieh
Xuart_625 racl_error_o[29] VDD VDD VSS VSS gf180mcu_fd_sc_mcu7t5v0__tiel
XFILLER_101_850 VDD VDD VSS VSS gf180mcu_fd_sc_mcu7t5v0__fill_1
Xfanout574 _7601_/RN _7613_/RN VDD VDD VSS VSS gf180mcu_fd_sc_mcu7t5v0__dlyd_1
Xfanout552 input6/Z _7653_/RN VDD VDD VSS VSS gf180mcu_fd_sc_mcu7t5v0__dlyd_1
Xfanout563 input6/Z wire565/I VDD VDD VSS VSS gf180mcu_fd_sc_mcu7t5v0__dlyd_1
XFILLER_74_734 VDD VDD VSS VSS gf180mcu_fd_sc_mcu7t5v0__fill_1
Xfanout585 _7798_/RN _7560_/RN VDD VDD VSS VSS gf180mcu_fd_sc_mcu7t5v0__dlyd_1
Xclkbuf_leaf_24_clk_i clkload1/I _7671_/CLK VDD VDD VSS VSS gf180mcu_fd_sc_mcu7t5v0__clkbuf_8
XFILLER_74_745 VDD VDD VSS VSS gf180mcu_fd_sc_mcu7t5v0__fillcap_4
XTAP_TAPCELL_ROW_1_270 VDD VSS gf180mcu_fd_sc_mcu7t5v0__filltie
XTAP_TAPCELL_ROW_29_667 VDD VSS gf180mcu_fd_sc_mcu7t5v0__filltie
Xclkbuf_leaf_39_clk_i clkload6/I _7254_/CLK VDD VDD VSS VSS gf180mcu_fd_sc_mcu7t5v0__clkbuf_8
XTAP_TAPCELL_ROW_64_1156 VDD VSS gf180mcu_fd_sc_mcu7t5v0__filltie
XTAP_TAPCELL_ROW_40_821 VDD VSS gf180mcu_fd_sc_mcu7t5v0__filltie
XFILLER_10_594 VDD VDD VSS VSS gf180mcu_fd_sc_mcu7t5v0__fill_1
XFILLER_69_506 VDD VDD VSS VSS gf180mcu_fd_sc_mcu7t5v0__fillcap_4
XFILLER_96_314 VDD VDD VSS VSS gf180mcu_fd_sc_mcu7t5v0__fill_1
XTAP_TAPCELL_ROW_9_381 VDD VSS gf180mcu_fd_sc_mcu7t5v0__filltie
XTAP_TAPCELL_ROW_48_932 VDD VSS gf180mcu_fd_sc_mcu7t5v0__filltie
X_5980_ _7033_/Q _6207_/A2 wire355/I _7026_/Q _7019_/Q _6207_/B1 _5981_/A2 VDD VDD
+ VSS VSS gf180mcu_fd_sc_mcu7t5v0__oai222_1
XFILLER_18_661 VDD VDD VSS VSS gf180mcu_fd_sc_mcu7t5v0__fillcap_4
XFILLER_46_981 VDD VDD VSS VSS gf180mcu_fd_sc_mcu7t5v0__fill_1
XFILLER_80_737 VDD VDD VSS VSS gf180mcu_fd_sc_mcu7t5v0__fill_2
X_4931_ _7180_/Q _4938_/A2 _4932_/B VDD VDD VSS VSS gf180mcu_fd_sc_mcu7t5v0__nand2_1
X_4862_ _5086_/A1 _4868_/A2 _4862_/B _7145_/D VDD VDD VSS VSS gf180mcu_fd_sc_mcu7t5v0__oai21_1
X_7650_ _7650_/D _7742_/RN _7792_/CLK _7650_/Q VDD VDD VSS VSS gf180mcu_fd_sc_mcu7t5v0__dffrnq_1
XFILLER_20_314 VDD VDD VSS VSS gf180mcu_fd_sc_mcu7t5v0__fill_1
X_3813_ _7772_/Q _3812_/Z _3901_/A1 VDD VDD VSS VSS gf180mcu_fd_sc_mcu7t5v0__nand2_1
XFILLER_32_174 VDD VDD VSS VSS gf180mcu_fd_sc_mcu7t5v0__fill_1
X_6601_ _6601_/A1 _6600_/Z _6601_/B _7716_/D VDD VDD VSS VSS gf180mcu_fd_sc_mcu7t5v0__oai21_1
X_7581_ _7581_/D _7613_/RN _7613_/CLK _7581_/Q VDD VDD VSS VSS gf180mcu_fd_sc_mcu7t5v0__dffrnq_1
X_4793_ _7111_/Q _4798_/A2 _4794_/B VDD VDD VSS VSS gf180mcu_fd_sc_mcu7t5v0__nand2_1
XANTENNA_15 alert_rx_i[1] VDD VDD VSS VSS gf180mcu_fd_sc_mcu7t5v0__antenna
X_6532_ _6538_/A1 _6532_/A2 _6531_/Z _7686_/D VDD VDD VSS VSS gf180mcu_fd_sc_mcu7t5v0__nor3_1
X_3744_ _7547_/Q _7546_/Q _5665_/A1 _3748_/B1 VDD VDD VSS VSS gf180mcu_fd_sc_mcu7t5v0__nand3_1
X_6463_ _6463_/A1 _6463_/A2 _6463_/Z VDD VDD VSS VSS gf180mcu_fd_sc_mcu7t5v0__xor2_1
X_3675_ _3385_/I _3675_/A2 _3675_/B _3676_/A2 VDD VDD VSS VSS gf180mcu_fd_sc_mcu7t5v0__aoi21_1
X_5414_ _7283_/Q _5607_/B1 _5416_/A2 VDD VDD VSS VSS gf180mcu_fd_sc_mcu7t5v0__nor2_1
Xoutput133 _7574_/Q tl_o[18] VDD VDD VSS VSS gf180mcu_fd_sc_mcu7t5v0__dlyd_1
X_6394_ _6387_/Z _6394_/A2 _6394_/B _6400_/A2 VDD VDD VSS VSS gf180mcu_fd_sc_mcu7t5v0__aoi21_1
Xoutput111 _7809_/Q intr_rx_break_err_o VDD VDD VSS VSS gf180mcu_fd_sc_mcu7t5v0__dlyd_1
Xoutput122 _7880_/Z racl_error_o[3] VDD VDD VSS VSS gf180mcu_fd_sc_mcu7t5v0__dlyd_1
Xoutput166 _7604_/Q tl_o[49] VDD VDD VSS VSS gf180mcu_fd_sc_mcu7t5v0__dlyd_1
Xoutput144 _7584_/Q tl_o[28] VDD VDD VSS VSS gf180mcu_fd_sc_mcu7t5v0__dlyd_1
Xoutput177 _3918_/Z tl_o[5] VDD VDD VSS VSS gf180mcu_fd_sc_mcu7t5v0__dlyd_1
Xoutput155 _7594_/Q tl_o[38] VDD VDD VSS VSS gf180mcu_fd_sc_mcu7t5v0__dlyd_1
X_5345_ _5345_/I0 _7492_/Q _5351_/S _7492_/D VDD VDD VSS VSS gf180mcu_fd_sc_mcu7t5v0__mux2_2
X_5276_ _5304_/I0 _7423_/Q _5281_/S _7423_/D VDD VDD VSS VSS gf180mcu_fd_sc_mcu7t5v0__mux2_2
X_7015_ _7015_/D _7097_/CLK _7015_/Q VDD VDD VSS VSS gf180mcu_fd_sc_mcu7t5v0__dffq_1
X_4227_ _4235_/A1 _4233_/A2 _5323_/S VDD VDD VSS VSS gf180mcu_fd_sc_mcu7t5v0__nand2_1
X_4158_ _4235_/A1 _4224_/A1 _5141_/S VDD VDD VSS VSS gf180mcu_fd_sc_mcu7t5v0__nand2_1
X_4089_ _4150_/A2 _4110_/A2 _4854_/A2 VDD VDD VSS VSS gf180mcu_fd_sc_mcu7t5v0__nand2_1
XTAP_TAPCELL_ROW_104_1713 VDD VSS gf180mcu_fd_sc_mcu7t5v0__filltie
XTAP_TAPCELL_ROW_26_626 VDD VSS gf180mcu_fd_sc_mcu7t5v0__filltie
XFILLER_70_258 VDD VDD VSS VSS gf180mcu_fd_sc_mcu7t5v0__fill_1
X_7779_ _7779_/D _7780_/RN _7782_/CLK _7779_/Q VDD VDD VSS VSS gf180mcu_fd_sc_mcu7t5v0__dffsnq_1
XFILLER_118_780 VDD VDD VSS VSS gf180mcu_fd_sc_mcu7t5v0__fill_2
XTAP_TAPCELL_ROW_115_1875 VDD VSS gf180mcu_fd_sc_mcu7t5v0__filltie
XTAP_TAPCELL_ROW_115_1864 VDD VSS gf180mcu_fd_sc_mcu7t5v0__filltie
XFILLER_79_837 VDD VDD VSS VSS gf180mcu_fd_sc_mcu7t5v0__fill_2
XTAP_TAPCELL_ROW_6_340 VDD VSS gf180mcu_fd_sc_mcu7t5v0__filltie
Xfanout393 _5883_/C _5744_/B VDD VDD VSS VSS gf180mcu_fd_sc_mcu7t5v0__dlyd_1
Xfanout382 _5613_/A2 _5610_/B1 VDD VDD VSS VSS gf180mcu_fd_sc_mcu7t5v0__dlyd_1
XFILLER_28_981 VDD VDD VSS VSS gf180mcu_fd_sc_mcu7t5v0__fill_1
Xinput13 tl_i[105] _3681_/C VDD VDD VSS VSS gf180mcu_fd_sc_mcu7t5v0__dlyd_1
XFILLER_30_667 VDD VDD VSS VSS gf180mcu_fd_sc_mcu7t5v0__fillcap_64
Xinput46 tl_i[44] input46/Z VDD VDD VSS VSS gf180mcu_fd_sc_mcu7t5v0__dlyd_1
Xinput35 tl_i[34] input35/Z VDD VDD VSS VSS gf180mcu_fd_sc_mcu7t5v0__dlyd_1
Xinput24 tl_i[15] input24/Z VDD VDD VSS VSS gf180mcu_fd_sc_mcu7t5v0__dlyd_1
Xinput79 tl_i[74] input79/Z VDD VDD VSS VSS gf180mcu_fd_sc_mcu7t5v0__dlyd_1
XTAP_TAPCELL_ROW_77_1336 VDD VSS gf180mcu_fd_sc_mcu7t5v0__filltie
Xinput68 tl_i[64] input68/Z VDD VDD VSS VSS gf180mcu_fd_sc_mcu7t5v0__dlyd_1
Xinput57 tl_i[54] input57/Z VDD VDD VSS VSS gf180mcu_fd_sc_mcu7t5v0__dlyd_1
X_3460_ _7603_/Q _6302_/A1 VDD VDD VSS VSS gf180mcu_fd_sc_mcu7t5v0__clkinv_1
XTAP_TAPCELL_ROW_90_1525 VDD VSS gf180mcu_fd_sc_mcu7t5v0__filltie
XTAP_TAPCELL_ROW_90_1514 VDD VSS gf180mcu_fd_sc_mcu7t5v0__filltie
X_3391_ _7735_/Q _4221_/A1 VDD VDD VSS VSS gf180mcu_fd_sc_mcu7t5v0__clkinv_1
X_5130_ _5130_/A1 _5134_/A2 _5130_/B _7279_/D VDD VDD VSS VSS gf180mcu_fd_sc_mcu7t5v0__oai21_1
XFILLER_97_623 VDD VDD VSS VSS gf180mcu_fd_sc_mcu7t5v0__fill_2
X_5061_ _7245_/Q _5064_/A2 _5062_/B VDD VDD VSS VSS gf180mcu_fd_sc_mcu7t5v0__nand2_1
X_4012_ _4012_/A1 _4027_/A2 _4518_/A2 VDD VDD VSS VSS gf180mcu_fd_sc_mcu7t5v0__nand2_1
XTAP_TAPCELL_ROW_88_1487 VDD VSS gf180mcu_fd_sc_mcu7t5v0__filltie
X_5963_ _6879_/Q _6593_/A2 _6201_/A2 _6858_/Q _6201_/C _5964_/A2 VDD VDD VSS VSS gf180mcu_fd_sc_mcu7t5v0__oai221_1
X_4914_ _4942_/A1 _4924_/A2 _4914_/B _7171_/D VDD VDD VSS VSS gf180mcu_fd_sc_mcu7t5v0__oai21_1
X_7702_ _7702_/D _7703_/RN _7703_/CLK _7702_/Q VDD VDD VSS VSS gf180mcu_fd_sc_mcu7t5v0__dffrnq_1
X_5894_ _7032_/Q _6153_/A2 wire313/I _7018_/Q _5896_/A1 VDD VDD VSS VSS gf180mcu_fd_sc_mcu7t5v0__oai22_1
X_7633_ _7633_/D _7695_/RN _7695_/CLK _7633_/Q VDD VDD VSS VSS gf180mcu_fd_sc_mcu7t5v0__dffrnq_1
X_4845_ _7137_/Q _4854_/A2 _4846_/B VDD VDD VSS VSS gf180mcu_fd_sc_mcu7t5v0__nand2_1
X_7564_ _7564_/D _7705_/RN _7703_/CLK _7564_/Q VDD VDD VSS VSS gf180mcu_fd_sc_mcu7t5v0__dffrnq_1
X_4776_ _5070_/A1 _4784_/A2 _4776_/B _7102_/D VDD VDD VSS VSS gf180mcu_fd_sc_mcu7t5v0__oai21_1
X_6515_ _6538_/A1 _6514_/Z _7680_/D VDD VDD VSS VSS gf180mcu_fd_sc_mcu7t5v0__nor2_1
XTAP_TAPCELL_ROW_31_695 VDD VSS gf180mcu_fd_sc_mcu7t5v0__filltie
X_3727_ _3727_/I _4154_/A1 VDD VDD VSS VSS gf180mcu_fd_sc_mcu7t5v0__clkinv_1
X_7495_ _7495_/D _7505_/CLK _7495_/Q VDD VDD VSS VSS gf180mcu_fd_sc_mcu7t5v0__dffq_1
X_6446_ _6446_/I _6454_/A3 VDD VDD VSS VSS gf180mcu_fd_sc_mcu7t5v0__clkinv_1
X_3658_ _3658_/A1 _3658_/A2 _3666_/A1 VDD VDD VSS VSS gf180mcu_fd_sc_mcu7t5v0__nor2_1
XFILLER_115_761 VDD VDD VSS VSS gf180mcu_fd_sc_mcu7t5v0__fillcap_8
XFILLER_103_901 VDD VDD VSS VSS gf180mcu_fd_sc_mcu7t5v0__fill_1
X_6377_ _7544_/Q _7540_/Q _6479_/S VDD VDD VSS VSS gf180mcu_fd_sc_mcu7t5v0__or2_1
X_3589_ input43/Z input51/Z _3589_/Z VDD VDD VSS VSS gf180mcu_fd_sc_mcu7t5v0__xor2_1
XFILLER_115_772 VDD VDD VSS VSS gf180mcu_fd_sc_mcu7t5v0__fillcap_64
XFILLER_103_912 VDD VDD VSS VSS gf180mcu_fd_sc_mcu7t5v0__fillcap_64
X_5328_ _5342_/I0 _7475_/Q _5330_/S _7475_/D VDD VDD VSS VSS gf180mcu_fd_sc_mcu7t5v0__mux2_2
X_5259_ wire517/Z _7406_/Q _5260_/S _7406_/D VDD VDD VSS VSS gf180mcu_fd_sc_mcu7t5v0__mux2_2
XTAP_TAPCELL_ROW_110_1794 VDD VSS gf180mcu_fd_sc_mcu7t5v0__filltie
XFILLER_28_255 VDD VDD VSS VSS gf180mcu_fd_sc_mcu7t5v0__fill_1
XFILLER_56_542 VDD VDD VSS VSS gf180mcu_fd_sc_mcu7t5v0__fillcap_8
XFILLER_44_726 VDD VDD VSS VSS gf180mcu_fd_sc_mcu7t5v0__fillcap_8
XFILLER_44_737 VDD VDD VSS VSS gf180mcu_fd_sc_mcu7t5v0__fillcap_64
XFILLER_71_556 VDD VDD VSS VSS gf180mcu_fd_sc_mcu7t5v0__fillcap_4
XTAP_TAPCELL_ROW_61_1115 VDD VSS gf180mcu_fd_sc_mcu7t5v0__filltie
XFILLER_12_667 VDD VDD VSS VSS gf180mcu_fd_sc_mcu7t5v0__fillcap_64
XTAP_TAPCELL_ROW_50_960 VDD VSS gf180mcu_fd_sc_mcu7t5v0__filltie
XFILLER_4_877 VDD VDD VSS VSS gf180mcu_fd_sc_mcu7t5v0__fillcap_64
XTAP_TAPCELL_ROW_59_1088 VDD VSS gf180mcu_fd_sc_mcu7t5v0__filltie
XFILLER_79_656 VDD VDD VSS VSS gf180mcu_fd_sc_mcu7t5v0__fill_1
XTAP_TAPCELL_ROW_72_1266 VDD VSS gf180mcu_fd_sc_mcu7t5v0__filltie
XFILLER_74_350 VDD VDD VSS VSS gf180mcu_fd_sc_mcu7t5v0__fill_1
XFILLER_62_567 VDD VDD VSS VSS gf180mcu_fd_sc_mcu7t5v0__fill_1
XFILLER_90_887 VDD VDD VSS VSS gf180mcu_fd_sc_mcu7t5v0__fillcap_4
X_4630_ wire291/Z _4630_/A2 _4630_/B _7029_/D VDD VDD VSS VSS gf180mcu_fd_sc_mcu7t5v0__oai21_1
XFILLER_31_976 VDD VDD VSS VSS gf180mcu_fd_sc_mcu7t5v0__fillcap_4
XFILLER_30_486 VDD VDD VSS VSS gf180mcu_fd_sc_mcu7t5v0__fill_1
X_6300_ _6300_/A1 _6300_/A2 _6300_/B1 _6300_/B2 _7602_/D VDD VDD VSS VSS gf180mcu_fd_sc_mcu7t5v0__aoi22_1
X_4561_ _6995_/Q _4574_/A2 _4562_/B VDD VDD VSS VSS gf180mcu_fd_sc_mcu7t5v0__nand2_1
X_4492_ _4506_/A1 _4504_/A2 _4492_/B _6960_/D VDD VDD VSS VSS gf180mcu_fd_sc_mcu7t5v0__oai21_1
X_7280_ _7280_/D _7687_/CLK _7280_/Q VDD VDD VSS VSS gf180mcu_fd_sc_mcu7t5v0__dffq_1
X_3512_ _3512_/A1 _5631_/B _7769_/D _7770_/D VDD VDD VSS VSS gf180mcu_fd_sc_mcu7t5v0__aoi21_1
X_6231_ _6231_/A1 _6231_/A2 _6231_/B1 _6224_/B _6231_/C _6245_/A2 VDD VDD VSS VSS
+ gf180mcu_fd_sc_mcu7t5v0__oai221_1
X_3443_ _7590_/Q _6276_/A1 VDD VDD VSS VSS gf180mcu_fd_sc_mcu7t5v0__clkinv_1
X_6162_ _6973_/Q _6162_/A2 _6222_/B1 _6966_/Q _6162_/C _6163_/A2 VDD VDD VSS VSS gf180mcu_fd_sc_mcu7t5v0__oai221_1
X_5113_ _7271_/Q _5120_/A2 _5114_/B VDD VDD VSS VSS gf180mcu_fd_sc_mcu7t5v0__nand2_1
XFILLER_97_453 VDD VDD VSS VSS gf180mcu_fd_sc_mcu7t5v0__fill_1
X_3374_ _7517_/Q _5632_/A1 VDD VDD VSS VSS gf180mcu_fd_sc_mcu7t5v0__clkinv_1
Xload_slew530 _5235_/I0 _5354_/I0 VDD VDD VSS VSS gf180mcu_fd_sc_mcu7t5v0__clkbuf_4
XFILLER_112_786 VDD VDD VSS VSS gf180mcu_fd_sc_mcu7t5v0__fillcap_16
X_6093_ _6093_/A1 _6093_/A2 _6095_/B1 VDD VDD VSS VSS gf180mcu_fd_sc_mcu7t5v0__nor2_1
Xload_slew596 _7690_/RN _7657_/RN VDD VDD VSS VSS gf180mcu_fd_sc_mcu7t5v0__buf_4
X_5044_ _5072_/A1 _5050_/A2 _5044_/B _7236_/D VDD VDD VSS VSS gf180mcu_fd_sc_mcu7t5v0__oai21_1
XFILLER_38_542 VDD VDD VSS VSS gf180mcu_fd_sc_mcu7t5v0__fillcap_32
XFILLER_26_737 VDD VDD VSS VSS gf180mcu_fd_sc_mcu7t5v0__fillcap_64
XFILLER_38_597 VDD VDD VSS VSS gf180mcu_fd_sc_mcu7t5v0__fillcap_64
X_6995_ _6995_/D _7003_/CLK _6995_/Q VDD VDD VSS VSS gf180mcu_fd_sc_mcu7t5v0__dffq_1
XFILLER_25_258 VDD VDD VSS VSS gf180mcu_fd_sc_mcu7t5v0__fill_1
X_5946_ _7574_/Q _6303_/S _5883_/B _5946_/B2 _5947_/I VDD VDD VSS VSS gf180mcu_fd_sc_mcu7t5v0__oai22_1
XTAP_TAPCELL_ROW_36_765 VDD VSS gf180mcu_fd_sc_mcu7t5v0__filltie
X_5877_ _5877_/A1 _5813_/Z _5881_/B VDD VDD VSS VSS gf180mcu_fd_sc_mcu7t5v0__nor2_1
X_4828_ _5066_/A1 _4840_/A2 _4828_/B _7128_/D VDD VDD VSS VSS gf180mcu_fd_sc_mcu7t5v0__oai21_1
X_7616_ _7616_/D _7701_/RN _7703_/CLK _7616_/Q VDD VDD VSS VSS gf180mcu_fd_sc_mcu7t5v0__dffrnq_1
XFILLER_21_497 VDD VDD VSS VSS gf180mcu_fd_sc_mcu7t5v0__fill_2
X_4759_ _7094_/Q _4770_/A2 _4760_/B VDD VDD VSS VSS gf180mcu_fd_sc_mcu7t5v0__nand2_1
X_7547_ _7547_/D _7800_/RN _7796_/CLK _7547_/Q VDD VDD VSS VSS gf180mcu_fd_sc_mcu7t5v0__dffrnq_1
X_7478_ _7478_/D _7489_/CLK _7478_/Q VDD VDD VSS VSS gf180mcu_fd_sc_mcu7t5v0__dffq_1
X_6429_ _7664_/Q _6479_/S _6435_/B VDD VDD VSS VSS gf180mcu_fd_sc_mcu7t5v0__nor2_1
XTAP_TAPCELL_ROW_112_1823 VDD VSS gf180mcu_fd_sc_mcu7t5v0__filltie
XFILLER_1_836 VDD VDD VSS VSS gf180mcu_fd_sc_mcu7t5v0__fillcap_4
XFILLER_89_976 VDD VDD VSS VSS gf180mcu_fd_sc_mcu7t5v0__fillcap_4
XFILLER_0_357 VDD VDD VSS VSS gf180mcu_fd_sc_mcu7t5v0__fill_2
XFILLER_48_317 VDD VDD VSS VSS gf180mcu_fd_sc_mcu7t5v0__fill_2
XTAP_TAPCELL_ROW_14_459 VDD VSS gf180mcu_fd_sc_mcu7t5v0__filltie
XTAP_TAPCELL_ROW_14_448 VDD VSS gf180mcu_fd_sc_mcu7t5v0__filltie
XFILLER_13_976 VDD VDD VSS VSS gf180mcu_fd_sc_mcu7t5v0__fillcap_4
XFILLER_12_464 VDD VDD VSS VSS gf180mcu_fd_sc_mcu7t5v0__fill_1
XFILLER_8_413 VDD VDD VSS VSS gf180mcu_fd_sc_mcu7t5v0__fill_2
XFILLER_33_61 VDD VDD VSS VSS gf180mcu_fd_sc_mcu7t5v0__fill_1
XFILLER_33_72 VDD VDD VSS VSS gf180mcu_fd_sc_mcu7t5v0__fill_1
XFILLER_8_457 VDD VDD VSS VSS gf180mcu_fd_sc_mcu7t5v0__fill_2
XFILLER_63_810 VDD VDD VSS VSS gf180mcu_fd_sc_mcu7t5v0__fill_2
XTAP_TAPCELL_ROW_85_1446 VDD VSS gf180mcu_fd_sc_mcu7t5v0__filltie
XFILLER_63_854 VDD VDD VSS VSS gf180mcu_fd_sc_mcu7t5v0__fill_2
X_5800_ _6967_/Q _6073_/A2 _6091_/A2 _6960_/Q _6946_/Q _6198_/C2 _5801_/A2 VDD VDD
+ VSS VSS gf180mcu_fd_sc_mcu7t5v0__oai222_1
X_3992_ _4143_/A1 _4420_/A2 _3992_/B _6750_/D VDD VDD VSS VSS gf180mcu_fd_sc_mcu7t5v0__oai21_1
X_6780_ _6780_/D _7453_/CLK _6780_/Q VDD VDD VSS VSS gf180mcu_fd_sc_mcu7t5v0__dffq_1
X_5731_ _7631_/Q _5731_/A2 _5731_/B _5731_/C _5732_/A4 VDD VDD VSS VSS gf180mcu_fd_sc_mcu7t5v0__aoi211_1
XTAP_TAPCELL_ROW_33_724 VDD VSS gf180mcu_fd_sc_mcu7t5v0__filltie
X_5662_ _7543_/Q input34/Z _5663_/S _7543_/D VDD VDD VSS VSS gf180mcu_fd_sc_mcu7t5v0__mux2_2
X_4613_ _7021_/Q _4616_/A2 _4614_/B VDD VDD VSS VSS gf180mcu_fd_sc_mcu7t5v0__nand2_1
X_5593_ _6811_/Q _5593_/A2 wire420/Z _6809_/Q _5595_/A2 VDD VDD VSS VSS gf180mcu_fd_sc_mcu7t5v0__oai22_1
X_7401_ _7401_/D _7736_/CLK _7401_/Q VDD VDD VSS VSS gf180mcu_fd_sc_mcu7t5v0__dffq_1
X_4544_ _5118_/A1 _4546_/A2 _4544_/B _6986_/D VDD VDD VSS VSS gf180mcu_fd_sc_mcu7t5v0__oai21_1
X_7332_ _7332_/D _7482_/CLK _7332_/Q VDD VDD VSS VSS gf180mcu_fd_sc_mcu7t5v0__dffq_1
X_7263_ _7263_/D _7267_/CLK _7263_/Q VDD VDD VSS VSS gf180mcu_fd_sc_mcu7t5v0__dffq_1
X_4475_ _6952_/Q _4476_/A2 _4476_/B VDD VDD VSS VSS gf180mcu_fd_sc_mcu7t5v0__nand2_1
XTAP_TAPCELL_ROW_96_1597 VDD VSS gf180mcu_fd_sc_mcu7t5v0__filltie
X_6214_ _6779_/Q _6214_/A2 _6214_/B _6216_/A1 VDD VDD VSS VSS gf180mcu_fd_sc_mcu7t5v0__oai21_1
X_3426_ _7746_/Q _6694_/A1 VDD VDD VSS VSS gf180mcu_fd_sc_mcu7t5v0__clkinv_1
X_7194_ _7194_/D _7250_/CLK _7194_/Q VDD VDD VSS VSS gf180mcu_fd_sc_mcu7t5v0__dffq_1
X_6145_ _7099_/Q _6214_/A2 _6215_/B1 _7085_/Q _6191_/B _6146_/A2 VDD VDD VSS VSS gf180mcu_fd_sc_mcu7t5v0__oai221_1
X_3357_ _7753_/Q _3866_/A2 VDD VDD VSS VSS gf180mcu_fd_sc_mcu7t5v0__clkinv_1
X_6076_ _6902_/Q _6076_/A2 _6076_/B1 _6895_/Q _6081_/A1 VDD VDD VSS VSS gf180mcu_fd_sc_mcu7t5v0__oai22_1
XFILLER_100_734 VDD VDD VSS VSS gf180mcu_fd_sc_mcu7t5v0__fill_1
Xload_slew371 _5610_/C2 _5516_/C2 VDD VDD VSS VSS gf180mcu_fd_sc_mcu7t5v0__buf_2
Xload_slew360 fanout358/Z _6225_/B1 VDD VDD VSS VSS gf180mcu_fd_sc_mcu7t5v0__buf_2
XFILLER_86_979 VDD VDD VSS VSS gf180mcu_fd_sc_mcu7t5v0__fill_2
X_5027_ _7228_/Q _5036_/A2 _5028_/B VDD VDD VSS VSS gf180mcu_fd_sc_mcu7t5v0__nand2_1
X_6978_ _6978_/D _7668_/CLK _6978_/Q VDD VDD VSS VSS gf180mcu_fd_sc_mcu7t5v0__dffq_1
X_5929_ _5929_/A1 _5929_/A2 _5933_/B1 VDD VDD VSS VSS gf180mcu_fd_sc_mcu7t5v0__nor2_1
XFILLER_41_559 VDD VDD VSS VSS gf180mcu_fd_sc_mcu7t5v0__fill_1
XTAP_TAPCELL_ROW_11_418 VDD VSS gf180mcu_fd_sc_mcu7t5v0__filltie
XTAP_TAPCELL_ROW_11_407 VDD VSS gf180mcu_fd_sc_mcu7t5v0__filltie
XFILLER_10_979 VDD VDD VSS VSS gf180mcu_fd_sc_mcu7t5v0__fill_2
XTAP_TAPCELL_ROW_56_1036 VDD VSS gf180mcu_fd_sc_mcu7t5v0__filltie
XTAP_TAPCELL_ROW_56_1047 VDD VSS gf180mcu_fd_sc_mcu7t5v0__filltie
XFILLER_77_979 VDD VDD VSS VSS gf180mcu_fd_sc_mcu7t5v0__fill_1
XTAP_TAPCELL_ROW_19_529 VDD VSS gf180mcu_fd_sc_mcu7t5v0__filltie
XTAP_TAPCELL_ROW_19_518 VDD VSS gf180mcu_fd_sc_mcu7t5v0__filltie
XTAP_TAPCELL_ROW_67_1198 VDD VSS gf180mcu_fd_sc_mcu7t5v0__filltie
XTAP_TAPCELL_ROW_80_1376 VDD VSS gf180mcu_fd_sc_mcu7t5v0__filltie
XFILLER_118_609 VDD VDD VSS VSS gf180mcu_fd_sc_mcu7t5v0__fill_2
XFILLER_9_766 VDD VDD VSS VSS gf180mcu_fd_sc_mcu7t5v0__fillcap_4
XFILLER_8_243 VDD VDD VSS VSS gf180mcu_fd_sc_mcu7t5v0__fill_2
X_4260_ _4540_/A1 _4266_/A2 _4260_/B _6844_/D VDD VDD VSS VSS gf180mcu_fd_sc_mcu7t5v0__oai21_1
X_4191_ _4224_/A1 _6651_/A2 _5218_/S VDD VDD VSS VSS gf180mcu_fd_sc_mcu7t5v0__nand2_1
XFILLER_68_979 VDD VDD VSS VSS gf180mcu_fd_sc_mcu7t5v0__fill_2
X_6901_ _6901_/D _7148_/CLK _6901_/Q VDD VDD VSS VSS gf180mcu_fd_sc_mcu7t5v0__dffq_1
XFILLER_82_448 VDD VDD VSS VSS gf180mcu_fd_sc_mcu7t5v0__fill_2
XFILLER_48_692 VDD VDD VSS VSS gf180mcu_fd_sc_mcu7t5v0__fill_1
X_7881_ _7881_/I _7881_/Z VDD VDD VSS VSS gf180mcu_fd_sc_mcu7t5v0__buf_1
X_6832_ _6832_/D _7504_/CLK _6832_/Q VDD VDD VSS VSS gf180mcu_fd_sc_mcu7t5v0__dffq_1
XFILLER_50_312 VDD VDD VSS VSS gf180mcu_fd_sc_mcu7t5v0__fill_2
XFILLER_63_684 VDD VDD VSS VSS gf180mcu_fd_sc_mcu7t5v0__fill_1
X_3975_ _6745_/Q _4350_/A2 _3976_/B VDD VDD VSS VSS gf180mcu_fd_sc_mcu7t5v0__nand2_1
X_6763_ _6763_/D _7261_/CLK _6763_/Q VDD VDD VSS VSS gf180mcu_fd_sc_mcu7t5v0__dffq_1
XFILLER_23_559 VDD VDD VSS VSS gf180mcu_fd_sc_mcu7t5v0__fill_1
X_6694_ _6694_/A1 _6694_/A2 _6678_/I _6694_/B2 _7746_/D VDD VDD VSS VSS gf180mcu_fd_sc_mcu7t5v0__aoi22_1
X_5714_ _5714_/A1 _5714_/A2 _5714_/A3 _5715_/A2 VDD VDD VSS VSS gf180mcu_fd_sc_mcu7t5v0__nor3_1
X_5645_ _7528_/Q input55/Z _5653_/S _7528_/D VDD VDD VSS VSS gf180mcu_fd_sc_mcu7t5v0__mux2_2
XTAP_TAPCELL_ROW_98_1637 VDD VSS gf180mcu_fd_sc_mcu7t5v0__filltie
XTAP_TAPCELL_ROW_98_1626 VDD VSS gf180mcu_fd_sc_mcu7t5v0__filltie
X_5576_ _5549_/C _5576_/A2 _5576_/A3 _5583_/A3 VDD VDD VSS VSS gf180mcu_fd_sc_mcu7t5v0__nor3_1
XFILLER_117_697 VDD VDD VSS VSS gf180mcu_fd_sc_mcu7t5v0__fill_2
X_4527_ _6978_/Q _4532_/A2 _4528_/B VDD VDD VSS VSS gf180mcu_fd_sc_mcu7t5v0__nand2_1
X_7315_ _7315_/D _7492_/CLK _7315_/Q VDD VDD VSS VSS gf180mcu_fd_sc_mcu7t5v0__dffq_1
X_4458_ wire240/Z _4462_/A2 _4458_/B _6943_/D VDD VDD VSS VSS gf180mcu_fd_sc_mcu7t5v0__oai21_1
X_7246_ _7246_/D _7253_/CLK _7246_/Q VDD VDD VSS VSS gf180mcu_fd_sc_mcu7t5v0__dffq_1
X_3409_ _7687_/Q _5711_/B2 VDD VDD VSS VSS gf180mcu_fd_sc_mcu7t5v0__clkinv_1
X_7177_ _7177_/D _7748_/CLK _7177_/Q VDD VDD VSS VSS gf180mcu_fd_sc_mcu7t5v0__dffq_1
X_4389_ _6909_/Q _4392_/A2 _4390_/B VDD VDD VSS VSS gf180mcu_fd_sc_mcu7t5v0__nand2_1
XFILLER_98_592 VDD VDD VSS VSS gf180mcu_fd_sc_mcu7t5v0__fill_2
X_6128_ _6488_/B _5809_/I _6124_/Z wire190/I _6129_/A4 VDD VDD VSS VSS gf180mcu_fd_sc_mcu7t5v0__aoi22_1
X_6059_ _6136_/B _6059_/A2 _6059_/B _6244_/C _6060_/A3 VDD VDD VSS VSS gf180mcu_fd_sc_mcu7t5v0__oai211_1
XTAP_TAPCELL_ROW_107_1755 VDD VSS gf180mcu_fd_sc_mcu7t5v0__filltie
XFILLER_22_592 VDD VDD VSS VSS gf180mcu_fd_sc_mcu7t5v0__fill_2
XTAP_TAPCELL_ROW_24_598 VDD VSS gf180mcu_fd_sc_mcu7t5v0__filltie
XFILLER_108_664 VDD VDD VSS VSS gf180mcu_fd_sc_mcu7t5v0__fill_1
XTAP_TAPCELL_ROW_69_1227 VDD VSS gf180mcu_fd_sc_mcu7t5v0__filltie
XTAP_TAPCELL_ROW_82_1405 VDD VSS gf180mcu_fd_sc_mcu7t5v0__filltie
XFILLER_73_971 VDD VDD VSS VSS gf180mcu_fd_sc_mcu7t5v0__fillcap_8
XTAP_TAPCELL_ROW_43_863 VDD VSS gf180mcu_fd_sc_mcu7t5v0__filltie
X_3760_ _3728_/Z _3729_/Z _3760_/A3 _3760_/B _7779_/D VDD VDD VSS VSS gf180mcu_fd_sc_mcu7t5v0__oai31_1
X_3691_ _3677_/S _3682_/C _3683_/C _3691_/B2 _3700_/A1 VDD VDD VSS VSS gf180mcu_fd_sc_mcu7t5v0__oai22_1
X_5430_ _5616_/S _5430_/A2 _5430_/A3 _5430_/B1 _5430_/B2 _5431_/I1 VDD VDD VSS VSS
+ gf180mcu_fd_sc_mcu7t5v0__oai32_1
X_5361_ _3708_/Z _5625_/C _7544_/Q _6732_/A1 VDD VDD VSS VSS gf180mcu_fd_sc_mcu7t5v0__oai21_1
XTAP_TAPCELL_ROW_93_1567 VDD VSS gf180mcu_fd_sc_mcu7t5v0__filltie
XTAP_TAPCELL_ROW_93_1556 VDD VSS gf180mcu_fd_sc_mcu7t5v0__filltie
X_4312_ _4396_/A1 _4322_/A2 _4312_/B _6870_/D VDD VDD VSS VSS gf180mcu_fd_sc_mcu7t5v0__oai21_1
X_5292_ _5341_/I0 _7439_/Q _5295_/S _7439_/D VDD VDD VSS VSS gf180mcu_fd_sc_mcu7t5v0__mux2_2
X_7100_ _7100_/D _7250_/CLK _7100_/Q VDD VDD VSS VSS gf180mcu_fd_sc_mcu7t5v0__dffq_1
X_7031_ _7031_/D _7099_/CLK _7031_/Q VDD VDD VSS VSS gf180mcu_fd_sc_mcu7t5v0__dffq_1
X_4243_ _6836_/Q _4252_/A2 _4244_/B VDD VDD VSS VSS gf180mcu_fd_sc_mcu7t5v0__nand2_1
XFILLER_101_339 VDD VDD VSS VSS gf180mcu_fd_sc_mcu7t5v0__fill_1
XFILLER_68_732 VDD VDD VSS VSS gf180mcu_fd_sc_mcu7t5v0__fill_2
X_4174_ _4179_/A2 _6651_/A2 _5169_/S VDD VDD VSS VSS gf180mcu_fd_sc_mcu7t5v0__nand2_1
XFILLER_95_562 VDD VDD VSS VSS gf180mcu_fd_sc_mcu7t5v0__fill_2
Xclkbuf_leaf_5_clk_i clkload0/I _7765_/CLK VDD VDD VSS VSS gf180mcu_fd_sc_mcu7t5v0__clkbuf_8
XFILLER_67_264 VDD VDD VSS VSS gf180mcu_fd_sc_mcu7t5v0__fill_2
XFILLER_68_798 VDD VDD VSS VSS gf180mcu_fd_sc_mcu7t5v0__fill_1
XFILLER_71_908 VDD VDD VSS VSS gf180mcu_fd_sc_mcu7t5v0__fill_2
XFILLER_63_492 VDD VDD VSS VSS gf180mcu_fd_sc_mcu7t5v0__fill_2
X_7795_ _7795_/D _7810_/RN clkload8/I _7795_/Q VDD VDD VSS VSS gf180mcu_fd_sc_mcu7t5v0__dffrnq_1
X_6815_ _6815_/D _7735_/CLK _6815_/Q VDD VDD VSS VSS gf180mcu_fd_sc_mcu7t5v0__dffq_1
X_6746_ _6746_/D _7148_/CLK _6746_/Q VDD VDD VSS VSS gf180mcu_fd_sc_mcu7t5v0__dffq_1
XFILLER_51_698 VDD VDD VSS VSS gf180mcu_fd_sc_mcu7t5v0__fill_2
XTAP_TAPCELL_ROW_102_1685 VDD VSS gf180mcu_fd_sc_mcu7t5v0__filltie
XTAP_TAPCELL_ROW_21_546 VDD VSS gf180mcu_fd_sc_mcu7t5v0__filltie
X_3958_ _6609_/A1 _7720_/Q _3966_/A1 _4132_/A1 VDD VDD VSS VSS gf180mcu_fd_sc_mcu7t5v0__nor3_4
XFILLER_109_417 VDD VDD VSS VSS gf180mcu_fd_sc_mcu7t5v0__fill_2
XTAP_TAPCELL_ROW_21_557 VDD VSS gf180mcu_fd_sc_mcu7t5v0__filltie
X_6677_ _6677_/A1 _6694_/A2 _6695_/A2 _6678_/I VDD VDD VSS VSS gf180mcu_fd_sc_mcu7t5v0__nor3_1
X_3889_ _3872_/Z _3889_/A2 _3890_/B VDD VDD VSS VSS gf180mcu_fd_sc_mcu7t5v0__nor2_1
X_5628_ _7515_/Q _6728_/B _6724_/B _5627_/Z _5629_/I VDD VDD VSS VSS gf180mcu_fd_sc_mcu7t5v0__oai22_1
X_5559_ _7309_/Q _5613_/B1 _5559_/B1 _7316_/Q _7323_/Q _5610_/B1 _5560_/A2 VDD VDD
+ VSS VSS gf180mcu_fd_sc_mcu7t5v0__oai222_1
XFILLER_78_507 VDD VDD VSS VSS gf180mcu_fd_sc_mcu7t5v0__fill_1
Xuart_615 racl_error_o[19] VDD VDD VSS VSS gf180mcu_fd_sc_mcu7t5v0__tiel
Xuart_604 racl_error_o[8] VDD VDD VSS VSS gf180mcu_fd_sc_mcu7t5v0__tiel
XTAP_TAPCELL_ROW_53_1006 VDD VSS gf180mcu_fd_sc_mcu7t5v0__filltie
Xuart_626 racl_error_o[30] VDD VDD VSS VSS gf180mcu_fd_sc_mcu7t5v0__tiel
Xuart_637 racl_error_o[41] VDD VDD VSS VSS gf180mcu_fd_sc_mcu7t5v0__tiel
Xfanout531 _5339_/I0 _6354_/I0 VDD VDD VSS VSS gf180mcu_fd_sc_mcu7t5v0__dlyd_1
Xfanout520 _7643_/Q wire521/I VDD VDD VSS VSS gf180mcu_fd_sc_mcu7t5v0__dlyd_1
X_7229_ _7229_/D _7250_/CLK _7229_/Q VDD VDD VSS VSS gf180mcu_fd_sc_mcu7t5v0__dffq_1
XFILLER_46_415 VDD VDD VSS VSS gf180mcu_fd_sc_mcu7t5v0__fill_2
XFILLER_74_757 VDD VDD VSS VSS gf180mcu_fd_sc_mcu7t5v0__fill_1
XTAP_TAPCELL_ROW_29_668 VDD VSS gf180mcu_fd_sc_mcu7t5v0__filltie
XTAP_TAPCELL_ROW_1_271 VDD VSS gf180mcu_fd_sc_mcu7t5v0__filltie
XFILLER_14_334 VDD VDD VSS VSS gf180mcu_fd_sc_mcu7t5v0__fill_1
XTAP_TAPCELL_ROW_64_1157 VDD VSS gf180mcu_fd_sc_mcu7t5v0__filltie
XTAP_TAPCELL_ROW_40_822 VDD VSS gf180mcu_fd_sc_mcu7t5v0__filltie
XFILLER_6_522 VDD VDD VSS VSS gf180mcu_fd_sc_mcu7t5v0__fill_2
XFILLER_97_838 VDD VDD VSS VSS gf180mcu_fd_sc_mcu7t5v0__fill_2
XTAP_TAPCELL_ROW_9_382 VDD VSS gf180mcu_fd_sc_mcu7t5v0__filltie
XFILLER_77_562 VDD VDD VSS VSS gf180mcu_fd_sc_mcu7t5v0__fill_2
XTAP_TAPCELL_ROW_48_933 VDD VSS gf180mcu_fd_sc_mcu7t5v0__filltie
XFILLER_53_908 VDD VDD VSS VSS gf180mcu_fd_sc_mcu7t5v0__fill_2
XFILLER_65_768 VDD VDD VSS VSS gf180mcu_fd_sc_mcu7t5v0__fill_2
X_4930_ _5112_/A1 _4938_/A2 _4930_/B _7179_/D VDD VDD VSS VSS gf180mcu_fd_sc_mcu7t5v0__oai21_1
X_4861_ _7145_/Q _4868_/A2 _4862_/B VDD VDD VSS VSS gf180mcu_fd_sc_mcu7t5v0__nand2_1
XFILLER_33_632 VDD VDD VSS VSS gf180mcu_fd_sc_mcu7t5v0__fillcap_64
X_3812_ _3812_/A1 _3850_/C _3812_/Z VDD VDD VSS VSS gf180mcu_fd_sc_mcu7t5v0__and2_1
X_6600_ _6184_/C _6600_/A2 _6600_/Z VDD VDD VSS VSS gf180mcu_fd_sc_mcu7t5v0__xor2_1
X_7580_ _7580_/D _7710_/RN _7710_/CLK _7580_/Q VDD VDD VSS VSS gf180mcu_fd_sc_mcu7t5v0__dffrnq_1
XANTENNA_16 alert_rx_i[2] VDD VDD VSS VSS gf180mcu_fd_sc_mcu7t5v0__antenna
X_4792_ _4988_/A1 _4798_/A2 _4792_/B _7110_/D VDD VDD VSS VSS gf180mcu_fd_sc_mcu7t5v0__oai21_1
X_6531_ _7685_/Q _7686_/Q _6526_/Z _6531_/Z VDD VDD VSS VSS gf180mcu_fd_sc_mcu7t5v0__and3_1
X_3743_ _7546_/Q _5665_/A1 _3750_/A2 VDD VDD VSS VSS gf180mcu_fd_sc_mcu7t5v0__nand2_1
X_6462_ _7667_/Q _7533_/Q _6462_/B _6463_/A2 VDD VDD VSS VSS gf180mcu_fd_sc_mcu7t5v0__aoi21_1
X_3674_ _7881_/I _7882_/I _5690_/A2 VDD VDD VSS VSS gf180mcu_fd_sc_mcu7t5v0__nor2_1
X_6393_ _7658_/Q _7524_/Q _6400_/A1 VDD VDD VSS VSS gf180mcu_fd_sc_mcu7t5v0__nor2_1
X_5413_ _5413_/A1 _5413_/A2 _5417_/A2 VDD VDD VSS VSS gf180mcu_fd_sc_mcu7t5v0__nor2_1
Xoutput134 _7575_/Q tl_o[19] VDD VDD VSS VSS gf180mcu_fd_sc_mcu7t5v0__dlyd_1
Xoutput112 _7808_/Q intr_rx_frame_err_o VDD VDD VSS VSS gf180mcu_fd_sc_mcu7t5v0__dlyd_1
X_5344_ _5344_/I0 _7491_/Q _5344_/S _7491_/D VDD VDD VSS VSS gf180mcu_fd_sc_mcu7t5v0__mux2_2
Xoutput123 _7881_/Z racl_error_o[4] VDD VDD VSS VSS gf180mcu_fd_sc_mcu7t5v0__dlyd_1
XFILLER_115_976 VDD VDD VSS VSS gf180mcu_fd_sc_mcu7t5v0__fillcap_4
Xoutput145 _7585_/Q tl_o[29] VDD VDD VSS VSS gf180mcu_fd_sc_mcu7t5v0__dlyd_1
XFILLER_99_142 VDD VDD VSS VSS gf180mcu_fd_sc_mcu7t5v0__fill_1
Xoutput167 _3835_/Z tl_o[4] VDD VDD VSS VSS gf180mcu_fd_sc_mcu7t5v0__dlyd_1
Xoutput156 _7595_/Q tl_o[39] VDD VDD VSS VSS gf180mcu_fd_sc_mcu7t5v0__dlyd_1
Xoutput178 _7516_/Q tl_o[62] VDD VDD VSS VSS gf180mcu_fd_sc_mcu7t5v0__dlyd_1
X_5275_ _5303_/I0 _7422_/Q _5281_/S _7422_/D VDD VDD VSS VSS gf180mcu_fd_sc_mcu7t5v0__mux2_2
X_7014_ _7014_/D _7060_/CLK _7014_/Q VDD VDD VSS VSS gf180mcu_fd_sc_mcu7t5v0__dffq_1
XFILLER_87_348 VDD VDD VSS VSS gf180mcu_fd_sc_mcu7t5v0__fill_2
X_4226_ _7735_/Q _7736_/Q _4226_/A3 _4233_/A2 VDD VDD VSS VSS gf180mcu_fd_sc_mcu7t5v0__nor3_1
X_4157_ _7735_/Q _7736_/Q _4203_/A1 _4224_/A1 VDD VDD VSS VSS gf180mcu_fd_sc_mcu7t5v0__nor3_1
X_4088_ _4088_/A1 _4840_/A2 _4088_/B _6780_/D VDD VDD VSS VSS gf180mcu_fd_sc_mcu7t5v0__oai21_1
XTAP_TAPCELL_ROW_104_1714 VDD VSS gf180mcu_fd_sc_mcu7t5v0__filltie
XTAP_TAPCELL_ROW_26_616 VDD VSS gf180mcu_fd_sc_mcu7t5v0__filltie
XTAP_TAPCELL_ROW_26_627 VDD VSS gf180mcu_fd_sc_mcu7t5v0__filltie
XFILLER_52_941 VDD VDD VSS VSS gf180mcu_fd_sc_mcu7t5v0__fillcap_4
X_7778_ _7778_/D _7825_/RN clkload9/I _7778_/Q VDD VDD VSS VSS gf180mcu_fd_sc_mcu7t5v0__dffrnq_1
XFILLER_7_319 VDD VDD VSS VSS gf180mcu_fd_sc_mcu7t5v0__fill_1
X_6729_ _6729_/A1 _6729_/A2 _7762_/D VDD VDD VSS VSS gf180mcu_fd_sc_mcu7t5v0__nand2_1
XFILLER_20_871 VDD VDD VSS VSS gf180mcu_fd_sc_mcu7t5v0__fillcap_4
XFILLER_106_943 VDD VDD VSS VSS gf180mcu_fd_sc_mcu7t5v0__fill_2
XTAP_TAPCELL_ROW_115_1865 VDD VSS gf180mcu_fd_sc_mcu7t5v0__filltie
XFILLER_105_442 VDD VDD VSS VSS gf180mcu_fd_sc_mcu7t5v0__fill_2
XFILLER_2_4 VDD VDD VSS VSS gf180mcu_fd_sc_mcu7t5v0__fill_1
XTAP_TAPCELL_ROW_6_341 VDD VSS gf180mcu_fd_sc_mcu7t5v0__filltie
XFILLER_87_860 VDD VDD VSS VSS gf180mcu_fd_sc_mcu7t5v0__fill_2
XFILLER_59_562 VDD VDD VSS VSS gf180mcu_fd_sc_mcu7t5v0__fill_2
XFILLER_46_289 VDD VDD VSS VSS gf180mcu_fd_sc_mcu7t5v0__fill_1
XFILLER_15_632 VDD VDD VSS VSS gf180mcu_fd_sc_mcu7t5v0__fillcap_64
XFILLER_42_484 VDD VDD VSS VSS gf180mcu_fd_sc_mcu7t5v0__fillcap_16
Xinput14 tl_i[106] _3683_/C VDD VDD VSS VSS gf180mcu_fd_sc_mcu7t5v0__dlyd_1
XFILLER_10_370 VDD VDD VSS VSS gf180mcu_fd_sc_mcu7t5v0__fill_1
XFILLER_7_842 VDD VDD VSS VSS gf180mcu_fd_sc_mcu7t5v0__fillcap_64
Xinput25 tl_i[16] input25/Z VDD VDD VSS VSS gf180mcu_fd_sc_mcu7t5v0__dlyd_1
Xinput36 tl_i[35] input36/Z VDD VDD VSS VSS gf180mcu_fd_sc_mcu7t5v0__dlyd_1
Xinput69 tl_i[65] _3677_/S VDD VDD VSS VSS gf180mcu_fd_sc_mcu7t5v0__dlyd_1
Xinput58 tl_i[55] input58/Z VDD VDD VSS VSS gf180mcu_fd_sc_mcu7t5v0__dlyd_1
XTAP_TAPCELL_ROW_77_1337 VDD VSS gf180mcu_fd_sc_mcu7t5v0__filltie
Xinput47 tl_i[45] input47/Z VDD VDD VSS VSS gf180mcu_fd_sc_mcu7t5v0__dlyd_1
XFILLER_97_602 VDD VDD VSS VSS gf180mcu_fd_sc_mcu7t5v0__fill_1
XTAP_TAPCELL_ROW_90_1515 VDD VSS gf180mcu_fd_sc_mcu7t5v0__filltie
X_3390_ _7734_/Q _6654_/A1 VDD VDD VSS VSS gf180mcu_fd_sc_mcu7t5v0__clkinv_1
XFILLER_97_613 VDD VDD VSS VSS gf180mcu_fd_sc_mcu7t5v0__fill_2
XFILLER_112_979 VDD VDD VSS VSS gf180mcu_fd_sc_mcu7t5v0__fill_2
XFILLER_2_591 VDD VDD VSS VSS gf180mcu_fd_sc_mcu7t5v0__fillcap_4
Xclkbuf_leaf_70_clk_i clkbuf_3_1__f_clk_i/Z _7500_/CLK VDD VDD VSS VSS gf180mcu_fd_sc_mcu7t5v0__clkbuf_8
X_5060_ _5060_/A1 _5064_/A2 _5060_/B _7244_/D VDD VDD VSS VSS gf180mcu_fd_sc_mcu7t5v0__oai21_1
X_4011_ wire248/Z _4504_/A2 _4011_/B _6756_/D VDD VDD VSS VSS gf180mcu_fd_sc_mcu7t5v0__oai21_1
XFILLER_84_329 VDD VDD VSS VSS gf180mcu_fd_sc_mcu7t5v0__fill_1
XFILLER_37_212 VDD VDD VSS VSS gf180mcu_fd_sc_mcu7t5v0__fill_1
XFILLER_93_885 VDD VDD VSS VSS gf180mcu_fd_sc_mcu7t5v0__fillcap_8
XTAP_TAPCELL_ROW_88_1488 VDD VSS gf180mcu_fd_sc_mcu7t5v0__filltie
X_5962_ _6872_/Q _6091_/A2 _6089_/B1 _6865_/Q _5964_/A1 VDD VDD VSS VSS gf180mcu_fd_sc_mcu7t5v0__oai22_1
Xclkbuf_leaf_85_clk_i clkload0/I _7472_/CLK VDD VDD VSS VSS gf180mcu_fd_sc_mcu7t5v0__clkbuf_8
XFILLER_34_941 VDD VDD VSS VSS gf180mcu_fd_sc_mcu7t5v0__fillcap_4
X_4913_ _7171_/Q _4924_/A2 _4914_/B VDD VDD VSS VSS gf180mcu_fd_sc_mcu7t5v0__nand2_1
X_7701_ _7701_/D _7701_/RN _7703_/CLK _7701_/Q VDD VDD VSS VSS gf180mcu_fd_sc_mcu7t5v0__dffrnq_1
X_5893_ _7060_/Q _6153_/A2 _5893_/B _6227_/C _5896_/B VDD VDD VSS VSS gf180mcu_fd_sc_mcu7t5v0__oai211_1
X_7632_ _7632_/D _7657_/RN _7695_/CLK _7632_/Q VDD VDD VSS VSS gf180mcu_fd_sc_mcu7t5v0__dffrnq_1
X_4844_ _4942_/A1 _4854_/A2 _4844_/B _7136_/D VDD VDD VSS VSS gf180mcu_fd_sc_mcu7t5v0__oai21_1
X_7563_ _7563_/D _7780_/RN _7780_/CLK _7563_/Q VDD VDD VSS VSS gf180mcu_fd_sc_mcu7t5v0__dffrnq_1
X_4775_ _7102_/Q _4784_/A2 _4776_/B VDD VDD VSS VSS gf180mcu_fd_sc_mcu7t5v0__nand2_1
X_6514_ _7680_/Q _6514_/A2 _6514_/Z VDD VDD VSS VSS gf180mcu_fd_sc_mcu7t5v0__xor2_1
XTAP_TAPCELL_ROW_31_696 VDD VSS gf180mcu_fd_sc_mcu7t5v0__filltie
X_3726_ _7731_/Q _7737_/Q _3727_/I VDD VDD VSS VSS gf180mcu_fd_sc_mcu7t5v0__xnor2_1
Xclkbuf_leaf_23_clk_i clkload1/I _7670_/CLK VDD VDD VSS VSS gf180mcu_fd_sc_mcu7t5v0__clkbuf_8
X_7494_ _7494_/D _7504_/CLK _7494_/Q VDD VDD VSS VSS gf180mcu_fd_sc_mcu7t5v0__dffq_1
X_6445_ _7666_/Q _7532_/Q _6446_/I VDD VDD VSS VSS gf180mcu_fd_sc_mcu7t5v0__nand2_1
X_3657_ _3551_/Z _3556_/Z _3654_/Z _3655_/Z _3657_/C _3658_/A2 VDD VDD VSS VSS gf180mcu_fd_sc_mcu7t5v0__oai221_1
X_6376_ _7544_/Q _7540_/Q _6451_/A2 VDD VDD VSS VSS gf180mcu_fd_sc_mcu7t5v0__nor2_2
X_3588_ input37/Z _3587_/Z _3588_/Z VDD VDD VSS VSS gf180mcu_fd_sc_mcu7t5v0__xor2_1
X_5327_ _5341_/I0 _7474_/Q _5330_/S _7474_/D VDD VDD VSS VSS gf180mcu_fd_sc_mcu7t5v0__mux2_2
XFILLER_102_423 VDD VDD VSS VSS gf180mcu_fd_sc_mcu7t5v0__fill_1
XFILLER_87_123 VDD VDD VSS VSS gf180mcu_fd_sc_mcu7t5v0__fill_1
Xclkbuf_leaf_38_clk_i clkload5/I _6915_/CLK VDD VDD VSS VSS gf180mcu_fd_sc_mcu7t5v0__clkbuf_8
XTAP_TAPCELL_ROW_3_300 VDD VSS gf180mcu_fd_sc_mcu7t5v0__filltie
X_5258_ wire521/Z _7405_/Q _5260_/S _7405_/D VDD VDD VSS VSS gf180mcu_fd_sc_mcu7t5v0__mux2_2
XFILLER_29_702 VDD VDD VSS VSS gf180mcu_fd_sc_mcu7t5v0__fillcap_64
XTAP_TAPCELL_ROW_110_1795 VDD VSS gf180mcu_fd_sc_mcu7t5v0__filltie
X_4209_ _7646_/Q _6820_/Q _5267_/S _6820_/D VDD VDD VSS VSS gf180mcu_fd_sc_mcu7t5v0__mux2_2
X_5189_ _5245_/I0 _7336_/Q _5190_/S _7336_/D VDD VDD VSS VSS gf180mcu_fd_sc_mcu7t5v0__mux2_2
XFILLER_56_532 VDD VDD VSS VSS gf180mcu_fd_sc_mcu7t5v0__fill_1
XFILLER_43_237 VDD VDD VSS VSS gf180mcu_fd_sc_mcu7t5v0__fill_1
XTAP_TAPCELL_ROW_61_1116 VDD VSS gf180mcu_fd_sc_mcu7t5v0__filltie
XTAP_TAPCELL_ROW_50_961 VDD VSS gf180mcu_fd_sc_mcu7t5v0__filltie
XFILLER_4_801 VDD VDD VSS VSS gf180mcu_fd_sc_mcu7t5v0__fillcap_4
XTAP_TAPCELL_ROW_59_1078 VDD VSS gf180mcu_fd_sc_mcu7t5v0__filltie
XTAP_TAPCELL_ROW_59_1089 VDD VSS gf180mcu_fd_sc_mcu7t5v0__filltie
XFILLER_106_784 VDD VDD VSS VSS gf180mcu_fd_sc_mcu7t5v0__fill_1
XTAP_TAPCELL_ROW_72_1267 VDD VSS gf180mcu_fd_sc_mcu7t5v0__filltie
Xfanout191 _6338_/S _6341_/S VDD VDD VSS VSS gf180mcu_fd_sc_mcu7t5v0__dlyd_1
XFILLER_19_278 VDD VDD VSS VSS gf180mcu_fd_sc_mcu7t5v0__fill_2
XFILLER_16_941 VDD VDD VSS VSS gf180mcu_fd_sc_mcu7t5v0__fillcap_4
XFILLER_62_535 VDD VDD VSS VSS gf180mcu_fd_sc_mcu7t5v0__fill_2
XFILLER_30_454 VDD VDD VSS VSS gf180mcu_fd_sc_mcu7t5v0__fill_1
X_4560_ _5078_/A1 _4560_/A2 _4560_/B _6994_/D VDD VDD VSS VSS gf180mcu_fd_sc_mcu7t5v0__oai21_1
X_4491_ _6960_/Q _4504_/A2 _4492_/B VDD VDD VSS VSS gf180mcu_fd_sc_mcu7t5v0__nand2_1
X_3511_ _7771_/Q _7517_/Q _5631_/B VDD VDD VSS VSS gf180mcu_fd_sc_mcu7t5v0__nand2_1
X_6230_ _6230_/A1 _6230_/A2 _6230_/B _6231_/B1 VDD VDD VSS VSS gf180mcu_fd_sc_mcu7t5v0__oai21_1
X_3442_ _7587_/Q _6269_/A1 VDD VDD VSS VSS gf180mcu_fd_sc_mcu7t5v0__clkinv_1
X_6161_ _6952_/Q wire322/Z _6228_/B1 _6959_/Q _6163_/A1 VDD VDD VSS VSS gf180mcu_fd_sc_mcu7t5v0__oai22_1
XFILLER_40_2 VDD VDD VSS VSS gf180mcu_fd_sc_mcu7t5v0__fill_1
X_3373_ _7724_/Q _6621_/A1 VDD VDD VSS VSS gf180mcu_fd_sc_mcu7t5v0__clkinv_1
X_5112_ _5112_/A1 _5120_/A2 _5112_/B _7270_/D VDD VDD VSS VSS gf180mcu_fd_sc_mcu7t5v0__oai21_1
X_6092_ _7273_/Q _6092_/A2 _6092_/B1 _7280_/Q _6853_/Q _6092_/C2 _6093_/A2 VDD VDD
+ VSS VSS gf180mcu_fd_sc_mcu7t5v0__oai222_1
Xload_slew542 _7823_/RN _7822_/RN VDD VDD VSS VSS gf180mcu_fd_sc_mcu7t5v0__clkbuf_4
Xload_slew553 _7653_/RN _7652_/RN VDD VDD VSS VSS gf180mcu_fd_sc_mcu7t5v0__clkbuf_4
Xload_slew564 wire565/Z _7755_/RN VDD VDD VSS VSS gf180mcu_fd_sc_mcu7t5v0__clkbuf_4
Xload_slew575 _7613_/RN _7612_/RN VDD VDD VSS VSS gf180mcu_fd_sc_mcu7t5v0__buf_3
Xload_slew597 _7690_/RN _7695_/RN VDD VDD VSS VSS gf180mcu_fd_sc_mcu7t5v0__buf_4
XFILLER_85_638 VDD VDD VSS VSS gf180mcu_fd_sc_mcu7t5v0__fill_1
XFILLER_38_521 VDD VDD VSS VSS gf180mcu_fd_sc_mcu7t5v0__fillcap_4
Xload_slew586 _7560_/RN _7693_/RN VDD VDD VSS VSS gf180mcu_fd_sc_mcu7t5v0__buf_4
X_5043_ _7236_/Q _5050_/A2 _5044_/B VDD VDD VSS VSS gf180mcu_fd_sc_mcu7t5v0__nand2_1
XFILLER_66_874 VDD VDD VSS VSS gf180mcu_fd_sc_mcu7t5v0__fill_1
X_6994_ _6994_/D _7252_/CLK _6994_/Q VDD VDD VSS VSS gf180mcu_fd_sc_mcu7t5v0__dffq_1
XTAP_TAPCELL_ROW_36_766 VDD VSS gf180mcu_fd_sc_mcu7t5v0__filltie
X_5945_ _3730_/Z _5813_/Z _5945_/B _5945_/C _5946_/B2 VDD VDD VSS VSS gf180mcu_fd_sc_mcu7t5v0__oai211_1
X_5876_ _5997_/C _5876_/A2 _5876_/B _6246_/C _5882_/A1 VDD VDD VSS VSS gf180mcu_fd_sc_mcu7t5v0__oai211_1
XFILLER_80_387 VDD VDD VSS VSS gf180mcu_fd_sc_mcu7t5v0__fill_1
X_4827_ _7128_/Q _4840_/A2 _4828_/B VDD VDD VSS VSS gf180mcu_fd_sc_mcu7t5v0__nand2_1
X_7615_ _7615_/D _7703_/RN _7703_/CLK _7615_/Q VDD VDD VSS VSS gf180mcu_fd_sc_mcu7t5v0__dffrnq_1
X_4758_ _4786_/A1 _4770_/A2 _4758_/B _7093_/D VDD VDD VSS VSS gf180mcu_fd_sc_mcu7t5v0__oai21_1
X_7546_ _7546_/D _7800_/RN _7796_/CLK _7546_/Q VDD VDD VSS VSS gf180mcu_fd_sc_mcu7t5v0__dffrnq_1
X_4689_ _7059_/Q _4700_/A2 _4690_/B VDD VDD VSS VSS gf180mcu_fd_sc_mcu7t5v0__nand2_1
X_7477_ _7477_/D _7490_/CLK _7477_/Q VDD VDD VSS VSS gf180mcu_fd_sc_mcu7t5v0__dffq_1
X_3709_ _7544_/Q _3708_/Z _7794_/D VDD VDD VSS VSS gf180mcu_fd_sc_mcu7t5v0__nand2_1
X_6428_ _7663_/Q _6427_/Z _6479_/S _7663_/D VDD VDD VSS VSS gf180mcu_fd_sc_mcu7t5v0__mux2_2
XFILLER_115_570 VDD VDD VSS VSS gf180mcu_fd_sc_mcu7t5v0__fill_1
XTAP_TAPCELL_ROW_112_1824 VDD VSS gf180mcu_fd_sc_mcu7t5v0__filltie
XFILLER_103_721 VDD VDD VSS VSS gf180mcu_fd_sc_mcu7t5v0__fill_1
X_6359_ wire513/I input36/Z _7782_/D _7645_/D VDD VDD VSS VSS gf180mcu_fd_sc_mcu7t5v0__mux2_2
XFILLER_88_454 VDD VDD VSS VSS gf180mcu_fd_sc_mcu7t5v0__fill_1
XFILLER_57_830 VDD VDD VSS VSS gf180mcu_fd_sc_mcu7t5v0__fill_2
XFILLER_29_554 VDD VDD VSS VSS gf180mcu_fd_sc_mcu7t5v0__fillcap_4
XFILLER_72_888 VDD VDD VSS VSS gf180mcu_fd_sc_mcu7t5v0__fill_1
XTAP_TAPCELL_ROW_14_449 VDD VSS gf180mcu_fd_sc_mcu7t5v0__filltie
XFILLER_113_507 VDD VDD VSS VSS gf180mcu_fd_sc_mcu7t5v0__fill_1
XFILLER_48_874 VDD VDD VSS VSS gf180mcu_fd_sc_mcu7t5v0__fill_1
XTAP_TAPCELL_ROW_85_1447 VDD VSS gf180mcu_fd_sc_mcu7t5v0__filltie
X_3991_ _6750_/Q _4420_/A2 _3992_/B VDD VDD VSS VSS gf180mcu_fd_sc_mcu7t5v0__nand2_1
XFILLER_90_663 VDD VDD VSS VSS gf180mcu_fd_sc_mcu7t5v0__fill_2
XFILLER_63_899 VDD VDD VSS VSS gf180mcu_fd_sc_mcu7t5v0__fillcap_8
X_5730_ _7634_/Q _5730_/A2 _5730_/B _5730_/C _5731_/C VDD VDD VSS VSS gf180mcu_fd_sc_mcu7t5v0__oai211_1
XTAP_TAPCELL_ROW_33_714 VDD VSS gf180mcu_fd_sc_mcu7t5v0__filltie
XTAP_TAPCELL_ROW_33_725 VDD VSS gf180mcu_fd_sc_mcu7t5v0__filltie
X_7400_ _7400_/D _7456_/CLK _7400_/Q VDD VDD VSS VSS gf180mcu_fd_sc_mcu7t5v0__dffq_1
X_5661_ _7542_/Q input39/Z _5661_/S _7542_/D VDD VDD VSS VSS gf180mcu_fd_sc_mcu7t5v0__mux2_2
X_4612_ wire240/Z _4616_/A2 _4612_/B _7020_/D VDD VDD VSS VSS gf180mcu_fd_sc_mcu7t5v0__oai21_1
X_5592_ _5592_/A1 _5592_/A2 _5602_/A2 VDD VDD VSS VSS gf180mcu_fd_sc_mcu7t5v0__nor2_1
X_4543_ _6986_/Q _4546_/A2 _4544_/B VDD VDD VSS VSS gf180mcu_fd_sc_mcu7t5v0__nand2_1
XFILLER_8_981 VDD VDD VSS VSS gf180mcu_fd_sc_mcu7t5v0__fill_1
X_7331_ _7331_/D _7804_/CLK _7331_/Q VDD VDD VSS VSS gf180mcu_fd_sc_mcu7t5v0__dffq_1
X_7262_ _7262_/D _7266_/CLK _7262_/Q VDD VDD VSS VSS gf180mcu_fd_sc_mcu7t5v0__dffq_1
X_4474_ _5118_/A1 _4476_/A2 _4474_/B _6951_/D VDD VDD VSS VSS gf180mcu_fd_sc_mcu7t5v0__oai21_1
XTAP_TAPCELL_ROW_96_1598 VDD VSS gf180mcu_fd_sc_mcu7t5v0__filltie
X_6213_ _6213_/A1 _6213_/A2 _6217_/A1 VDD VDD VSS VSS gf180mcu_fd_sc_mcu7t5v0__nor2_1
X_3425_ _7652_/Q _6372_/A1 VDD VDD VSS VSS gf180mcu_fd_sc_mcu7t5v0__clkinv_1
X_7193_ _7193_/D _7218_/CLK _7193_/Q VDD VDD VSS VSS gf180mcu_fd_sc_mcu7t5v0__dffq_1
X_6144_ _7092_/Q _6144_/A2 _6153_/B1 _7078_/Q _6146_/A1 VDD VDD VSS VSS gf180mcu_fd_sc_mcu7t5v0__oai22_1
XFILLER_38_18 VDD VDD VSS VSS gf180mcu_fd_sc_mcu7t5v0__fill_2
X_3356_ _7751_/Q _3932_/A2 VDD VDD VSS VSS gf180mcu_fd_sc_mcu7t5v0__clkinv_1
X_6075_ _6075_/A1 _6075_/A2 _6224_/B _6082_/A2 VDD VDD VSS VSS gf180mcu_fd_sc_mcu7t5v0__oai21_1
XFILLER_86_947 VDD VDD VSS VSS gf180mcu_fd_sc_mcu7t5v0__fillcap_32
Xload_slew383 _5610_/B1 _5562_/A2 VDD VDD VSS VSS gf180mcu_fd_sc_mcu7t5v0__clkbuf_4
Xload_slew372 _5559_/B1 _5610_/C2 VDD VDD VSS VSS gf180mcu_fd_sc_mcu7t5v0__buf_2
Xload_slew361 _6242_/B1 _6228_/A2 VDD VDD VSS VSS gf180mcu_fd_sc_mcu7t5v0__buf_4
Xload_slew350 _6233_/B1 _6235_/B1 VDD VDD VSS VSS gf180mcu_fd_sc_mcu7t5v0__buf_4
Xload_slew394 _5744_/B _6298_/A2 VDD VDD VSS VSS gf180mcu_fd_sc_mcu7t5v0__buf_4
X_5026_ _5068_/A1 _5036_/A2 _5026_/B _7227_/D VDD VDD VSS VSS gf180mcu_fd_sc_mcu7t5v0__oai21_1
XFILLER_26_524 VDD VDD VSS VSS gf180mcu_fd_sc_mcu7t5v0__fill_1
X_6977_ _6977_/D _7687_/CLK _6977_/Q VDD VDD VSS VSS gf180mcu_fd_sc_mcu7t5v0__dffq_1
XFILLER_54_877 VDD VDD VSS VSS gf180mcu_fd_sc_mcu7t5v0__fillcap_64
X_5928_ _7067_/Q _6192_/A2 wire341/Z _6990_/Q _6836_/Q _6177_/C2 _5929_/A2 VDD VDD
+ VSS VSS gf180mcu_fd_sc_mcu7t5v0__oai222_1
X_5859_ _7031_/Q _6153_/A2 _6208_/C _5860_/A2 VDD VDD VSS VSS gf180mcu_fd_sc_mcu7t5v0__oai21_1
XTAP_TAPCELL_ROW_11_419 VDD VSS gf180mcu_fd_sc_mcu7t5v0__filltie
XTAP_TAPCELL_ROW_11_408 VDD VSS gf180mcu_fd_sc_mcu7t5v0__filltie
XFILLER_10_947 VDD VDD VSS VSS gf180mcu_fd_sc_mcu7t5v0__fillcap_32
X_7529_ _7529_/D _7599_/RN _7669_/CLK _7529_/Q VDD VDD VSS VSS gf180mcu_fd_sc_mcu7t5v0__dffrnq_1
XTAP_TAPCELL_ROW_56_1037 VDD VSS gf180mcu_fd_sc_mcu7t5v0__filltie
XTAP_TAPCELL_ROW_56_1048 VDD VSS gf180mcu_fd_sc_mcu7t5v0__filltie
XFILLER_49_627 VDD VDD VSS VSS gf180mcu_fd_sc_mcu7t5v0__fill_2
XFILLER_49_649 VDD VDD VSS VSS gf180mcu_fd_sc_mcu7t5v0__fill_1
XTAP_TAPCELL_ROW_19_519 VDD VSS gf180mcu_fd_sc_mcu7t5v0__filltie
XFILLER_44_387 VDD VDD VSS VSS gf180mcu_fd_sc_mcu7t5v0__fill_2
XTAP_TAPCELL_ROW_67_1199 VDD VSS gf180mcu_fd_sc_mcu7t5v0__filltie
XTAP_TAPCELL_ROW_80_1377 VDD VSS gf180mcu_fd_sc_mcu7t5v0__filltie
XFILLER_8_299 VDD VDD VSS VSS gf180mcu_fd_sc_mcu7t5v0__fill_1
X_4190_ wire507/Z _6812_/Q _5211_/S _6812_/D VDD VDD VSS VSS gf180mcu_fd_sc_mcu7t5v0__mux2_2
XFILLER_68_947 VDD VDD VSS VSS gf180mcu_fd_sc_mcu7t5v0__fillcap_32
XPHY_EDGE_ROW_19_Left_138 VDD VSS gf180mcu_fd_sc_mcu7t5v0__endcap
XFILLER_54_107 VDD VDD VSS VSS gf180mcu_fd_sc_mcu7t5v0__fill_1
X_6900_ _6900_/D _7148_/CLK _6900_/Q VDD VDD VSS VSS gf180mcu_fd_sc_mcu7t5v0__dffq_1
X_7880_ _7880_/I _7880_/Z VDD VDD VSS VSS gf180mcu_fd_sc_mcu7t5v0__buf_1
X_6831_ _6831_/D _7490_/CLK _6831_/Q VDD VDD VSS VSS gf180mcu_fd_sc_mcu7t5v0__dffq_1
XFILLER_36_877 VDD VDD VSS VSS gf180mcu_fd_sc_mcu7t5v0__fillcap_64
X_6762_ _6762_/D _7002_/CLK _6762_/Q VDD VDD VSS VSS gf180mcu_fd_sc_mcu7t5v0__dffq_1
X_3974_ _4147_/A1 _3999_/A2 _4350_/A2 VDD VDD VSS VSS gf180mcu_fd_sc_mcu7t5v0__nand2_1
XFILLER_16_590 VDD VDD VSS VSS gf180mcu_fd_sc_mcu7t5v0__fillcap_4
X_6693_ _6693_/A1 _6679_/S _6694_/B2 VDD VDD VSS VSS gf180mcu_fd_sc_mcu7t5v0__nand2_1
X_5713_ _7615_/Q _6490_/A1 _7621_/Q _6508_/A1 _5714_/A3 VDD VDD VSS VSS gf180mcu_fd_sc_mcu7t5v0__oai22_1
XTAP_TAPCELL_ROW_98_1627 VDD VSS gf180mcu_fd_sc_mcu7t5v0__filltie
X_5644_ _7527_/Q input54/Z _5653_/S _7527_/D VDD VDD VSS VSS gf180mcu_fd_sc_mcu7t5v0__mux2_2
XPHY_EDGE_ROW_28_Left_147 VDD VSS gf180mcu_fd_sc_mcu7t5v0__endcap
X_7314_ _7314_/D _7418_/CLK _7314_/Q VDD VDD VSS VSS gf180mcu_fd_sc_mcu7t5v0__dffq_1
X_5575_ _7351_/Q _5593_/A2 wire420/Z _7337_/Q _5576_/A3 VDD VDD VSS VSS gf180mcu_fd_sc_mcu7t5v0__oai22_1
X_4526_ _4540_/A1 _4532_/A2 _4526_/B _6977_/D VDD VDD VSS VSS gf180mcu_fd_sc_mcu7t5v0__oai21_1
X_4457_ _6943_/Q _4462_/A2 _4458_/B VDD VDD VSS VSS gf180mcu_fd_sc_mcu7t5v0__nand2_1
XFILLER_105_838 VDD VDD VSS VSS gf180mcu_fd_sc_mcu7t5v0__fill_2
X_7245_ _7245_/D _7248_/CLK _7245_/Q VDD VDD VSS VSS gf180mcu_fd_sc_mcu7t5v0__dffq_1
X_3408_ _7630_/Q _6340_/A1 VDD VDD VSS VSS gf180mcu_fd_sc_mcu7t5v0__clkinv_1
X_7176_ _7176_/D _7453_/CLK _7176_/Q VDD VDD VSS VSS gf180mcu_fd_sc_mcu7t5v0__dffq_1
X_4388_ _5102_/A1 _4392_/A2 _4388_/B _6908_/D VDD VDD VSS VSS gf180mcu_fd_sc_mcu7t5v0__oai21_1
X_6127_ _7549_/Q _6247_/A2 _6254_/B1 _7701_/Q _6271_/B1 _7620_/Q _6129_/A3 VDD VDD
+ VSS VSS gf180mcu_fd_sc_mcu7t5v0__aoi222_1
XFILLER_74_917 VDD VDD VSS VSS gf180mcu_fd_sc_mcu7t5v0__fillcap_16
XPHY_EDGE_ROW_37_Left_156 VDD VSS gf180mcu_fd_sc_mcu7t5v0__endcap
XFILLER_86_777 VDD VDD VSS VSS gf180mcu_fd_sc_mcu7t5v0__fill_1
X_6058_ _6058_/A1 _6058_/A2 _6058_/B _6059_/A2 VDD VDD VSS VSS gf180mcu_fd_sc_mcu7t5v0__oai21_1
X_5009_ _7219_/Q _5022_/A2 _5010_/B VDD VDD VSS VSS gf180mcu_fd_sc_mcu7t5v0__nand2_1
XTAP_TAPCELL_ROW_107_1756 VDD VSS gf180mcu_fd_sc_mcu7t5v0__filltie
XFILLER_54_663 VDD VDD VSS VSS gf180mcu_fd_sc_mcu7t5v0__fill_2
XFILLER_14_20 VDD VDD VSS VSS gf180mcu_fd_sc_mcu7t5v0__fill_1
XFILLER_41_357 VDD VDD VSS VSS gf180mcu_fd_sc_mcu7t5v0__fill_1
XPHY_EDGE_ROW_46_Left_165 VDD VSS gf180mcu_fd_sc_mcu7t5v0__endcap
XTAP_TAPCELL_ROW_24_588 VDD VSS gf180mcu_fd_sc_mcu7t5v0__filltie
XTAP_TAPCELL_ROW_24_599 VDD VSS gf180mcu_fd_sc_mcu7t5v0__filltie
XFILLER_6_737 VDD VDD VSS VSS gf180mcu_fd_sc_mcu7t5v0__fillcap_64
XFILLER_104_882 VDD VDD VSS VSS gf180mcu_fd_sc_mcu7t5v0__fillcap_4
XFILLER_1_486 VDD VDD VSS VSS gf180mcu_fd_sc_mcu7t5v0__fillcap_4
XPHY_EDGE_ROW_55_Left_174 VDD VSS gf180mcu_fd_sc_mcu7t5v0__endcap
XFILLER_39_72 VDD VDD VSS VSS gf180mcu_fd_sc_mcu7t5v0__fill_2
XTAP_TAPCELL_ROW_69_1228 VDD VSS gf180mcu_fd_sc_mcu7t5v0__filltie
XPHY_EDGE_ROW_101_Right_101 VDD VSS gf180mcu_fd_sc_mcu7t5v0__endcap
XFILLER_29_170 VDD VDD VSS VSS gf180mcu_fd_sc_mcu7t5v0__fill_1
XFILLER_18_877 VDD VDD VSS VSS gf180mcu_fd_sc_mcu7t5v0__fillcap_64
XTAP_TAPCELL_ROW_82_1406 VDD VSS gf180mcu_fd_sc_mcu7t5v0__filltie
XFILLER_33_836 VDD VDD VSS VSS gf180mcu_fd_sc_mcu7t5v0__fillcap_4
XPHY_EDGE_ROW_64_Left_183 VDD VSS gf180mcu_fd_sc_mcu7t5v0__endcap
XFILLER_72_493 VDD VDD VSS VSS gf180mcu_fd_sc_mcu7t5v0__fill_2
XTAP_TAPCELL_ROW_43_864 VDD VSS gf180mcu_fd_sc_mcu7t5v0__filltie
XFILLER_9_553 VDD VDD VSS VSS gf180mcu_fd_sc_mcu7t5v0__fillcap_4
X_3690_ _3681_/C _3690_/A2 _3690_/B _3699_/A2 VDD VDD VSS VSS gf180mcu_fd_sc_mcu7t5v0__oai21_1
X_5360_ _7544_/Q _3708_/Z _5625_/C _5367_/A2 VDD VDD VSS VSS gf180mcu_fd_sc_mcu7t5v0__aoi21_1
XTAP_TAPCELL_ROW_93_1557 VDD VSS gf180mcu_fd_sc_mcu7t5v0__filltie
X_4311_ _6870_/Q _4322_/A2 _4312_/B VDD VDD VSS VSS gf180mcu_fd_sc_mcu7t5v0__nand2_1
X_5291_ _5347_/I0 _7438_/Q _5295_/S _7438_/D VDD VDD VSS VSS gf180mcu_fd_sc_mcu7t5v0__mux2_2
X_4242_ _4396_/A1 _4252_/A2 _4242_/B _6835_/D VDD VDD VSS VSS gf180mcu_fd_sc_mcu7t5v0__oai21_1
X_7030_ _7030_/D _7097_/CLK _7030_/Q VDD VDD VSS VSS gf180mcu_fd_sc_mcu7t5v0__dffq_1
XPHY_EDGE_ROW_73_Left_192 VDD VSS gf180mcu_fd_sc_mcu7t5v0__endcap
X_4173_ _4173_/A1 _7733_/Q _6651_/A2 VDD VDD VSS VSS gf180mcu_fd_sc_mcu7t5v0__nor2_2
X_6814_ _6814_/D _7735_/CLK _6814_/Q VDD VDD VSS VSS gf180mcu_fd_sc_mcu7t5v0__dffq_1
X_7794_ _7794_/D _7652_/RN _7794_/CLK _7794_/Q VDD VDD VSS VSS gf180mcu_fd_sc_mcu7t5v0__dffsnq_1
X_6745_ _6745_/D _7008_/CLK _6745_/Q VDD VDD VSS VSS gf180mcu_fd_sc_mcu7t5v0__dffq_1
X_3957_ wire248/I _4294_/A2 _3957_/B _6741_/D VDD VDD VSS VSS gf180mcu_fd_sc_mcu7t5v0__oai21_1
XFILLER_11_508 VDD VDD VSS VSS gf180mcu_fd_sc_mcu7t5v0__fill_1
XTAP_TAPCELL_ROW_102_1686 VDD VSS gf180mcu_fd_sc_mcu7t5v0__filltie
XTAP_TAPCELL_ROW_21_547 VDD VSS gf180mcu_fd_sc_mcu7t5v0__filltie
XTAP_TAPCELL_ROW_21_558 VDD VSS gf180mcu_fd_sc_mcu7t5v0__filltie
X_6676_ _7744_/Q _6717_/A1 _6674_/Z _6676_/A4 _6695_/A2 VDD VDD VSS VSS gf180mcu_fd_sc_mcu7t5v0__nor4_1
X_3888_ _7649_/Q _3872_/Z _3888_/B _3891_/B VDD VDD VSS VSS gf180mcu_fd_sc_mcu7t5v0__oai21_1
X_5627_ _7539_/Q _5627_/A2 _5627_/Z VDD VDD VSS VSS gf180mcu_fd_sc_mcu7t5v0__xor2_1
X_5558_ _7330_/Q _5604_/A2 _5558_/B _5560_/A1 VDD VDD VSS VSS gf180mcu_fd_sc_mcu7t5v0__oai21_1
X_4509_ _6969_/Q _4518_/A2 _4510_/B VDD VDD VSS VSS gf180mcu_fd_sc_mcu7t5v0__nand2_1
Xuart_605 racl_error_o[9] VDD VDD VSS VSS gf180mcu_fd_sc_mcu7t5v0__tiel
X_5489_ _7397_/Q _5578_/A2 _5491_/A2 VDD VDD VSS VSS gf180mcu_fd_sc_mcu7t5v0__nor2_1
XTAP_TAPCELL_ROW_53_1007 VDD VSS gf180mcu_fd_sc_mcu7t5v0__filltie
X_7228_ _7228_/D _7247_/CLK _7228_/Q VDD VDD VSS VSS gf180mcu_fd_sc_mcu7t5v0__dffq_1
Xuart_616 racl_error_o[20] VDD VDD VSS VSS gf180mcu_fd_sc_mcu7t5v0__tiel
Xuart_627 racl_error_o[31] VDD VDD VSS VSS gf180mcu_fd_sc_mcu7t5v0__tiel
Xuart_638 racl_error_o[42] VDD VDD VSS VSS gf180mcu_fd_sc_mcu7t5v0__tiel
Xfanout543 fanout546/Z fanout543/Z VDD VDD VSS VSS gf180mcu_fd_sc_mcu7t5v0__dlyd_1
Xfanout554 input6/Z _7733_/RN VDD VDD VSS VSS gf180mcu_fd_sc_mcu7t5v0__dlyd_1
X_7159_ _7159_/D _7248_/CLK _7159_/Q VDD VDD VSS VSS gf180mcu_fd_sc_mcu7t5v0__dffq_1
XFILLER_101_885 VDD VDD VSS VSS gf180mcu_fd_sc_mcu7t5v0__fillcap_4
Xfanout587 fanout589/Z _7701_/RN VDD VDD VSS VSS gf180mcu_fd_sc_mcu7t5v0__dlyd_1
Xfanout598 input6/Z _7798_/RN VDD VDD VSS VSS gf180mcu_fd_sc_mcu7t5v0__dlyd_1
XFILLER_100_384 VDD VDD VSS VSS gf180mcu_fd_sc_mcu7t5v0__fill_1
XTAP_TAPCELL_ROW_29_658 VDD VSS gf180mcu_fd_sc_mcu7t5v0__filltie
XTAP_TAPCELL_ROW_29_669 VDD VSS gf180mcu_fd_sc_mcu7t5v0__filltie
XFILLER_15_836 VDD VDD VSS VSS gf180mcu_fd_sc_mcu7t5v0__fillcap_4
XTAP_TAPCELL_ROW_1_272 VDD VSS gf180mcu_fd_sc_mcu7t5v0__filltie
XFILLER_27_696 VDD VDD VSS VSS gf180mcu_fd_sc_mcu7t5v0__fillcap_4
XTAP_TAPCELL_ROW_64_1158 VDD VSS gf180mcu_fd_sc_mcu7t5v0__filltie
XFILLER_70_942 VDD VDD VSS VSS gf180mcu_fd_sc_mcu7t5v0__fill_2
XTAP_TAPCELL_ROW_40_812 VDD VSS gf180mcu_fd_sc_mcu7t5v0__filltie
XTAP_TAPCELL_ROW_40_823 VDD VSS gf180mcu_fd_sc_mcu7t5v0__filltie
XFILLER_10_574 VDD VDD VSS VSS gf180mcu_fd_sc_mcu7t5v0__fillcap_16
XTAP_TAPCELL_ROW_9_383 VDD VSS gf180mcu_fd_sc_mcu7t5v0__filltie
XFILLER_104_690 VDD VDD VSS VSS gf180mcu_fd_sc_mcu7t5v0__fill_2
XFILLER_77_541 VDD VDD VSS VSS gf180mcu_fd_sc_mcu7t5v0__fillcap_16
XTAP_TAPCELL_ROW_48_934 VDD VSS gf180mcu_fd_sc_mcu7t5v0__filltie
XFILLER_80_739 VDD VDD VSS VSS gf180mcu_fd_sc_mcu7t5v0__fill_1
X_4860_ _5014_/A1 _4868_/A2 _4860_/B _7144_/D VDD VDD VSS VSS gf180mcu_fd_sc_mcu7t5v0__oai21_1
X_3811_ _3812_/A1 _3811_/A2 _3811_/B _7776_/D VDD VDD VSS VSS gf180mcu_fd_sc_mcu7t5v0__oai21_1
XANTENNA_17 alert_rx_i[3] VDD VDD VSS VSS gf180mcu_fd_sc_mcu7t5v0__antenna
X_6530_ _7685_/Q _6526_/Z _7686_/Q _6532_/A2 VDD VDD VSS VSS gf180mcu_fd_sc_mcu7t5v0__aoi21_1
X_4791_ _7110_/Q _4798_/A2 _4792_/B VDD VDD VSS VSS gf180mcu_fd_sc_mcu7t5v0__nand2_1
X_3742_ _7546_/Q _7545_/Q _7547_/Q _3756_/B1 VDD VDD VSS VSS gf180mcu_fd_sc_mcu7t5v0__oai21_1
XFILLER_70_2 VDD VDD VSS VSS gf180mcu_fd_sc_mcu7t5v0__fill_1
X_6461_ _6459_/Z _6469_/C _6463_/A1 VDD VDD VSS VSS gf180mcu_fd_sc_mcu7t5v0__nand2_1
X_3673_ _7882_/I _5690_/A1 _3673_/A3 _5813_/A2 _7879_/I _3675_/B VDD VDD VSS VSS gf180mcu_fd_sc_mcu7t5v0__oai32_1
X_6392_ _7658_/Q _7524_/Q _6400_/B VDD VDD VSS VSS gf180mcu_fd_sc_mcu7t5v0__nand2_1
XPHY_EDGE_ROW_81_Left_200 VDD VSS gf180mcu_fd_sc_mcu7t5v0__endcap
X_5412_ _7486_/Q wire428/I _5412_/B1 _7479_/Q _5531_/B _5413_/A2 VDD VDD VSS VSS gf180mcu_fd_sc_mcu7t5v0__oai221_1
Xoutput124 _7882_/Z racl_error_o[5] VDD VDD VSS VSS gf180mcu_fd_sc_mcu7t5v0__dlyd_1
X_5343_ _5343_/I0 _7490_/Q _5344_/S _7490_/D VDD VDD VSS VSS gf180mcu_fd_sc_mcu7t5v0__mux2_2
Xoutput113 _7807_/Q intr_rx_overflow_o VDD VDD VSS VSS gf180mcu_fd_sc_mcu7t5v0__dlyd_1
Xoutput146 _3828_/Z tl_o[2] VDD VDD VSS VSS gf180mcu_fd_sc_mcu7t5v0__dlyd_1
Xoutput168 _7605_/Q tl_o[50] VDD VDD VSS VSS gf180mcu_fd_sc_mcu7t5v0__dlyd_1
Xoutput157 _3910_/Z tl_o[3] VDD VDD VSS VSS gf180mcu_fd_sc_mcu7t5v0__dlyd_1
Xoutput135 _7883_/Z tl_o[1] VDD VDD VSS VSS gf180mcu_fd_sc_mcu7t5v0__dlyd_1
Xoutput179 _7886_/Z tl_o[65] VDD VDD VSS VSS gf180mcu_fd_sc_mcu7t5v0__dlyd_1
X_5274_ _5309_/I0 _7421_/Q _5274_/S _7421_/D VDD VDD VSS VSS gf180mcu_fd_sc_mcu7t5v0__mux2_2
X_7013_ _7013_/D _7062_/CLK _7013_/Q VDD VDD VSS VSS gf180mcu_fd_sc_mcu7t5v0__dffq_1
X_4225_ wire507/Z _6827_/Q _5316_/S _6827_/D VDD VDD VSS VSS gf180mcu_fd_sc_mcu7t5v0__mux2_2
X_4156_ _6654_/A1 _4155_/Z _4203_/A1 VDD VDD VSS VSS gf180mcu_fd_sc_mcu7t5v0__nand2_1
XFILLER_29_906 VDD VDD VSS VSS gf180mcu_fd_sc_mcu7t5v0__fillcap_4
X_4087_ _6780_/Q _4840_/A2 _4088_/B VDD VDD VSS VSS gf180mcu_fd_sc_mcu7t5v0__nand2_1
XTAP_TAPCELL_ROW_104_1715 VDD VSS gf180mcu_fd_sc_mcu7t5v0__filltie
XTAP_TAPCELL_ROW_26_617 VDD VSS gf180mcu_fd_sc_mcu7t5v0__filltie
XTAP_TAPCELL_ROW_26_628 VDD VSS gf180mcu_fd_sc_mcu7t5v0__filltie
X_7777_ _7777_/D _7825_/RN clkload8/I _7777_/Q VDD VDD VSS VSS gf180mcu_fd_sc_mcu7t5v0__dffrnq_1
X_4989_ _7209_/Q _4994_/A2 _4990_/B VDD VDD VSS VSS gf180mcu_fd_sc_mcu7t5v0__nand2_1
X_6728_ _6730_/A1 _6727_/Z _6728_/B _7544_/Q _6729_/A2 VDD VDD VSS VSS gf180mcu_fd_sc_mcu7t5v0__oai211_1
X_6659_ _6659_/A1 _6659_/A2 _7736_/D VDD VDD VSS VSS gf180mcu_fd_sc_mcu7t5v0__nor2_1
XTAP_TAPCELL_ROW_115_1866 VDD VSS gf180mcu_fd_sc_mcu7t5v0__filltie
XFILLER_79_839 VDD VDD VSS VSS gf180mcu_fd_sc_mcu7t5v0__fill_1
XTAP_TAPCELL_ROW_6_342 VDD VSS gf180mcu_fd_sc_mcu7t5v0__filltie
Xfanout384 _5596_/A2 _5600_/C2 VDD VDD VSS VSS gf180mcu_fd_sc_mcu7t5v0__dlyd_1
Xfanout373 _5373_/Z _5600_/B1 VDD VDD VSS VSS gf180mcu_fd_sc_mcu7t5v0__dlyd_1
Xfanout395 _6242_/A2 _6593_/A2 VDD VDD VSS VSS gf180mcu_fd_sc_mcu7t5v0__dlyd_1
XFILLER_36_51 VDD VDD VSS VSS gf180mcu_fd_sc_mcu7t5v0__fill_1
XFILLER_42_452 VDD VDD VSS VSS gf180mcu_fd_sc_mcu7t5v0__fill_2
Xinput15 tl_i[10] input15/Z VDD VDD VSS VSS gf180mcu_fd_sc_mcu7t5v0__dlyd_1
Xinput26 tl_i[17] input26/Z VDD VDD VSS VSS gf180mcu_fd_sc_mcu7t5v0__dlyd_1
Xinput37 tl_i[36] input37/Z VDD VDD VSS VSS gf180mcu_fd_sc_mcu7t5v0__dlyd_1
XTAP_TAPCELL_ROW_77_1338 VDD VSS gf180mcu_fd_sc_mcu7t5v0__filltie
Xinput59 tl_i[56] input59/Z VDD VDD VSS VSS gf180mcu_fd_sc_mcu7t5v0__dlyd_1
Xclkbuf_leaf_4_clk_i clkload0/I _7804_/CLK VDD VDD VSS VSS gf180mcu_fd_sc_mcu7t5v0__clkbuf_8
Xinput48 tl_i[46] input48/Z VDD VDD VSS VSS gf180mcu_fd_sc_mcu7t5v0__dlyd_1
XTAP_TAPCELL_ROW_90_1516 VDD VSS gf180mcu_fd_sc_mcu7t5v0__filltie
XFILLER_112_947 VDD VDD VSS VSS gf180mcu_fd_sc_mcu7t5v0__fillcap_32
XFILLER_69_327 VDD VDD VSS VSS gf180mcu_fd_sc_mcu7t5v0__fill_2
X_4010_ _6756_/Q _4504_/A2 _4011_/B VDD VDD VSS VSS gf180mcu_fd_sc_mcu7t5v0__nand2_1
X_5961_ _5961_/A1 _5961_/A2 _5994_/A1 VDD VDD VSS VSS gf180mcu_fd_sc_mcu7t5v0__nor2_1
XFILLER_93_897 VDD VDD VSS VSS gf180mcu_fd_sc_mcu7t5v0__fill_1
XTAP_TAPCELL_ROW_88_1489 VDD VSS gf180mcu_fd_sc_mcu7t5v0__filltie
X_4912_ _4940_/A1 _4924_/A2 _4912_/B _7170_/D VDD VDD VSS VSS gf180mcu_fd_sc_mcu7t5v0__oai21_1
X_7700_ _7700_/D _7701_/RN _7792_/CLK _7700_/Q VDD VDD VSS VSS gf180mcu_fd_sc_mcu7t5v0__dffrnq_1
X_5892_ _5892_/I _5893_/B VDD VDD VSS VSS gf180mcu_fd_sc_mcu7t5v0__clkinv_1
X_7631_ _7631_/D _7706_/RN _7693_/CLK _7631_/Q VDD VDD VSS VSS gf180mcu_fd_sc_mcu7t5v0__dffrnq_1
X_4843_ _7136_/Q _4854_/A2 _4844_/B VDD VDD VSS VSS gf180mcu_fd_sc_mcu7t5v0__nand2_1
X_4774_ wire268/Z _4784_/A2 _4774_/B _7101_/D VDD VDD VSS VSS gf180mcu_fd_sc_mcu7t5v0__oai21_1
X_7562_ _7562_/D _7652_/RN _7794_/CLK _7562_/Q VDD VDD VSS VSS gf180mcu_fd_sc_mcu7t5v0__dffrnq_1
X_7493_ _7493_/D _7500_/CLK _7493_/Q VDD VDD VSS VSS gf180mcu_fd_sc_mcu7t5v0__dffq_1
XTAP_TAPCELL_ROW_31_686 VDD VSS gf180mcu_fd_sc_mcu7t5v0__filltie
X_3725_ _6641_/A1 _4161_/A2 _3725_/B _3728_/A1 VDD VDD VSS VSS gf180mcu_fd_sc_mcu7t5v0__oai21_1
X_6513_ _7679_/Q _7680_/Q _6516_/A4 _6517_/A2 VDD VDD VSS VSS gf180mcu_fd_sc_mcu7t5v0__nand3_1
X_6444_ _6436_/Z _6440_/Z _6449_/A3 VDD VDD VSS VSS gf180mcu_fd_sc_mcu7t5v0__nor2_1
XTAP_TAPCELL_ROW_31_697 VDD VSS gf180mcu_fd_sc_mcu7t5v0__filltie
X_3656_ _3605_/Z _3612_/Z _3654_/Z _3655_/Z _3657_/C VDD VDD VSS VSS gf180mcu_fd_sc_mcu7t5v0__aoi22_1
X_6375_ _3760_/B _6373_/S _6375_/B _7654_/D VDD VDD VSS VSS gf180mcu_fd_sc_mcu7t5v0__oai21_1
X_3587_ input32/Z input31/Z input85/Z _3587_/Z VDD VDD VSS VSS gf180mcu_fd_sc_mcu7t5v0__xor3_1
XFILLER_0_507 VDD VDD VSS VSS gf180mcu_fd_sc_mcu7t5v0__fill_2
X_5326_ _5347_/I0 _7473_/Q _5330_/S _7473_/D VDD VDD VSS VSS gf180mcu_fd_sc_mcu7t5v0__mux2_2
X_5257_ wire525/Z _7404_/Q _5260_/S _7404_/D VDD VDD VSS VSS gf180mcu_fd_sc_mcu7t5v0__mux2_2
XTAP_TAPCELL_ROW_3_301 VDD VSS gf180mcu_fd_sc_mcu7t5v0__filltie
X_4208_ _6651_/A1 _4210_/A2 _5267_/S VDD VDD VSS VSS gf180mcu_fd_sc_mcu7t5v0__nand2_1
XTAP_TAPCELL_ROW_110_1796 VDD VSS gf180mcu_fd_sc_mcu7t5v0__filltie
X_5188_ _5244_/I0 _7335_/Q _5190_/S _7335_/D VDD VDD VSS VSS gf180mcu_fd_sc_mcu7t5v0__mux2_2
X_4139_ _6797_/Q _5075_/A2 _4140_/B VDD VDD VSS VSS gf180mcu_fd_sc_mcu7t5v0__nor2_1
XFILLER_71_514 VDD VDD VSS VSS gf180mcu_fd_sc_mcu7t5v0__fill_2
XFILLER_52_772 VDD VDD VSS VSS gf180mcu_fd_sc_mcu7t5v0__fill_1
XFILLER_52_761 VDD VDD VSS VSS gf180mcu_fd_sc_mcu7t5v0__fill_2
XTAP_TAPCELL_ROW_61_1106 VDD VSS gf180mcu_fd_sc_mcu7t5v0__filltie
XTAP_TAPCELL_ROW_61_1117 VDD VSS gf180mcu_fd_sc_mcu7t5v0__filltie
XTAP_TAPCELL_ROW_50_962 VDD VSS gf180mcu_fd_sc_mcu7t5v0__filltie
XFILLER_106_752 VDD VDD VSS VSS gf180mcu_fd_sc_mcu7t5v0__fill_2
XTAP_TAPCELL_ROW_59_1079 VDD VSS gf180mcu_fd_sc_mcu7t5v0__filltie
XFILLER_0_2 VDD VDD VSS VSS gf180mcu_fd_sc_mcu7t5v0__fill_2
XTAP_TAPCELL_ROW_72_1268 VDD VSS gf180mcu_fd_sc_mcu7t5v0__filltie
XFILLER_87_680 VDD VDD VSS VSS gf180mcu_fd_sc_mcu7t5v0__fillcap_4
XFILLER_31_912 VDD VDD VSS VSS gf180mcu_fd_sc_mcu7t5v0__fillcap_64
XFILLER_43_772 VDD VDD VSS VSS gf180mcu_fd_sc_mcu7t5v0__fillcap_64
XFILLER_8_88 VDD VDD VSS VSS gf180mcu_fd_sc_mcu7t5v0__fill_2
X_3510_ _3510_/A1 _3926_/A3 _7802_/D VDD VDD VSS VSS gf180mcu_fd_sc_mcu7t5v0__xnor2_1
X_4490_ _4532_/A1 _4490_/A2 _4490_/B _6959_/D VDD VDD VSS VSS gf180mcu_fd_sc_mcu7t5v0__oai21_1
XFILLER_116_516 VDD VDD VSS VSS gf180mcu_fd_sc_mcu7t5v0__fill_1
Xwire593 wire593/I wire593/Z VDD VDD VSS VSS gf180mcu_fd_sc_mcu7t5v0__clkbuf_4
X_3441_ _7584_/Q _6263_/A1 VDD VDD VSS VSS gf180mcu_fd_sc_mcu7t5v0__clkinv_1
XFILLER_6_172 VDD VDD VSS VSS gf180mcu_fd_sc_mcu7t5v0__fill_2
X_6160_ _6160_/A1 _6160_/A2 _6170_/A2 VDD VDD VSS VSS gf180mcu_fd_sc_mcu7t5v0__nor2_1
X_3372_ _6244_/C _6231_/C VDD VDD VSS VSS gf180mcu_fd_sc_mcu7t5v0__clkinv_1
X_5111_ _7270_/Q _5120_/A2 _5112_/B VDD VDD VSS VSS gf180mcu_fd_sc_mcu7t5v0__nand2_1
XFILLER_97_422 VDD VDD VSS VSS gf180mcu_fd_sc_mcu7t5v0__fill_2
Xload_slew532 _6354_/I0 _5332_/I0 VDD VDD VSS VSS gf180mcu_fd_sc_mcu7t5v0__buf_4
XFILLER_33_2 VDD VDD VSS VSS gf180mcu_fd_sc_mcu7t5v0__fill_2
Xload_slew510 _5239_/I0 _5344_/I0 VDD VDD VSS VSS gf180mcu_fd_sc_mcu7t5v0__clkbuf_4
X_6091_ _6846_/Q _6091_/A2 _6197_/B _6093_/A1 VDD VDD VSS VSS gf180mcu_fd_sc_mcu7t5v0__oai21_1
XFILLER_69_157 VDD VDD VSS VSS gf180mcu_fd_sc_mcu7t5v0__fill_1
XFILLER_100_939 VDD VDD VSS VSS gf180mcu_fd_sc_mcu7t5v0__fillcap_4
X_5042_ _5056_/A1 _5050_/A2 _5042_/B _7235_/D VDD VDD VSS VSS gf180mcu_fd_sc_mcu7t5v0__oai21_1
Xload_slew576 _7613_/RN _7589_/RN VDD VDD VSS VSS gf180mcu_fd_sc_mcu7t5v0__buf_2
XFILLER_93_661 VDD VDD VSS VSS gf180mcu_fd_sc_mcu7t5v0__fill_2
XFILLER_65_374 VDD VDD VSS VSS gf180mcu_fd_sc_mcu7t5v0__fill_2
X_6993_ _6993_/D _7254_/CLK _6993_/Q VDD VDD VSS VSS gf180mcu_fd_sc_mcu7t5v0__dffq_1
XTAP_TAPCELL_ROW_36_756 VDD VSS gf180mcu_fd_sc_mcu7t5v0__filltie
XTAP_TAPCELL_ROW_36_767 VDD VSS gf180mcu_fd_sc_mcu7t5v0__filltie
X_5944_ _5625_/C _5809_/I _5944_/B _5945_/C VDD VDD VSS VSS gf180mcu_fd_sc_mcu7t5v0__aoi21_1
X_5875_ _5997_/C _5875_/A2 _5875_/A3 _5876_/B VDD VDD VSS VSS gf180mcu_fd_sc_mcu7t5v0__nand3_1
X_7614_ _7614_/D _7614_/RN _7710_/CLK _7614_/Q VDD VDD VSS VSS gf180mcu_fd_sc_mcu7t5v0__dffrnq_1
XTAP_TAPCELL_ROW_16_480 VDD VSS gf180mcu_fd_sc_mcu7t5v0__filltie
XFILLER_33_282 VDD VDD VSS VSS gf180mcu_fd_sc_mcu7t5v0__fill_2
X_4826_ _4826_/A1 _4826_/A2 _4826_/B _7127_/D VDD VDD VSS VSS gf180mcu_fd_sc_mcu7t5v0__oai21_1
X_7545_ _7545_/D _7701_/RN _7796_/CLK _7545_/Q VDD VDD VSS VSS gf180mcu_fd_sc_mcu7t5v0__dffrnq_1
X_4757_ _7093_/Q _4770_/A2 _4758_/B VDD VDD VSS VSS gf180mcu_fd_sc_mcu7t5v0__nand2_1
XFILLER_21_499 VDD VDD VSS VSS gf180mcu_fd_sc_mcu7t5v0__fill_1
X_4688_ _5094_/A1 _4700_/A2 _4688_/B _7058_/D VDD VDD VSS VSS gf180mcu_fd_sc_mcu7t5v0__oai21_1
X_7476_ _7476_/D _7483_/CLK _7476_/Q VDD VDD VSS VSS gf180mcu_fd_sc_mcu7t5v0__dffq_1
X_3708_ _7761_/Q _7762_/Q _7764_/Q _7763_/Q _3708_/Z VDD VDD VSS VSS gf180mcu_fd_sc_mcu7t5v0__or4_1
X_6427_ _6438_/A1 _6438_/A2 _6427_/Z VDD VDD VSS VSS gf180mcu_fd_sc_mcu7t5v0__xor2_1
X_3639_ _3610_/Z _3637_/Z _3638_/Z _3639_/Z VDD VDD VSS VSS gf180mcu_fd_sc_mcu7t5v0__xor3_1
XTAP_TAPCELL_ROW_112_1825 VDD VSS gf180mcu_fd_sc_mcu7t5v0__filltie
XFILLER_89_912 VDD VDD VSS VSS gf180mcu_fd_sc_mcu7t5v0__fill_2
X_6358_ wire517/I input35/Z _7782_/D _7644_/D VDD VDD VSS VSS gf180mcu_fd_sc_mcu7t5v0__mux2_2
X_5309_ _5309_/I0 _7456_/Q _5309_/S _7456_/D VDD VDD VSS VSS gf180mcu_fd_sc_mcu7t5v0__mux2_2
X_6289_ _7530_/Q _6301_/B1 _6290_/B2 VDD VDD VSS VSS gf180mcu_fd_sc_mcu7t5v0__nand2_1
XFILLER_48_319 VDD VDD VSS VSS gf180mcu_fd_sc_mcu7t5v0__fill_1
XFILLER_44_536 VDD VDD VSS VSS gf180mcu_fd_sc_mcu7t5v0__fillcap_8
XFILLER_13_912 VDD VDD VSS VSS gf180mcu_fd_sc_mcu7t5v0__fillcap_64
XFILLER_25_772 VDD VDD VSS VSS gf180mcu_fd_sc_mcu7t5v0__fillcap_64
XFILLER_40_731 VDD VDD VSS VSS gf180mcu_fd_sc_mcu7t5v0__fillcap_4
XFILLER_52_591 VDD VDD VSS VSS gf180mcu_fd_sc_mcu7t5v0__fillcap_4
Xclkbuf_leaf_84_clk_i clkbuf_3_1__f_clk_i/Z _7489_/CLK VDD VDD VSS VSS gf180mcu_fd_sc_mcu7t5v0__clkbuf_8
XFILLER_79_488 VDD VDD VSS VSS gf180mcu_fd_sc_mcu7t5v0__fill_2
XFILLER_48_897 VDD VDD VSS VSS gf180mcu_fd_sc_mcu7t5v0__fillcap_32
Xclkbuf_leaf_22_clk_i clkload1/I _7669_/CLK VDD VDD VSS VSS gf180mcu_fd_sc_mcu7t5v0__clkbuf_8
XTAP_TAPCELL_ROW_85_1448 VDD VSS gf180mcu_fd_sc_mcu7t5v0__filltie
XFILLER_47_396 VDD VDD VSS VSS gf180mcu_fd_sc_mcu7t5v0__fill_2
XFILLER_63_856 VDD VDD VSS VSS gf180mcu_fd_sc_mcu7t5v0__fill_1
X_3990_ _4129_/A1 _3999_/A2 _4420_/A2 VDD VDD VSS VSS gf180mcu_fd_sc_mcu7t5v0__nand2_1
XFILLER_35_558 VDD VDD VSS VSS gf180mcu_fd_sc_mcu7t5v0__fill_2
XFILLER_62_344 VDD VDD VSS VSS gf180mcu_fd_sc_mcu7t5v0__fill_2
XFILLER_90_697 VDD VDD VSS VSS gf180mcu_fd_sc_mcu7t5v0__fill_2
XTAP_TAPCELL_ROW_33_715 VDD VSS gf180mcu_fd_sc_mcu7t5v0__filltie
XTAP_TAPCELL_ROW_33_726 VDD VSS gf180mcu_fd_sc_mcu7t5v0__filltie
Xclkbuf_leaf_37_clk_i clkload5/I _6882_/CLK VDD VDD VSS VSS gf180mcu_fd_sc_mcu7t5v0__clkbuf_8
XFILLER_15_282 VDD VDD VSS VSS gf180mcu_fd_sc_mcu7t5v0__fill_2
X_5660_ _7541_/Q input38/Z _5661_/S _7541_/D VDD VDD VSS VSS gf180mcu_fd_sc_mcu7t5v0__mux2_2
X_4611_ _7020_/Q _4616_/A2 _4612_/B VDD VDD VSS VSS gf180mcu_fd_sc_mcu7t5v0__nand2_1
X_5591_ _6814_/Q _5600_/A2 _5600_/B1 _6815_/Q _6816_/Q _5600_/C2 _5592_/A2 VDD VDD
+ VSS VSS gf180mcu_fd_sc_mcu7t5v0__oai222_1
XFILLER_117_836 VDD VDD VSS VSS gf180mcu_fd_sc_mcu7t5v0__fillcap_4
X_4542_ _4584_/A1 _4546_/A2 _4542_/B _6985_/D VDD VDD VSS VSS gf180mcu_fd_sc_mcu7t5v0__oai21_1
X_7330_ _7330_/D _7489_/CLK _7330_/Q VDD VDD VSS VSS gf180mcu_fd_sc_mcu7t5v0__dffq_1
X_4473_ _6951_/Q _4476_/A2 _4474_/B VDD VDD VSS VSS gf180mcu_fd_sc_mcu7t5v0__nand2_1
X_7261_ _7261_/D _7261_/CLK _7261_/Q VDD VDD VSS VSS gf180mcu_fd_sc_mcu7t5v0__dffq_1
XTAP_TAPCELL_ROW_96_1599 VDD VSS gf180mcu_fd_sc_mcu7t5v0__filltie
X_6212_ _6774_/Q wire355/I _6212_/B1 _6772_/Q _6212_/C _6213_/A2 VDD VDD VSS VSS gf180mcu_fd_sc_mcu7t5v0__oai221_1
X_3424_ _7654_/Q _3760_/B VDD VDD VSS VSS gf180mcu_fd_sc_mcu7t5v0__clkinv_1
XPHY_EDGE_ROW_115_Right_115 VDD VSS gf180mcu_fd_sc_mcu7t5v0__endcap
X_7192_ _7192_/D _7216_/CLK _7192_/Q VDD VDD VSS VSS gf180mcu_fd_sc_mcu7t5v0__dffq_1
X_6143_ _6143_/A1 _6143_/A2 _6143_/B1 _6143_/B2 _6157_/A2 VDD VDD VSS VSS gf180mcu_fd_sc_mcu7t5v0__oai22_1
X_3355_ _7750_/Q _3932_/A1 VDD VDD VSS VSS gf180mcu_fd_sc_mcu7t5v0__clkinv_1
Xload_slew340 wire341/Z _6177_/B1 VDD VDD VSS VSS gf180mcu_fd_sc_mcu7t5v0__buf_4
X_6074_ _6979_/Q _6229_/B1 _6074_/B1 _6986_/Q _6090_/C _6075_/A2 VDD VDD VSS VSS gf180mcu_fd_sc_mcu7t5v0__oai221_1
XFILLER_98_786 VDD VDD VSS VSS gf180mcu_fd_sc_mcu7t5v0__fillcap_16
Xload_slew351 _6104_/A2 _6233_/B1 VDD VDD VSS VSS gf180mcu_fd_sc_mcu7t5v0__buf_4
Xload_slew362 _6252_/A2 _5677_/I VDD VDD VSS VSS gf180mcu_fd_sc_mcu7t5v0__buf_2
XFILLER_39_842 VDD VDD VSS VSS gf180mcu_fd_sc_mcu7t5v0__fillcap_64
X_5025_ _7227_/Q _5036_/A2 _5026_/B VDD VDD VSS VSS gf180mcu_fd_sc_mcu7t5v0__nand2_1
XFILLER_94_981 VDD VDD VSS VSS gf180mcu_fd_sc_mcu7t5v0__fill_1
X_6976_ _6976_/D _7276_/CLK _6976_/Q VDD VDD VSS VSS gf180mcu_fd_sc_mcu7t5v0__dffq_1
X_5927_ _6913_/Q _6131_/A2 _6229_/C _5929_/A1 VDD VDD VSS VSS gf180mcu_fd_sc_mcu7t5v0__oai21_1
XFILLER_34_580 VDD VDD VSS VSS gf180mcu_fd_sc_mcu7t5v0__fillcap_8
XFILLER_22_731 VDD VDD VSS VSS gf180mcu_fd_sc_mcu7t5v0__fillcap_4
X_5858_ _7010_/Q _6153_/B1 wire313/I _7017_/Q _7024_/Q _6144_/A2 _5860_/A1 VDD VDD
+ VSS VSS gf180mcu_fd_sc_mcu7t5v0__oai222_1
XTAP_TAPCELL_ROW_11_409 VDD VSS gf180mcu_fd_sc_mcu7t5v0__filltie
XPHY_EDGE_ROW_17_Right_17 VDD VSS gf180mcu_fd_sc_mcu7t5v0__endcap
X_5789_ _7156_/Q _6235_/A2 _6236_/B1 _7135_/Q _5791_/A1 VDD VDD VSS VSS gf180mcu_fd_sc_mcu7t5v0__oai22_1
X_4809_ _7119_/Q _4812_/A2 _4810_/B VDD VDD VSS VSS gf180mcu_fd_sc_mcu7t5v0__nand2_1
X_7528_ _7528_/D _7595_/RN _7671_/CLK _7528_/Q VDD VDD VSS VSS gf180mcu_fd_sc_mcu7t5v0__dffrnq_1
X_7459_ _7459_/D _7483_/CLK _7459_/Q VDD VDD VSS VSS gf180mcu_fd_sc_mcu7t5v0__dffq_1
XTAP_TAPCELL_ROW_56_1038 VDD VSS gf180mcu_fd_sc_mcu7t5v0__filltie
XTAP_TAPCELL_ROW_56_1049 VDD VSS gf180mcu_fd_sc_mcu7t5v0__filltie
XFILLER_89_764 VDD VDD VSS VSS gf180mcu_fd_sc_mcu7t5v0__fillcap_4
XPHY_EDGE_ROW_26_Right_26 VDD VSS gf180mcu_fd_sc_mcu7t5v0__endcap
XFILLER_17_558 VDD VDD VSS VSS gf180mcu_fd_sc_mcu7t5v0__fill_2
XFILLER_9_702 VDD VDD VSS VSS gf180mcu_fd_sc_mcu7t5v0__fillcap_64
XTAP_TAPCELL_ROW_80_1378 VDD VSS gf180mcu_fd_sc_mcu7t5v0__filltie
XPHY_EDGE_ROW_35_Right_35 VDD VSS gf180mcu_fd_sc_mcu7t5v0__endcap
XPHY_EDGE_ROW_44_Right_44 VDD VSS gf180mcu_fd_sc_mcu7t5v0__endcap
XFILLER_67_458 VDD VDD VSS VSS gf180mcu_fd_sc_mcu7t5v0__fill_2
XFILLER_95_778 VDD VDD VSS VSS gf180mcu_fd_sc_mcu7t5v0__fill_2
XFILLER_76_981 VDD VDD VSS VSS gf180mcu_fd_sc_mcu7t5v0__fill_1
XFILLER_36_801 VDD VDD VSS VSS gf180mcu_fd_sc_mcu7t5v0__fillcap_4
XFILLER_48_650 VDD VDD VSS VSS gf180mcu_fd_sc_mcu7t5v0__fill_2
XFILLER_91_973 VDD VDD VSS VSS gf180mcu_fd_sc_mcu7t5v0__fillcap_4
X_6830_ _6830_/D _7490_/CLK _6830_/Q VDD VDD VSS VSS gf180mcu_fd_sc_mcu7t5v0__dffq_1
XFILLER_62_130 VDD VDD VSS VSS gf180mcu_fd_sc_mcu7t5v0__fill_2
X_6761_ _6761_/D _7276_/CLK _6761_/Q VDD VDD VSS VSS gf180mcu_fd_sc_mcu7t5v0__dffq_1
XFILLER_50_314 VDD VDD VSS VSS gf180mcu_fd_sc_mcu7t5v0__fill_1
XFILLER_51_826 VDD VDD VSS VSS gf180mcu_fd_sc_mcu7t5v0__fill_1
X_3973_ _4085_/A1 _4002_/A2 _3999_/A2 VDD VDD VSS VSS gf180mcu_fd_sc_mcu7t5v0__nor2_1
X_5712_ _6349_/A1 _7693_/Q _7637_/Q _5712_/B2 _5714_/A2 VDD VDD VSS VSS gf180mcu_fd_sc_mcu7t5v0__oai22_1
XPHY_EDGE_ROW_53_Right_53 VDD VSS gf180mcu_fd_sc_mcu7t5v0__endcap
X_6692_ _6717_/A2 _6692_/A2 _6692_/B _6692_/C _7745_/D VDD VDD VSS VSS gf180mcu_fd_sc_mcu7t5v0__oai211_1
XTAP_TAPCELL_ROW_98_1628 VDD VSS gf180mcu_fd_sc_mcu7t5v0__filltie
X_5643_ _7526_/Q input53/Z _5643_/S _7526_/D VDD VDD VSS VSS gf180mcu_fd_sc_mcu7t5v0__mux2_2
X_5574_ _7358_/Q _6632_/A1 _5594_/B1 _7344_/Q _5576_/A2 VDD VDD VSS VSS gf180mcu_fd_sc_mcu7t5v0__oai22_1
X_4525_ _6977_/Q _4532_/A2 _4526_/B VDD VDD VSS VSS gf180mcu_fd_sc_mcu7t5v0__nand2_1
X_7313_ _7313_/D _7492_/CLK _7313_/Q VDD VDD VSS VSS gf180mcu_fd_sc_mcu7t5v0__dffq_1
XFILLER_117_666 VDD VDD VSS VSS gf180mcu_fd_sc_mcu7t5v0__fill_2
Xclkbuf_3_1__f_clk_i clkbuf_0_clk_i/Z clkbuf_3_1__f_clk_i/Z VDD VDD VSS VSS gf180mcu_fd_sc_mcu7t5v0__clkbuf_16
XFILLER_117_699 VDD VDD VSS VSS gf180mcu_fd_sc_mcu7t5v0__fill_1
X_4456_ _5086_/A1 _4462_/A2 _4456_/B _6942_/D VDD VDD VSS VSS gf180mcu_fd_sc_mcu7t5v0__oai21_1
X_7244_ _7244_/D _7247_/CLK _7244_/Q VDD VDD VSS VSS gf180mcu_fd_sc_mcu7t5v0__dffq_1
XPHY_EDGE_ROW_62_Right_62 VDD VSS gf180mcu_fd_sc_mcu7t5v0__endcap
X_4387_ _6908_/Q _4392_/A2 _4388_/B VDD VDD VSS VSS gf180mcu_fd_sc_mcu7t5v0__nand2_1
X_3407_ _7686_/Q _5716_/A2 VDD VDD VSS VSS gf180mcu_fd_sc_mcu7t5v0__clkinv_1
X_7175_ _7175_/D _7189_/CLK _7175_/Q VDD VDD VSS VSS gf180mcu_fd_sc_mcu7t5v0__dffq_1
XFILLER_59_904 VDD VDD VSS VSS gf180mcu_fd_sc_mcu7t5v0__fillcap_4
XFILLER_86_723 VDD VDD VSS VSS gf180mcu_fd_sc_mcu7t5v0__fillcap_4
X_6126_ _7520_/Q _6256_/A2 _5677_/I _7553_/Q _7562_/Q _5691_/I _6129_/A2 VDD VDD VSS
+ VSS gf180mcu_fd_sc_mcu7t5v0__aoi222_1
XFILLER_98_594 VDD VDD VSS VSS gf180mcu_fd_sc_mcu7t5v0__fill_1
X_6057_ _7167_/Q _6241_/A2 _6057_/B _6242_/C _6058_/B VDD VDD VSS VSS gf180mcu_fd_sc_mcu7t5v0__oai211_1
Xload_slew192 _6331_/S _6325_/S VDD VDD VSS VSS gf180mcu_fd_sc_mcu7t5v0__buf_4
X_5008_ _5008_/A1 _5008_/A2 _5008_/B _7218_/D VDD VDD VSS VSS gf180mcu_fd_sc_mcu7t5v0__oai21_1
XTAP_TAPCELL_ROW_107_1757 VDD VSS gf180mcu_fd_sc_mcu7t5v0__filltie
XPHY_EDGE_ROW_71_Right_71 VDD VSS gf180mcu_fd_sc_mcu7t5v0__endcap
X_6959_ _6959_/D _7002_/CLK _6959_/Q VDD VDD VSS VSS gf180mcu_fd_sc_mcu7t5v0__dffq_1
XPHY_EDGE_ROW_101_Left_220 VDD VSS gf180mcu_fd_sc_mcu7t5v0__endcap
XFILLER_22_594 VDD VDD VSS VSS gf180mcu_fd_sc_mcu7t5v0__fill_1
XTAP_TAPCELL_ROW_24_589 VDD VSS gf180mcu_fd_sc_mcu7t5v0__filltie
XPHY_EDGE_ROW_80_Right_80 VDD VSS gf180mcu_fd_sc_mcu7t5v0__endcap
XFILLER_100_2 VDD VDD VSS VSS gf180mcu_fd_sc_mcu7t5v0__fill_1
XFILLER_1_432 VDD VDD VSS VSS gf180mcu_fd_sc_mcu7t5v0__fill_2
XFILLER_89_572 VDD VDD VSS VSS gf180mcu_fd_sc_mcu7t5v0__fill_2
XFILLER_76_200 VDD VDD VSS VSS gf180mcu_fd_sc_mcu7t5v0__fill_1
XFILLER_49_458 VDD VDD VSS VSS gf180mcu_fd_sc_mcu7t5v0__fill_2
XFILLER_18_801 VDD VDD VSS VSS gf180mcu_fd_sc_mcu7t5v0__fillcap_4
XTAP_TAPCELL_ROW_69_1218 VDD VSS gf180mcu_fd_sc_mcu7t5v0__filltie
XFILLER_92_737 VDD VDD VSS VSS gf180mcu_fd_sc_mcu7t5v0__fill_2
XFILLER_58_981 VDD VDD VSS VSS gf180mcu_fd_sc_mcu7t5v0__fill_1
XTAP_TAPCELL_ROW_69_1229 VDD VSS gf180mcu_fd_sc_mcu7t5v0__filltie
XTAP_TAPCELL_ROW_82_1407 VDD VSS gf180mcu_fd_sc_mcu7t5v0__filltie
XTAP_TAPCELL_ROW_43_854 VDD VSS gf180mcu_fd_sc_mcu7t5v0__filltie
XTAP_TAPCELL_ROW_43_865 VDD VSS gf180mcu_fd_sc_mcu7t5v0__filltie
XTAP_TAPCELL_ROW_93_1558 VDD VSS gf180mcu_fd_sc_mcu7t5v0__filltie
X_4310_ _4324_/A1 _4322_/A2 _4310_/B _6869_/D VDD VDD VSS VSS gf180mcu_fd_sc_mcu7t5v0__oai21_1
X_5290_ _6354_/I0 _7437_/Q _5295_/S _7437_/D VDD VDD VSS VSS gf180mcu_fd_sc_mcu7t5v0__mux2_2
X_4241_ _6835_/Q _4252_/A2 _4242_/B VDD VDD VSS VSS gf180mcu_fd_sc_mcu7t5v0__nand2_1
X_4172_ _4238_/I0 _6805_/Q _5162_/S _6805_/D VDD VDD VSS VSS gf180mcu_fd_sc_mcu7t5v0__mux2_2
XFILLER_68_734 VDD VDD VSS VSS gf180mcu_fd_sc_mcu7t5v0__fill_1
XFILLER_95_564 VDD VDD VSS VSS gf180mcu_fd_sc_mcu7t5v0__fill_1
XFILLER_83_715 VDD VDD VSS VSS gf180mcu_fd_sc_mcu7t5v0__fill_1
XFILLER_67_266 VDD VDD VSS VSS gf180mcu_fd_sc_mcu7t5v0__fill_1
XFILLER_67_277 VDD VDD VSS VSS gf180mcu_fd_sc_mcu7t5v0__fill_2
X_6813_ _6813_/D _7823_/CLK _6813_/Q VDD VDD VSS VSS gf180mcu_fd_sc_mcu7t5v0__dffq_1
X_7793_ _7793_/D _7791_/RN _7793_/CLK _7793_/Q VDD VDD VSS VSS gf180mcu_fd_sc_mcu7t5v0__dffsnq_1
X_3956_ _6741_/Q _4294_/A2 _3957_/B VDD VDD VSS VSS gf180mcu_fd_sc_mcu7t5v0__nand2_1
X_6744_ _6744_/D _6915_/CLK _6744_/Q VDD VDD VSS VSS gf180mcu_fd_sc_mcu7t5v0__dffq_1
XFILLER_23_358 VDD VDD VSS VSS gf180mcu_fd_sc_mcu7t5v0__fill_1
XTAP_TAPCELL_ROW_102_1687 VDD VSS gf180mcu_fd_sc_mcu7t5v0__filltie
X_6675_ _7743_/Q _7745_/Q _6676_/A4 VDD VDD VSS VSS gf180mcu_fd_sc_mcu7t5v0__nand2_1
XFILLER_109_419 VDD VDD VSS VSS gf180mcu_fd_sc_mcu7t5v0__fill_1
XTAP_TAPCELL_ROW_21_548 VDD VSS gf180mcu_fd_sc_mcu7t5v0__filltie
XTAP_TAPCELL_ROW_21_559 VDD VSS gf180mcu_fd_sc_mcu7t5v0__filltie
X_5626_ _7538_/Q _5366_/Z _6724_/B VDD VDD VSS VSS gf180mcu_fd_sc_mcu7t5v0__nand2_1
X_3887_ _3873_/Z _3889_/A2 _3888_/B VDD VDD VSS VSS gf180mcu_fd_sc_mcu7t5v0__nor2_1
XFILLER_118_920 VDD VDD VSS VSS gf180mcu_fd_sc_mcu7t5v0__fillcap_32
X_5557_ _5557_/A1 _5557_/A2 _7512_/D VDD VDD VSS VSS gf180mcu_fd_sc_mcu7t5v0__nand2_1
X_4508_ _5124_/A1 _4518_/A2 _4508_/B _6968_/D VDD VDD VSS VSS gf180mcu_fd_sc_mcu7t5v0__oai21_1
X_5488_ _5488_/A1 _5488_/A2 _5492_/B1 VDD VDD VSS VSS gf180mcu_fd_sc_mcu7t5v0__nor2_1
X_4439_ _6934_/Q _4448_/A2 _4440_/B VDD VDD VSS VSS gf180mcu_fd_sc_mcu7t5v0__nand2_1
Xuart_606 racl_error_o[10] VDD VDD VSS VSS gf180mcu_fd_sc_mcu7t5v0__tiel
X_7227_ _7227_/D _7251_/CLK _7227_/Q VDD VDD VSS VSS gf180mcu_fd_sc_mcu7t5v0__dffq_1
Xuart_639 tl_o[15] VDD VDD VSS VSS gf180mcu_fd_sc_mcu7t5v0__tiel
Xuart_617 racl_error_o[21] VDD VDD VSS VSS gf180mcu_fd_sc_mcu7t5v0__tiel
Xfanout522 _6356_/I0 _5243_/I0 VDD VDD VSS VSS gf180mcu_fd_sc_mcu7t5v0__dlyd_1
Xuart_628 racl_error_o[32] VDD VDD VSS VSS gf180mcu_fd_sc_mcu7t5v0__tiel
Xfanout533 _7640_/Q _5339_/I0 VDD VDD VSS VSS gf180mcu_fd_sc_mcu7t5v0__dlyd_1
Xfanout511 _7645_/Q wire513/I VDD VDD VSS VSS gf180mcu_fd_sc_mcu7t5v0__dlyd_1
Xfanout566 _7703_/RN _7706_/RN VDD VDD VSS VSS gf180mcu_fd_sc_mcu7t5v0__dlyd_1
X_7158_ _7158_/D _7189_/CLK _7158_/Q VDD VDD VSS VSS gf180mcu_fd_sc_mcu7t5v0__dffq_1
Xfanout577 _7711_/RN _7710_/RN VDD VDD VSS VSS gf180mcu_fd_sc_mcu7t5v0__dlyd_1
X_7089_ _7089_/D _7118_/CLK _7089_/Q VDD VDD VSS VSS gf180mcu_fd_sc_mcu7t5v0__dffq_1
XFILLER_47_907 VDD VDD VSS VSS gf180mcu_fd_sc_mcu7t5v0__fill_2
X_6109_ _6109_/A1 _6109_/A2 _6109_/B1 _6109_/B2 _6123_/A2 VDD VDD VSS VSS gf180mcu_fd_sc_mcu7t5v0__oai22_1
XFILLER_100_396 VDD VDD VSS VSS gf180mcu_fd_sc_mcu7t5v0__fill_1
XTAP_TAPCELL_ROW_29_659 VDD VSS gf180mcu_fd_sc_mcu7t5v0__filltie
XTAP_TAPCELL_ROW_1_273 VDD VSS gf180mcu_fd_sc_mcu7t5v0__filltie
XFILLER_70_910 VDD VDD VSS VSS gf180mcu_fd_sc_mcu7t5v0__fillcap_32
XFILLER_26_174 VDD VDD VSS VSS gf180mcu_fd_sc_mcu7t5v0__fill_1
XTAP_TAPCELL_ROW_64_1148 VDD VSS gf180mcu_fd_sc_mcu7t5v0__filltie
XFILLER_30_807 VDD VDD VSS VSS gf180mcu_fd_sc_mcu7t5v0__fillcap_64
XFILLER_42_667 VDD VDD VSS VSS gf180mcu_fd_sc_mcu7t5v0__fillcap_64
XTAP_TAPCELL_ROW_64_1159 VDD VSS gf180mcu_fd_sc_mcu7t5v0__filltie
XTAP_TAPCELL_ROW_40_813 VDD VSS gf180mcu_fd_sc_mcu7t5v0__filltie
XTAP_TAPCELL_ROW_40_824 VDD VSS gf180mcu_fd_sc_mcu7t5v0__filltie
XFILLER_10_542 VDD VDD VSS VSS gf180mcu_fd_sc_mcu7t5v0__fillcap_32
XFILLER_6_524 VDD VDD VSS VSS gf180mcu_fd_sc_mcu7t5v0__fill_1
XFILLER_10_597 VDD VDD VSS VSS gf180mcu_fd_sc_mcu7t5v0__fillcap_64
XTAP_TAPCELL_ROW_9_384 VDD VSS gf180mcu_fd_sc_mcu7t5v0__filltie
XFILLER_77_564 VDD VDD VSS VSS gf180mcu_fd_sc_mcu7t5v0__fill_1
XTAP_TAPCELL_ROW_48_924 VDD VSS gf180mcu_fd_sc_mcu7t5v0__filltie
XTAP_TAPCELL_ROW_48_935 VDD VSS gf180mcu_fd_sc_mcu7t5v0__filltie
XFILLER_64_269 VDD VDD VSS VSS gf180mcu_fd_sc_mcu7t5v0__fill_1
X_3810_ _7776_/Q _3518_/B _3811_/B VDD VDD VSS VSS gf180mcu_fd_sc_mcu7t5v0__nand2_1
XFILLER_61_976 VDD VDD VSS VSS gf180mcu_fd_sc_mcu7t5v0__fillcap_4
X_4790_ _5070_/A1 _4798_/A2 _4790_/B _7109_/D VDD VDD VSS VSS gf180mcu_fd_sc_mcu7t5v0__oai21_1
XANTENNA_18 _6954_/D VDD VDD VSS VSS gf180mcu_fd_sc_mcu7t5v0__antenna
XFILLER_20_317 VDD VDD VSS VSS gf180mcu_fd_sc_mcu7t5v0__fill_2
XFILLER_32_177 VDD VDD VSS VSS gf180mcu_fd_sc_mcu7t5v0__fill_1
X_3741_ _3747_/C _7545_/Q _3747_/B _3755_/A2 VDD VDD VSS VSS gf180mcu_fd_sc_mcu7t5v0__aoi21_1
X_6460_ _7668_/Q _7534_/Q _6469_/C VDD VDD VSS VSS gf180mcu_fd_sc_mcu7t5v0__nand2_1
X_3672_ _3696_/A1 _7882_/I _5813_/A2 VDD VDD VSS VSS gf180mcu_fd_sc_mcu7t5v0__nand2_1
X_6391_ _6451_/A2 _6391_/A2 _6391_/B _7657_/D VDD VDD VSS VSS gf180mcu_fd_sc_mcu7t5v0__oai21_1
X_5411_ _7465_/Q _5507_/B1 _5606_/B1 _7472_/Q _5413_/A1 VDD VDD VSS VSS gf180mcu_fd_sc_mcu7t5v0__oai22_1
XFILLER_115_912 VDD VDD VSS VSS gf180mcu_fd_sc_mcu7t5v0__fillcap_64
XFILLER_114_400 VDD VDD VSS VSS gf180mcu_fd_sc_mcu7t5v0__fill_1
Xoutput125 _5744_/A1 tl_o[0] VDD VDD VSS VSS gf180mcu_fd_sc_mcu7t5v0__dlyd_1
Xoutput114 _7811_/Q intr_rx_parity_err_o VDD VDD VSS VSS gf180mcu_fd_sc_mcu7t5v0__dlyd_1
X_5342_ _5342_/I0 _7489_/Q _5344_/S _7489_/D VDD VDD VSS VSS gf180mcu_fd_sc_mcu7t5v0__mux2_2
Xoutput147 _7586_/Q tl_o[30] VDD VDD VSS VSS gf180mcu_fd_sc_mcu7t5v0__dlyd_1
Xoutput158 _7596_/Q tl_o[40] VDD VDD VSS VSS gf180mcu_fd_sc_mcu7t5v0__dlyd_1
Xoutput136 _7576_/Q tl_o[20] VDD VDD VSS VSS gf180mcu_fd_sc_mcu7t5v0__dlyd_1
XFILLER_114_488 VDD VDD VSS VSS gf180mcu_fd_sc_mcu7t5v0__fill_1
XFILLER_114_477 VDD VDD VSS VSS gf180mcu_fd_sc_mcu7t5v0__fill_1
Xoutput169 _7606_/Q tl_o[51] VDD VDD VSS VSS gf180mcu_fd_sc_mcu7t5v0__dlyd_1
X_7012_ _7012_/D _7070_/CLK _7012_/Q VDD VDD VSS VSS gf180mcu_fd_sc_mcu7t5v0__dffq_1
X_5273_ wire517/Z _7420_/Q _5274_/S _7420_/D VDD VDD VSS VSS gf180mcu_fd_sc_mcu7t5v0__mux2_2
X_4224_ _4224_/A1 _6653_/A2 _5316_/S VDD VDD VSS VSS gf180mcu_fd_sc_mcu7t5v0__nand2_1
X_4155_ _7782_/Q _5819_/B2 _4155_/Z VDD VDD VSS VSS gf180mcu_fd_sc_mcu7t5v0__and2_1
XFILLER_68_597 VDD VDD VSS VSS gf180mcu_fd_sc_mcu7t5v0__fill_2
X_4086_ _4147_/A1 _4110_/A2 _4840_/A2 VDD VDD VSS VSS gf180mcu_fd_sc_mcu7t5v0__nand2_1
XTAP_TAPCELL_ROW_104_1716 VDD VSS gf180mcu_fd_sc_mcu7t5v0__filltie
XFILLER_83_578 VDD VDD VSS VSS gf180mcu_fd_sc_mcu7t5v0__fill_2
XTAP_TAPCELL_ROW_26_618 VDD VSS gf180mcu_fd_sc_mcu7t5v0__filltie
XTAP_TAPCELL_ROW_26_629 VDD VSS gf180mcu_fd_sc_mcu7t5v0__filltie
XFILLER_12_807 VDD VDD VSS VSS gf180mcu_fd_sc_mcu7t5v0__fillcap_64
XFILLER_24_667 VDD VDD VSS VSS gf180mcu_fd_sc_mcu7t5v0__fillcap_64
X_7776_ _7776_/D _7811_/RN clkload7/I _7776_/Q VDD VDD VSS VSS gf180mcu_fd_sc_mcu7t5v0__dffrnq_1
X_4988_ _4988_/A1 _4994_/A2 _4988_/B _7208_/D VDD VDD VSS VSS gf180mcu_fd_sc_mcu7t5v0__oai21_1
X_3939_ _7723_/Q _7724_/Q _4085_/A1 _4126_/A1 VDD VDD VSS VSS gf180mcu_fd_sc_mcu7t5v0__nor3_2
X_6727_ _7761_/Q _7762_/Q _6727_/Z VDD VDD VSS VSS gf180mcu_fd_sc_mcu7t5v0__and2_1
X_6658_ _5309_/S _6658_/A2 _6659_/A2 VDD VDD VSS VSS gf180mcu_fd_sc_mcu7t5v0__nand2_1
X_5609_ _6805_/Q _5613_/B1 _5609_/B _5611_/A1 VDD VDD VSS VSS gf180mcu_fd_sc_mcu7t5v0__oai21_1
X_6589_ _7713_/Q _6603_/A2 _6591_/B VDD VDD VSS VSS gf180mcu_fd_sc_mcu7t5v0__nand2_1
XFILLER_117_282 VDD VDD VSS VSS gf180mcu_fd_sc_mcu7t5v0__fill_1
XTAP_TAPCELL_ROW_115_1867 VDD VSS gf180mcu_fd_sc_mcu7t5v0__filltie
XFILLER_78_317 VDD VDD VSS VSS gf180mcu_fd_sc_mcu7t5v0__fill_2
XTAP_TAPCELL_ROW_6_343 VDD VSS gf180mcu_fd_sc_mcu7t5v0__filltie
XFILLER_87_862 VDD VDD VSS VSS gf180mcu_fd_sc_mcu7t5v0__fill_1
Xfanout363 _5635_/ZN _6283_/C1 VDD VDD VSS VSS gf180mcu_fd_sc_mcu7t5v0__dlyd_1
XFILLER_59_564 VDD VDD VSS VSS gf180mcu_fd_sc_mcu7t5v0__fill_1
Xfanout352 fanout358/Z wire353/I VDD VDD VSS VSS gf180mcu_fd_sc_mcu7t5v0__dlyd_1
XFILLER_74_545 VDD VDD VSS VSS gf180mcu_fd_sc_mcu7t5v0__fill_1
XFILLER_43_976 VDD VDD VSS VSS gf180mcu_fd_sc_mcu7t5v0__fillcap_4
Xinput16 tl_i[110] input16/Z VDD VDD VSS VSS gf180mcu_fd_sc_mcu7t5v0__dlyd_1
Xinput27 tl_i[18] _3383_/I VDD VDD VSS VSS gf180mcu_fd_sc_mcu7t5v0__dlyd_1
Xinput49 tl_i[47] input49/Z VDD VDD VSS VSS gf180mcu_fd_sc_mcu7t5v0__dlyd_1
Xinput38 tl_i[37] input38/Z VDD VDD VSS VSS gf180mcu_fd_sc_mcu7t5v0__dlyd_1
XFILLER_109_772 VDD VDD VSS VSS gf180mcu_fd_sc_mcu7t5v0__fillcap_4
XTAP_TAPCELL_ROW_77_1339 VDD VSS gf180mcu_fd_sc_mcu7t5v0__filltie
XFILLER_6_387 VDD VDD VSS VSS gf180mcu_fd_sc_mcu7t5v0__fill_2
XFILLER_6_354 VDD VDD VSS VSS gf180mcu_fd_sc_mcu7t5v0__fill_1
XTAP_TAPCELL_ROW_90_1517 VDD VSS gf180mcu_fd_sc_mcu7t5v0__filltie
XFILLER_38_737 VDD VDD VSS VSS gf180mcu_fd_sc_mcu7t5v0__fillcap_64
X_5960_ _7271_/Q _6092_/A2 _6092_/B1 _7278_/Q _6851_/Q _6092_/C2 _5961_/A2 VDD VDD
+ VSS VSS gf180mcu_fd_sc_mcu7t5v0__oai222_1
XFILLER_80_515 VDD VDD VSS VSS gf180mcu_fd_sc_mcu7t5v0__fill_2
XFILLER_46_770 VDD VDD VSS VSS gf180mcu_fd_sc_mcu7t5v0__fill_2
X_5891_ _7039_/Q _6153_/B1 wire313/Z _7046_/Q _7053_/Q _6154_/A2 _5892_/I VDD VDD
+ VSS VSS gf180mcu_fd_sc_mcu7t5v0__oai222_1
X_4911_ _7170_/Q _4924_/A2 _4912_/B VDD VDD VSS VSS gf180mcu_fd_sc_mcu7t5v0__nand2_1
XFILLER_46_781 VDD VDD VSS VSS gf180mcu_fd_sc_mcu7t5v0__fillcap_16
X_7630_ _7630_/D _7711_/RN _7711_/CLK _7630_/Q VDD VDD VSS VSS gf180mcu_fd_sc_mcu7t5v0__dffrnq_1
XFILLER_20_103 VDD VDD VSS VSS gf180mcu_fd_sc_mcu7t5v0__fill_2
XFILLER_21_626 VDD VDD VSS VSS gf180mcu_fd_sc_mcu7t5v0__fillcap_4
X_4842_ _5066_/A1 _4854_/A2 _4842_/B _7135_/D VDD VDD VSS VSS gf180mcu_fd_sc_mcu7t5v0__oai21_1
X_7561_ _7561_/D _7780_/RN _7782_/CLK _7561_/Q VDD VDD VSS VSS gf180mcu_fd_sc_mcu7t5v0__dffrnq_1
X_4773_ _7101_/Q _4784_/A2 _4774_/B VDD VDD VSS VSS gf180mcu_fd_sc_mcu7t5v0__nand2_1
X_6512_ _6538_/A1 _6512_/A2 _7679_/D VDD VDD VSS VSS gf180mcu_fd_sc_mcu7t5v0__nor2_1
X_7492_ _7492_/D _7492_/CLK _7492_/Q VDD VDD VSS VSS gf180mcu_fd_sc_mcu7t5v0__dffq_1
X_3724_ _3712_/Z _3729_/A2 _3725_/B VDD VDD VSS VSS gf180mcu_fd_sc_mcu7t5v0__nand2_1
XTAP_TAPCELL_ROW_31_687 VDD VSS gf180mcu_fd_sc_mcu7t5v0__filltie
X_6443_ _7666_/Q _6479_/S _6450_/B VDD VDD VSS VSS gf180mcu_fd_sc_mcu7t5v0__nor2_1
XTAP_TAPCELL_ROW_31_698 VDD VSS gf180mcu_fd_sc_mcu7t5v0__filltie
X_3655_ input46/Z input30/Z _3554_/Z _3655_/Z VDD VDD VSS VSS gf180mcu_fd_sc_mcu7t5v0__xor3_1
X_6374_ input29/Z _6373_/S _6375_/B VDD VDD VSS VSS gf180mcu_fd_sc_mcu7t5v0__nand2_1
X_3586_ input59/Z _3584_/Z _3646_/A2 _3591_/A1 VDD VDD VSS VSS gf180mcu_fd_sc_mcu7t5v0__xnor3_1
X_5325_ _5332_/I0 _7472_/Q _5330_/S _7472_/D VDD VDD VSS VSS gf180mcu_fd_sc_mcu7t5v0__mux2_2
X_5256_ _5354_/I0 _7403_/Q _5260_/S _7403_/D VDD VDD VSS VSS gf180mcu_fd_sc_mcu7t5v0__mux2_2
XTAP_TAPCELL_ROW_3_302 VDD VSS gf180mcu_fd_sc_mcu7t5v0__filltie
X_4207_ _7646_/Q _6819_/Q _5260_/S _6819_/D VDD VDD VSS VSS gf180mcu_fd_sc_mcu7t5v0__mux2_2
XTAP_TAPCELL_ROW_110_1797 VDD VSS gf180mcu_fd_sc_mcu7t5v0__filltie
X_5187_ _5243_/I0 _7334_/Q _5190_/S _7334_/D VDD VDD VSS VSS gf180mcu_fd_sc_mcu7t5v0__mux2_2
X_4138_ _4138_/A1 _4138_/A2 _4138_/A3 _4138_/ZN VDD VDD VSS VSS gf180mcu_fd_sc_mcu7t5v0__nor3_2
X_4069_ _4123_/A1 _4081_/A2 _4770_/A2 VDD VDD VSS VSS gf180mcu_fd_sc_mcu7t5v0__nand2_1
XTAP_TAPCELL_ROW_39_798 VDD VSS gf180mcu_fd_sc_mcu7t5v0__filltie
XFILLER_25_976 VDD VDD VSS VSS gf180mcu_fd_sc_mcu7t5v0__fillcap_4
XTAP_TAPCELL_ROW_61_1107 VDD VSS gf180mcu_fd_sc_mcu7t5v0__filltie
XTAP_TAPCELL_ROW_61_1118 VDD VSS gf180mcu_fd_sc_mcu7t5v0__filltie
X_7759_ _7759_/D _7764_/RN _7765_/CLK _7759_/Q VDD VDD VSS VSS gf180mcu_fd_sc_mcu7t5v0__dffrnq_1
XFILLER_40_979 VDD VDD VSS VSS gf180mcu_fd_sc_mcu7t5v0__fill_2
XTAP_TAPCELL_ROW_50_952 VDD VSS gf180mcu_fd_sc_mcu7t5v0__filltie
XTAP_TAPCELL_ROW_50_963 VDD VSS gf180mcu_fd_sc_mcu7t5v0__filltie
XTAP_TAPCELL_ROW_72_1269 VDD VSS gf180mcu_fd_sc_mcu7t5v0__filltie
XFILLER_102_981 VDD VDD VSS VSS gf180mcu_fd_sc_mcu7t5v0__fill_1
XFILLER_74_397 VDD VDD VSS VSS gf180mcu_fd_sc_mcu7t5v0__fill_2
XFILLER_62_537 VDD VDD VSS VSS gf180mcu_fd_sc_mcu7t5v0__fill_1
X_3440_ _7585_/Q _6265_/A1 VDD VDD VSS VSS gf180mcu_fd_sc_mcu7t5v0__clkinv_1
XFILLER_7_696 VDD VDD VSS VSS gf180mcu_fd_sc_mcu7t5v0__fillcap_4
X_3371_ _6184_/C _6122_/C VDD VDD VSS VSS gf180mcu_fd_sc_mcu7t5v0__inv_2
X_5110_ _5110_/A1 _5120_/A2 _5110_/B _7269_/D VDD VDD VSS VSS gf180mcu_fd_sc_mcu7t5v0__oai21_1
X_6090_ _6881_/Q _6092_/C2 _6091_/A2 _6874_/Q _6090_/C _6094_/A2 VDD VDD VSS VSS gf180mcu_fd_sc_mcu7t5v0__oai221_1
XFILLER_98_979 VDD VDD VSS VSS gf180mcu_fd_sc_mcu7t5v0__fill_2
Xload_slew544 _7811_/RN _7825_/RN VDD VDD VSS VSS gf180mcu_fd_sc_mcu7t5v0__buf_4
Xload_slew555 _7558_/RN _7782_/RN VDD VDD VSS VSS gf180mcu_fd_sc_mcu7t5v0__buf_4
X_5041_ _7235_/Q _5050_/A2 _5042_/B VDD VDD VSS VSS gf180mcu_fd_sc_mcu7t5v0__nand2_1
XFILLER_26_2 VDD VDD VSS VSS gf180mcu_fd_sc_mcu7t5v0__fill_2
Xload_slew588 _7701_/RN _7800_/RN VDD VDD VSS VSS gf180mcu_fd_sc_mcu7t5v0__buf_4
Xload_slew599 _7798_/RN _7661_/RN VDD VDD VSS VSS gf180mcu_fd_sc_mcu7t5v0__buf_4
XFILLER_80_301 VDD VDD VSS VSS gf180mcu_fd_sc_mcu7t5v0__fill_2
XFILLER_53_515 VDD VDD VSS VSS gf180mcu_fd_sc_mcu7t5v0__fill_1
XFILLER_65_364 VDD VDD VSS VSS gf180mcu_fd_sc_mcu7t5v0__fill_2
X_6992_ _6992_/D _7254_/CLK _6992_/Q VDD VDD VSS VSS gf180mcu_fd_sc_mcu7t5v0__dffq_1
XTAP_TAPCELL_ROW_36_757 VDD VSS gf180mcu_fd_sc_mcu7t5v0__filltie
XTAP_TAPCELL_ROW_36_768 VDD VSS gf180mcu_fd_sc_mcu7t5v0__filltie
X_5943_ _5943_/A1 _5943_/A2 _5943_/A3 _5943_/A4 _5944_/B VDD VDD VSS VSS gf180mcu_fd_sc_mcu7t5v0__nand4_1
X_5874_ _6136_/B _5874_/A2 _5874_/B _6184_/C _5875_/A3 VDD VDD VSS VSS gf180mcu_fd_sc_mcu7t5v0__oai211_1
X_7613_ _7613_/D _7613_/RN _7613_/CLK _7885_/I VDD VDD VSS VSS gf180mcu_fd_sc_mcu7t5v0__dffrnq_1
XTAP_TAPCELL_ROW_16_481 VDD VSS gf180mcu_fd_sc_mcu7t5v0__filltie
XFILLER_22_979 VDD VDD VSS VSS gf180mcu_fd_sc_mcu7t5v0__fill_2
X_4825_ _7127_/Q _4826_/A2 _4826_/B VDD VDD VSS VSS gf180mcu_fd_sc_mcu7t5v0__nand2_1
X_7544_ _7544_/D _7785_/RN _7790_/CLK _7544_/Q VDD VDD VSS VSS gf180mcu_fd_sc_mcu7t5v0__dffrnq_1
X_4756_ wire291/Z _4756_/A2 _4756_/B _7092_/D VDD VDD VSS VSS gf180mcu_fd_sc_mcu7t5v0__oai21_1
X_4687_ _7058_/Q _4700_/A2 _4688_/B VDD VDD VSS VSS gf180mcu_fd_sc_mcu7t5v0__nand2_1
X_7475_ _7475_/D _7482_/CLK _7475_/Q VDD VDD VSS VSS gf180mcu_fd_sc_mcu7t5v0__dffq_1
X_3707_ _7761_/Q _7762_/Q _6730_/A1 VDD VDD VSS VSS gf180mcu_fd_sc_mcu7t5v0__nor2_1
X_6426_ _6419_/Z _6426_/A2 _6426_/B _6438_/A2 VDD VDD VSS VSS gf180mcu_fd_sc_mcu7t5v0__aoi21_1
X_3638_ input82/Z input95/Z _3638_/Z VDD VDD VSS VSS gf180mcu_fd_sc_mcu7t5v0__xor2_1
XTAP_TAPCELL_ROW_112_1826 VDD VSS gf180mcu_fd_sc_mcu7t5v0__filltie
X_3569_ input97/Z input99/Z _3640_/A1 _3574_/A1 VDD VDD VSS VSS gf180mcu_fd_sc_mcu7t5v0__xnor3_1
X_6357_ wire521/I input34/Z _7782_/D _7643_/D VDD VDD VSS VSS gf180mcu_fd_sc_mcu7t5v0__mux2_2
X_5308_ wire517/I _7455_/Q _5309_/S _7455_/D VDD VDD VSS VSS gf180mcu_fd_sc_mcu7t5v0__mux2_2
X_6288_ _6288_/A1 _6298_/A2 _6300_/B1 _6288_/B2 _7596_/D VDD VDD VSS VSS gf180mcu_fd_sc_mcu7t5v0__aoi22_1
XFILLER_89_968 VDD VDD VSS VSS gf180mcu_fd_sc_mcu7t5v0__fillcap_8
XFILLER_75_106 VDD VDD VSS VSS gf180mcu_fd_sc_mcu7t5v0__fill_1
X_5239_ _5239_/I0 _7386_/Q _5239_/S _7386_/D VDD VDD VSS VSS gf180mcu_fd_sc_mcu7t5v0__mux2_2
XFILLER_57_832 VDD VDD VSS VSS gf180mcu_fd_sc_mcu7t5v0__fill_1
Xclkbuf_leaf_3_clk_i clkload0/I _7378_/CLK VDD VDD VSS VSS gf180mcu_fd_sc_mcu7t5v0__clkbuf_8
XFILLER_44_548 VDD VDD VSS VSS gf180mcu_fd_sc_mcu7t5v0__fill_1
XFILLER_31_209 VDD VDD VSS VSS gf180mcu_fd_sc_mcu7t5v0__fill_1
XFILLER_9_906 VDD VDD VSS VSS gf180mcu_fd_sc_mcu7t5v0__fillcap_4
XFILLER_24_283 VDD VDD VSS VSS gf180mcu_fd_sc_mcu7t5v0__fill_2
XTAP_TAPCELL_ROW_85_1449 VDD VSS gf180mcu_fd_sc_mcu7t5v0__filltie
XFILLER_63_846 VDD VDD VSS VSS gf180mcu_fd_sc_mcu7t5v0__fill_2
XTAP_TAPCELL_ROW_33_716 VDD VSS gf180mcu_fd_sc_mcu7t5v0__filltie
XTAP_TAPCELL_ROW_33_727 VDD VSS gf180mcu_fd_sc_mcu7t5v0__filltie
X_4610_ _4708_/A1 _4616_/A2 _4610_/B _7019_/D VDD VDD VSS VSS gf180mcu_fd_sc_mcu7t5v0__oai21_1
XTAP_TAPCELL_ROW_13_440 VDD VSS gf180mcu_fd_sc_mcu7t5v0__filltie
X_5590_ _6817_/Q _5599_/A2 _5590_/B _5592_/A1 VDD VDD VSS VSS gf180mcu_fd_sc_mcu7t5v0__oai21_1
X_4541_ _6985_/Q _4546_/A2 _4542_/B VDD VDD VSS VSS gf180mcu_fd_sc_mcu7t5v0__nand2_1
X_4472_ _4584_/A1 _4476_/A2 _4472_/B _6950_/D VDD VDD VSS VSS gf180mcu_fd_sc_mcu7t5v0__oai21_1
X_7260_ _7260_/D _7266_/CLK _7260_/Q VDD VDD VSS VSS gf180mcu_fd_sc_mcu7t5v0__dffq_1
X_6211_ _6775_/Q _6214_/A2 _6211_/B1 _6773_/Q _6213_/A1 VDD VDD VSS VSS gf180mcu_fd_sc_mcu7t5v0__oai22_1
X_7191_ _7191_/D _7251_/CLK _7191_/Q VDD VDD VSS VSS gf180mcu_fd_sc_mcu7t5v0__dffq_1
X_3423_ _7545_/Q _5665_/A1 VDD VDD VSS VSS gf180mcu_fd_sc_mcu7t5v0__clkinv_1
X_6142_ _6142_/A1 _6142_/A2 _6196_/B _6143_/B2 VDD VDD VSS VSS gf180mcu_fd_sc_mcu7t5v0__oai21_1
Xload_slew330 fanout328/Z _6215_/A2 VDD VDD VSS VSS gf180mcu_fd_sc_mcu7t5v0__clkbuf_4
X_3354_ _7747_/Q _3930_/A2 VDD VDD VSS VSS gf180mcu_fd_sc_mcu7t5v0__clkinv_1
XFILLER_112_564 VDD VDD VSS VSS gf180mcu_fd_sc_mcu7t5v0__fill_1
X_6073_ _7007_/Q _6073_/A2 _6222_/B1 _7000_/Q _6075_/A1 VDD VDD VSS VSS gf180mcu_fd_sc_mcu7t5v0__oai22_1
Xload_slew374 _5597_/B1 _5501_/B1 VDD VDD VSS VSS gf180mcu_fd_sc_mcu7t5v0__buf_4
XFILLER_100_737 VDD VDD VSS VSS gf180mcu_fd_sc_mcu7t5v0__fillcap_4
XFILLER_97_297 VDD VDD VSS VSS gf180mcu_fd_sc_mcu7t5v0__fill_2
Xload_slew385 _5544_/A2 _5542_/A2 VDD VDD VSS VSS gf180mcu_fd_sc_mcu7t5v0__buf_4
X_5024_ _5066_/A1 _5036_/A2 _5024_/B _7226_/D VDD VDD VSS VSS gf180mcu_fd_sc_mcu7t5v0__oai21_1
XFILLER_57_139 VDD VDD VSS VSS gf180mcu_fd_sc_mcu7t5v0__fill_1
Xload_slew396 _6055_/A2 _6132_/A2 VDD VDD VSS VSS gf180mcu_fd_sc_mcu7t5v0__buf_2
XFILLER_93_492 VDD VDD VSS VSS gf180mcu_fd_sc_mcu7t5v0__fill_2
X_6975_ _6975_/D _7003_/CLK _6975_/Q VDD VDD VSS VSS gf180mcu_fd_sc_mcu7t5v0__dffq_1
XFILLER_41_507 VDD VDD VSS VSS gf180mcu_fd_sc_mcu7t5v0__fillcap_4
X_5926_ _5926_/A1 _5926_/A2 _5926_/B _5933_/A2 VDD VDD VSS VSS gf180mcu_fd_sc_mcu7t5v0__oai21_1
XFILLER_34_592 VDD VDD VSS VSS gf180mcu_fd_sc_mcu7t5v0__fill_2
X_5857_ _5857_/A1 _5857_/A2 _5861_/A1 VDD VDD VSS VSS gf180mcu_fd_sc_mcu7t5v0__nor2_1
X_5788_ _7163_/Q _6241_/A2 _5788_/B _6242_/C _5791_/B VDD VDD VSS VSS gf180mcu_fd_sc_mcu7t5v0__oai211_1
X_4808_ _4822_/A1 _4812_/A2 _4808_/B _7118_/D VDD VDD VSS VSS gf180mcu_fd_sc_mcu7t5v0__oai21_1
XFILLER_108_815 VDD VDD VSS VSS gf180mcu_fd_sc_mcu7t5v0__fillcap_4
X_7527_ _7527_/D _7709_/RN _7711_/CLK _7527_/Q VDD VDD VSS VSS gf180mcu_fd_sc_mcu7t5v0__dffrnq_1
X_4739_ _7084_/Q _4742_/A2 _4740_/B VDD VDD VSS VSS gf180mcu_fd_sc_mcu7t5v0__nand2_1
X_7458_ _7458_/D clkload9/I _7458_/Q VDD VDD VSS VSS gf180mcu_fd_sc_mcu7t5v0__dffq_1
X_6409_ _7661_/Q _7527_/Q _6421_/B VDD VDD VSS VSS gf180mcu_fd_sc_mcu7t5v0__nand2_1
X_7389_ _7389_/D _7499_/CLK _7389_/Q VDD VDD VSS VSS gf180mcu_fd_sc_mcu7t5v0__dffq_1
XTAP_TAPCELL_ROW_56_1039 VDD VSS gf180mcu_fd_sc_mcu7t5v0__filltie
XFILLER_88_275 VDD VDD VSS VSS gf180mcu_fd_sc_mcu7t5v0__fill_2
XFILLER_49_629 VDD VDD VSS VSS gf180mcu_fd_sc_mcu7t5v0__fill_1
XFILLER_76_448 VDD VDD VSS VSS gf180mcu_fd_sc_mcu7t5v0__fill_2
XFILLER_57_640 VDD VDD VSS VSS gf180mcu_fd_sc_mcu7t5v0__fillcap_4
XFILLER_44_323 VDD VDD VSS VSS gf180mcu_fd_sc_mcu7t5v0__fill_2
XFILLER_71_142 VDD VDD VSS VSS gf180mcu_fd_sc_mcu7t5v0__fill_2
XTAP_TAPCELL_ROW_80_1379 VDD VSS gf180mcu_fd_sc_mcu7t5v0__filltie
XFILLER_12_242 VDD VDD VSS VSS gf180mcu_fd_sc_mcu7t5v0__fill_2
XFILLER_114_807 VDD VDD VSS VSS gf180mcu_fd_sc_mcu7t5v0__fillcap_64
XFILLER_95_702 VDD VDD VSS VSS gf180mcu_fd_sc_mcu7t5v0__fill_2
XFILLER_91_941 VDD VDD VSS VSS gf180mcu_fd_sc_mcu7t5v0__fillcap_32
XTAP_TAPCELL_ROW_18_510 VDD VSS gf180mcu_fd_sc_mcu7t5v0__filltie
XFILLER_63_610 VDD VDD VSS VSS gf180mcu_fd_sc_mcu7t5v0__fill_1
XFILLER_90_462 VDD VDD VSS VSS gf180mcu_fd_sc_mcu7t5v0__fill_2
X_6760_ _6760_/D _7252_/CLK _6760_/Q VDD VDD VSS VSS gf180mcu_fd_sc_mcu7t5v0__dffq_1
X_5711_ _7629_/Q _5716_/A2 _7630_/Q _5711_/B2 _7633_/Q _5728_/B2 _5714_/A1 VDD VDD
+ VSS VSS gf180mcu_fd_sc_mcu7t5v0__oai222_1
X_3972_ _7723_/Q _6621_/A1 _4002_/A2 VDD VDD VSS VSS gf180mcu_fd_sc_mcu7t5v0__nand2_1
XTAP_TAPCELL_ROW_46_896 VDD VSS gf180mcu_fd_sc_mcu7t5v0__filltie
XFILLER_31_562 VDD VDD VSS VSS gf180mcu_fd_sc_mcu7t5v0__fillcap_64
X_6691_ _7745_/Q _6694_/A2 _6692_/B VDD VDD VSS VSS gf180mcu_fd_sc_mcu7t5v0__nand2_1
XTAP_TAPCELL_ROW_98_1629 VDD VSS gf180mcu_fd_sc_mcu7t5v0__filltie
X_5642_ _7525_/Q input51/Z _5642_/S _7525_/D VDD VDD VSS VSS gf180mcu_fd_sc_mcu7t5v0__mux2_2
X_5573_ _5573_/A1 _5573_/A2 _5583_/A2 VDD VDD VSS VSS gf180mcu_fd_sc_mcu7t5v0__nor2_1
X_4524_ _5014_/A1 _4532_/A2 _4524_/B _6976_/D VDD VDD VSS VSS gf180mcu_fd_sc_mcu7t5v0__oai21_1
X_7312_ _7312_/D _7491_/CLK _7312_/Q VDD VDD VSS VSS gf180mcu_fd_sc_mcu7t5v0__dffq_1
X_4455_ _6942_/Q _4462_/A2 _4456_/B VDD VDD VSS VSS gf180mcu_fd_sc_mcu7t5v0__nand2_1
X_7243_ _7243_/D _7252_/CLK _7243_/Q VDD VDD VSS VSS gf180mcu_fd_sc_mcu7t5v0__dffq_1
X_3406_ _7628_/Q _6337_/A1 VDD VDD VSS VSS gf180mcu_fd_sc_mcu7t5v0__clkinv_1
X_4386_ _5086_/A1 _4392_/A2 _4386_/B _6907_/D VDD VDD VSS VSS gf180mcu_fd_sc_mcu7t5v0__oai21_1
X_7174_ _7174_/D _7748_/CLK _7174_/Q VDD VDD VSS VSS gf180mcu_fd_sc_mcu7t5v0__dffq_1
X_6125_ _3728_/Z _6283_/B1 _6129_/A1 VDD VDD VSS VSS gf180mcu_fd_sc_mcu7t5v0__nand2_1
Xload_slew193 _6341_/S _6331_/S VDD VDD VSS VSS gf180mcu_fd_sc_mcu7t5v0__buf_4
X_6056_ _6056_/I _6057_/B VDD VDD VSS VSS gf180mcu_fd_sc_mcu7t5v0__clkinv_1
X_5007_ _7218_/Q _5008_/A2 _5008_/B VDD VDD VSS VSS gf180mcu_fd_sc_mcu7t5v0__nand2_1
XTAP_TAPCELL_ROW_107_1758 VDD VSS gf180mcu_fd_sc_mcu7t5v0__filltie
XFILLER_54_632 VDD VDD VSS VSS gf180mcu_fd_sc_mcu7t5v0__fill_2
Xclkbuf_leaf_83_clk_i clkbuf_3_1__f_clk_i/Z _7490_/CLK VDD VDD VSS VSS gf180mcu_fd_sc_mcu7t5v0__clkbuf_8
XFILLER_53_142 VDD VDD VSS VSS gf180mcu_fd_sc_mcu7t5v0__fill_1
X_6958_ _6958_/D _7667_/CLK _6958_/Q VDD VDD VSS VSS gf180mcu_fd_sc_mcu7t5v0__dffq_1
X_6889_ _6889_/D _6939_/CLK _6889_/Q VDD VDD VSS VSS gf180mcu_fd_sc_mcu7t5v0__dffq_1
X_5909_ _6934_/Q wire355/Z _6085_/B1 _6927_/Q _5914_/A1 VDD VDD VSS VSS gf180mcu_fd_sc_mcu7t5v0__oai22_1
Xclkbuf_leaf_21_clk_i clkload1/I _7613_/CLK VDD VDD VSS VSS gf180mcu_fd_sc_mcu7t5v0__clkbuf_8
Xclkbuf_leaf_36_clk_i clkload3/I _7719_/CLK VDD VDD VSS VSS gf180mcu_fd_sc_mcu7t5v0__clkbuf_8
XFILLER_77_768 VDD VDD VSS VSS gf180mcu_fd_sc_mcu7t5v0__fill_2
XTAP_TAPCELL_ROW_69_1219 VDD VSS gf180mcu_fd_sc_mcu7t5v0__filltie
XFILLER_72_440 VDD VDD VSS VSS gf180mcu_fd_sc_mcu7t5v0__fill_2
XTAP_TAPCELL_ROW_82_1408 VDD VSS gf180mcu_fd_sc_mcu7t5v0__filltie
XFILLER_72_495 VDD VDD VSS VSS gf180mcu_fd_sc_mcu7t5v0__fill_1
XFILLER_13_562 VDD VDD VSS VSS gf180mcu_fd_sc_mcu7t5v0__fillcap_64
XTAP_TAPCELL_ROW_43_855 VDD VSS gf180mcu_fd_sc_mcu7t5v0__filltie
XTAP_TAPCELL_ROW_43_866 VDD VSS gf180mcu_fd_sc_mcu7t5v0__filltie
XTAP_TAPCELL_ROW_93_1559 VDD VSS gf180mcu_fd_sc_mcu7t5v0__filltie
XFILLER_5_772 VDD VDD VSS VSS gf180mcu_fd_sc_mcu7t5v0__fillcap_64
X_4240_ _4996_/A1 _4252_/A2 _4240_/B _6834_/D VDD VDD VSS VSS gf180mcu_fd_sc_mcu7t5v0__oai21_1
X_4171_ _4235_/A1 _4179_/A2 _5162_/S VDD VDD VSS VSS gf180mcu_fd_sc_mcu7t5v0__nand2_1
X_6812_ _6812_/D _7378_/CLK _6812_/Q VDD VDD VSS VSS gf180mcu_fd_sc_mcu7t5v0__dffq_1
X_7792_ _7792_/D wire565/Z _7792_/CLK _7792_/Q VDD VDD VSS VSS gf180mcu_fd_sc_mcu7t5v0__dffrnq_1
X_6743_ _6743_/D _6915_/CLK _6743_/Q VDD VDD VSS VSS gf180mcu_fd_sc_mcu7t5v0__dffq_1
X_3955_ _4150_/A1 _4129_/A1 _4294_/A2 VDD VDD VSS VSS gf180mcu_fd_sc_mcu7t5v0__nand2_1
XTAP_TAPCELL_ROW_102_1688 VDD VSS gf180mcu_fd_sc_mcu7t5v0__filltie
XFILLER_32_871 VDD VDD VSS VSS gf180mcu_fd_sc_mcu7t5v0__fillcap_4
X_6674_ _6679_/I0 _7742_/Q _6674_/Z VDD VDD VSS VSS gf180mcu_fd_sc_mcu7t5v0__xor2_1
XTAP_TAPCELL_ROW_21_549 VDD VSS gf180mcu_fd_sc_mcu7t5v0__filltie
X_5625_ _5625_/A1 _5623_/Z _5625_/B _5625_/C _5627_/A2 VDD VDD VSS VSS gf180mcu_fd_sc_mcu7t5v0__aoi211_1
X_3886_ _7542_/Q _7541_/Q _3892_/A2 VDD VDD VSS VSS gf180mcu_fd_sc_mcu7t5v0__nand2_1
XFILLER_118_954 VDD VDD VSS VSS gf180mcu_fd_sc_mcu7t5v0__fillcap_16
XFILLER_117_431 VDD VDD VSS VSS gf180mcu_fd_sc_mcu7t5v0__fill_1
X_5556_ _7513_/Q _6732_/A1 _6728_/B _5556_/C _5557_/A2 VDD VDD VSS VSS gf180mcu_fd_sc_mcu7t5v0__oai211_1
X_4507_ _6968_/Q _4518_/A2 _4508_/B VDD VDD VSS VSS gf180mcu_fd_sc_mcu7t5v0__nand2_1
XFILLER_105_637 VDD VDD VSS VSS gf180mcu_fd_sc_mcu7t5v0__fill_1
X_5487_ _7446_/Q _5544_/A2 _5501_/B1 _7432_/Q _5599_/B _5488_/A2 VDD VDD VSS VSS gf180mcu_fd_sc_mcu7t5v0__oai221_1
X_4438_ _4550_/A1 _4448_/A2 _4438_/B _6933_/D VDD VDD VSS VSS gf180mcu_fd_sc_mcu7t5v0__oai21_1
X_7226_ _7226_/D _7247_/CLK _7226_/Q VDD VDD VSS VSS gf180mcu_fd_sc_mcu7t5v0__dffq_1
XFILLER_99_871 VDD VDD VSS VSS gf180mcu_fd_sc_mcu7t5v0__fillcap_8
Xuart_618 racl_error_o[22] VDD VDD VSS VSS gf180mcu_fd_sc_mcu7t5v0__tiel
Xuart_607 racl_error_o[11] VDD VDD VSS VSS gf180mcu_fd_sc_mcu7t5v0__tiel
Xuart_629 racl_error_o[33] VDD VDD VSS VSS gf180mcu_fd_sc_mcu7t5v0__tiel
X_4369_ _6899_/Q _4378_/A2 _4370_/B VDD VDD VSS VSS gf180mcu_fd_sc_mcu7t5v0__nand2_1
X_7157_ _7157_/D _7189_/CLK _7157_/Q VDD VDD VSS VSS gf180mcu_fd_sc_mcu7t5v0__dffq_1
X_7088_ _7088_/D _7099_/CLK _7088_/Q VDD VDD VSS VSS gf180mcu_fd_sc_mcu7t5v0__dffq_1
Xfanout589 _7798_/RN fanout589/Z VDD VDD VSS VSS gf180mcu_fd_sc_mcu7t5v0__dlyd_1
X_6108_ _6108_/A1 _6108_/A2 _6196_/B _6109_/B2 VDD VDD VSS VSS gf180mcu_fd_sc_mcu7t5v0__oai21_1
X_6039_ _6943_/Q _6225_/A2 wire355/Z _6936_/Q _6227_/C _6040_/A2 VDD VDD VSS VSS gf180mcu_fd_sc_mcu7t5v0__oai221_1
XFILLER_27_632 VDD VDD VSS VSS gf180mcu_fd_sc_mcu7t5v0__fillcap_64
XFILLER_82_771 VDD VDD VSS VSS gf180mcu_fd_sc_mcu7t5v0__fill_2
XTAP_TAPCELL_ROW_1_274 VDD VSS gf180mcu_fd_sc_mcu7t5v0__filltie
XTAP_TAPCELL_ROW_64_1149 VDD VSS gf180mcu_fd_sc_mcu7t5v0__filltie
XFILLER_70_944 VDD VDD VSS VSS gf180mcu_fd_sc_mcu7t5v0__fill_1
XTAP_TAPCELL_ROW_40_814 VDD VSS gf180mcu_fd_sc_mcu7t5v0__filltie
XTAP_TAPCELL_ROW_40_825 VDD VSS gf180mcu_fd_sc_mcu7t5v0__filltie
XFILLER_109_976 VDD VDD VSS VSS gf180mcu_fd_sc_mcu7t5v0__fillcap_4
XTAP_TAPCELL_ROW_79_1370 VDD VSS gf180mcu_fd_sc_mcu7t5v0__filltie
XFILLER_6_569 VDD VDD VSS VSS gf180mcu_fd_sc_mcu7t5v0__fillcap_16
XFILLER_2_731 VDD VDD VSS VSS gf180mcu_fd_sc_mcu7t5v0__fillcap_4
XTAP_TAPCELL_ROW_9_385 VDD VSS gf180mcu_fd_sc_mcu7t5v0__filltie
XFILLER_104_692 VDD VDD VSS VSS gf180mcu_fd_sc_mcu7t5v0__fill_1
XFILLER_49_212 VDD VDD VSS VSS gf180mcu_fd_sc_mcu7t5v0__fill_1
XTAP_TAPCELL_ROW_48_925 VDD VSS gf180mcu_fd_sc_mcu7t5v0__filltie
XTAP_TAPCELL_ROW_48_936 VDD VSS gf180mcu_fd_sc_mcu7t5v0__filltie
XFILLER_46_941 VDD VDD VSS VSS gf180mcu_fd_sc_mcu7t5v0__fillcap_4
XFILLER_73_782 VDD VDD VSS VSS gf180mcu_fd_sc_mcu7t5v0__fillcap_4
XANTENNA_19 _6971_/D VDD VDD VSS VSS gf180mcu_fd_sc_mcu7t5v0__antenna
XFILLER_14_871 VDD VDD VSS VSS gf180mcu_fd_sc_mcu7t5v0__fillcap_4
X_3740_ _7547_/Q _7546_/Q _7545_/Q _3754_/B VDD VDD VSS VSS gf180mcu_fd_sc_mcu7t5v0__nand3_1
XFILLER_9_352 VDD VDD VSS VSS gf180mcu_fd_sc_mcu7t5v0__fill_2
X_3671_ _7879_/I _7880_/I _7881_/I _3673_/A3 VDD VDD VSS VSS gf180mcu_fd_sc_mcu7t5v0__aoi21_1
X_6390_ _7657_/Q _6451_/A2 _6391_/B VDD VDD VSS VSS gf180mcu_fd_sc_mcu7t5v0__nand2_1
X_5410_ _5508_/C _5410_/A2 _5410_/A3 _5584_/S _5417_/B2 VDD VDD VSS VSS gf180mcu_fd_sc_mcu7t5v0__oai31_1
X_5341_ _5341_/I0 _7488_/Q _5344_/S _7488_/D VDD VDD VSS VSS gf180mcu_fd_sc_mcu7t5v0__mux2_2
Xoutput115 _7810_/Q intr_rx_timeout_o VDD VDD VSS VSS gf180mcu_fd_sc_mcu7t5v0__dlyd_1
XFILLER_56_2 VDD VDD VSS VSS gf180mcu_fd_sc_mcu7t5v0__fill_2
Xoutput137 _7577_/Q tl_o[21] VDD VDD VSS VSS gf180mcu_fd_sc_mcu7t5v0__dlyd_1
Xoutput126 _3818_/ZN tl_o[10] VDD VDD VSS VSS gf180mcu_fd_sc_mcu7t5v0__dlyd_1
Xoutput148 _7587_/Q tl_o[31] VDD VDD VSS VSS gf180mcu_fd_sc_mcu7t5v0__dlyd_1
Xoutput159 _7597_/Q tl_o[41] VDD VDD VSS VSS gf180mcu_fd_sc_mcu7t5v0__dlyd_1
X_7011_ _7011_/D _7060_/CLK _7011_/Q VDD VDD VSS VSS gf180mcu_fd_sc_mcu7t5v0__dffq_1
X_5272_ wire521/Z _7419_/Q _5274_/S _7419_/D VDD VDD VSS VSS gf180mcu_fd_sc_mcu7t5v0__mux2_2
X_4223_ _4223_/I0 _6826_/Q _5309_/S _6826_/D VDD VDD VSS VSS gf180mcu_fd_sc_mcu7t5v0__mux2_2
XFILLER_96_874 VDD VDD VSS VSS gf180mcu_fd_sc_mcu7t5v0__fill_1
X_4154_ _4154_/A1 _3763_/Z _7793_/Q _5819_/B2 VDD VDD VSS VSS gf180mcu_fd_sc_mcu7t5v0__aoi21_1
XFILLER_96_885 VDD VDD VSS VSS gf180mcu_fd_sc_mcu7t5v0__fillcap_4
X_4085_ _4085_/A1 _4138_/A3 _4110_/A2 VDD VDD VSS VSS gf180mcu_fd_sc_mcu7t5v0__nor2_1
XTAP_TAPCELL_ROW_26_619 VDD VSS gf180mcu_fd_sc_mcu7t5v0__filltie
XTAP_TAPCELL_ROW_104_1717 VDD VSS gf180mcu_fd_sc_mcu7t5v0__filltie
X_7775_ _7775_/D _7825_/RN clkload9/I _7775_/Q VDD VDD VSS VSS gf180mcu_fd_sc_mcu7t5v0__dffrnq_1
X_6726_ _7762_/Q _6733_/A4 _6729_/A1 VDD VDD VSS VSS gf180mcu_fd_sc_mcu7t5v0__nand2_1
X_4987_ _7208_/Q _4994_/A2 _4988_/B VDD VDD VSS VSS gf180mcu_fd_sc_mcu7t5v0__nand2_1
X_3938_ _6617_/A1 _6608_/A2 _4085_/A1 VDD VDD VSS VSS gf180mcu_fd_sc_mcu7t5v0__nand2_1
X_6657_ _7736_/Q _6657_/A2 _6659_/A1 VDD VDD VSS VSS gf180mcu_fd_sc_mcu7t5v0__nor2_1
X_3869_ _6679_/I0 _7749_/Q _3869_/B wire220/I VDD VDD VSS VSS gf180mcu_fd_sc_mcu7t5v0__aoi21_1
X_5608_ _5508_/C _5608_/A2 _5608_/A3 _5615_/A3 VDD VDD VSS VSS gf180mcu_fd_sc_mcu7t5v0__nor3_1
X_6588_ _7712_/Q _6585_/Z _6588_/B _7712_/D VDD VDD VSS VSS gf180mcu_fd_sc_mcu7t5v0__oai21_1
XFILLER_118_784 VDD VDD VSS VSS gf180mcu_fd_sc_mcu7t5v0__fillcap_32
XFILLER_106_935 VDD VDD VSS VSS gf180mcu_fd_sc_mcu7t5v0__fillcap_8
X_5539_ _5539_/A1 _5539_/A2 _5539_/B _5614_/B _5540_/B VDD VDD VSS VSS gf180mcu_fd_sc_mcu7t5v0__oai211_1
XFILLER_3_506 VDD VDD VSS VSS gf180mcu_fd_sc_mcu7t5v0__fillcap_4
XFILLER_3_528 VDD VDD VSS VSS gf180mcu_fd_sc_mcu7t5v0__fillcap_32
XTAP_TAPCELL_ROW_115_1868 VDD VSS gf180mcu_fd_sc_mcu7t5v0__filltie
XFILLER_106_979 VDD VDD VSS VSS gf180mcu_fd_sc_mcu7t5v0__fill_2
XFILLER_79_819 VDD VDD VSS VSS gf180mcu_fd_sc_mcu7t5v0__fillcap_4
Xfanout331 _6227_/A2 _6212_/B1 VDD VDD VSS VSS gf180mcu_fd_sc_mcu7t5v0__dlyd_1
XTAP_TAPCELL_ROW_6_344 VDD VSS gf180mcu_fd_sc_mcu7t5v0__filltie
X_7209_ _7209_/D _7251_/CLK _7209_/Q VDD VDD VSS VSS gf180mcu_fd_sc_mcu7t5v0__dffq_1
Xfanout342 fanout346/Z _6198_/B1 VDD VDD VSS VSS gf180mcu_fd_sc_mcu7t5v0__dlyd_1
XFILLER_28_941 VDD VDD VSS VSS gf180mcu_fd_sc_mcu7t5v0__fillcap_4
XFILLER_42_454 VDD VDD VSS VSS gf180mcu_fd_sc_mcu7t5v0__fill_1
XTAP_TAPCELL_ROW_53_994 VDD VSS gf180mcu_fd_sc_mcu7t5v0__filltie
Xinput17 tl_i[111] _3695_/C VDD VDD VSS VSS gf180mcu_fd_sc_mcu7t5v0__dlyd_1
Xinput28 tl_i[1] input28/Z VDD VDD VSS VSS gf180mcu_fd_sc_mcu7t5v0__dlyd_1
Xinput39 tl_i[38] input39/Z VDD VDD VSS VSS gf180mcu_fd_sc_mcu7t5v0__dlyd_1
XTAP_TAPCELL_ROW_90_1518 VDD VSS gf180mcu_fd_sc_mcu7t5v0__filltie
XFILLER_93_855 VDD VDD VSS VSS gf180mcu_fd_sc_mcu7t5v0__fill_1
XFILLER_18_462 VDD VDD VSS VSS gf180mcu_fd_sc_mcu7t5v0__fill_1
X_4910_ _4952_/A1 _4910_/A2 _4910_/B _7169_/D VDD VDD VSS VSS gf180mcu_fd_sc_mcu7t5v0__oai21_1
X_5890_ _5890_/A1 _5890_/A2 _6216_/B _5934_/A2 VDD VDD VSS VSS gf180mcu_fd_sc_mcu7t5v0__oai21_1
X_4841_ _7135_/Q _4854_/A2 _4842_/B VDD VDD VSS VSS gf180mcu_fd_sc_mcu7t5v0__nand2_1
XFILLER_60_262 VDD VDD VSS VSS gf180mcu_fd_sc_mcu7t5v0__fill_2
X_7560_ _7560_/D _7560_/RN _7781_/CLK _7560_/Q VDD VDD VSS VSS gf180mcu_fd_sc_mcu7t5v0__dffrnq_1
X_4772_ _4996_/A1 _4784_/A2 _4772_/B _7100_/D VDD VDD VSS VSS gf180mcu_fd_sc_mcu7t5v0__oai21_1
X_6511_ _7679_/Q _6516_/A4 _6512_/A2 VDD VDD VSS VSS gf180mcu_fd_sc_mcu7t5v0__xnor2_1
X_7491_ _7491_/D _7491_/CLK _7491_/Q VDD VDD VSS VSS gf180mcu_fd_sc_mcu7t5v0__dffq_1
X_3723_ _4221_/A1 _5493_/S _3723_/B _3729_/A2 VDD VDD VSS VSS gf180mcu_fd_sc_mcu7t5v0__oai21_1
X_6442_ _6451_/A2 _6442_/A2 _6440_/Z _6442_/B _7665_/D VDD VDD VSS VSS gf180mcu_fd_sc_mcu7t5v0__oai31_1
XTAP_TAPCELL_ROW_31_688 VDD VSS gf180mcu_fd_sc_mcu7t5v0__filltie
XTAP_TAPCELL_ROW_31_699 VDD VSS gf180mcu_fd_sc_mcu7t5v0__filltie
X_3654_ input48/Z _3603_/Z _3653_/Z _3654_/Z VDD VDD VSS VSS gf180mcu_fd_sc_mcu7t5v0__xor3_1
X_6373_ _7653_/Q input38/Z _6373_/S _7653_/D VDD VDD VSS VSS gf180mcu_fd_sc_mcu7t5v0__mux2_2
X_3585_ input40/Z input38/Z _3646_/A2 VDD VDD VSS VSS gf180mcu_fd_sc_mcu7t5v0__xnor2_1
X_5324_ _5345_/I0 _7471_/Q _5330_/S _7471_/D VDD VDD VSS VSS gf180mcu_fd_sc_mcu7t5v0__mux2_2
XFILLER_0_509 VDD VDD VSS VSS gf180mcu_fd_sc_mcu7t5v0__fill_1
X_5255_ _5304_/I0 _7402_/Q _5260_/S _7402_/D VDD VDD VSS VSS gf180mcu_fd_sc_mcu7t5v0__mux2_2
X_4206_ _6651_/A2 _4210_/A2 _5260_/S VDD VDD VSS VSS gf180mcu_fd_sc_mcu7t5v0__nand2_1
XTAP_TAPCELL_ROW_110_1798 VDD VSS gf180mcu_fd_sc_mcu7t5v0__filltie
XFILLER_96_671 VDD VDD VSS VSS gf180mcu_fd_sc_mcu7t5v0__fill_1
XTAP_TAPCELL_ROW_3_303 VDD VSS gf180mcu_fd_sc_mcu7t5v0__filltie
X_5186_ _5235_/I0 _7333_/Q _5190_/S _7333_/D VDD VDD VSS VSS gf180mcu_fd_sc_mcu7t5v0__mux2_2
XFILLER_69_896 VDD VDD VSS VSS gf180mcu_fd_sc_mcu7t5v0__fill_2
X_4137_ _4140_/A1 _5064_/A2 _4137_/B _6796_/D VDD VDD VSS VSS gf180mcu_fd_sc_mcu7t5v0__oai21_1
XFILLER_56_524 VDD VDD VSS VSS gf180mcu_fd_sc_mcu7t5v0__fill_1
XFILLER_84_877 VDD VDD VSS VSS gf180mcu_fd_sc_mcu7t5v0__fill_2
X_4068_ _4071_/A1 _4756_/A2 _4068_/B _6774_/D VDD VDD VSS VSS gf180mcu_fd_sc_mcu7t5v0__oai21_1
XTAP_TAPCELL_ROW_39_799 VDD VSS gf180mcu_fd_sc_mcu7t5v0__filltie
XFILLER_71_538 VDD VDD VSS VSS gf180mcu_fd_sc_mcu7t5v0__fill_2
X_7827_ _7827_/D _7827_/RN clkload7/I _7827_/Q VDD VDD VSS VSS gf180mcu_fd_sc_mcu7t5v0__dffrnq_1
XTAP_TAPCELL_ROW_61_1108 VDD VSS gf180mcu_fd_sc_mcu7t5v0__filltie
XTAP_TAPCELL_ROW_61_1119 VDD VSS gf180mcu_fd_sc_mcu7t5v0__filltie
X_7758_ _7758_/D _7760_/RN _7765_/CLK _7758_/Q VDD VDD VSS VSS gf180mcu_fd_sc_mcu7t5v0__dffrnq_1
XFILLER_40_947 VDD VDD VSS VSS gf180mcu_fd_sc_mcu7t5v0__fillcap_32
XTAP_TAPCELL_ROW_50_953 VDD VSS gf180mcu_fd_sc_mcu7t5v0__filltie
X_7689_ _7689_/D _7690_/RN _7692_/CLK _7689_/Q VDD VDD VSS VSS gf180mcu_fd_sc_mcu7t5v0__dffrnq_1
X_6709_ _6709_/I _7752_/D VDD VDD VSS VSS gf180mcu_fd_sc_mcu7t5v0__clkinv_1
XTAP_TAPCELL_ROW_50_964 VDD VSS gf180mcu_fd_sc_mcu7t5v0__filltie
XFILLER_106_754 VDD VDD VSS VSS gf180mcu_fd_sc_mcu7t5v0__fill_1
XFILLER_47_502 VDD VDD VSS VSS gf180mcu_fd_sc_mcu7t5v0__fill_2
XFILLER_75_833 VDD VDD VSS VSS gf180mcu_fd_sc_mcu7t5v0__fillcap_4
Xfanout194 wire197/I _6326_/A2 VDD VDD VSS VSS gf180mcu_fd_sc_mcu7t5v0__dlyd_1
XFILLER_19_248 VDD VDD VSS VSS gf180mcu_fd_sc_mcu7t5v0__fill_1
XTAP_TAPCELL_ROW_87_1480 VDD VSS gf180mcu_fd_sc_mcu7t5v0__filltie
XFILLER_74_387 VDD VDD VSS VSS gf180mcu_fd_sc_mcu7t5v0__fill_2
XFILLER_34_229 VDD VDD VSS VSS gf180mcu_fd_sc_mcu7t5v0__fill_1
XFILLER_43_763 VDD VDD VSS VSS gf180mcu_fd_sc_mcu7t5v0__fillcap_4
XFILLER_30_402 VDD VDD VSS VSS gf180mcu_fd_sc_mcu7t5v0__fill_1
XFILLER_70_593 VDD VDD VSS VSS gf180mcu_fd_sc_mcu7t5v0__fill_2
XFILLER_6_141 VDD VDD VSS VSS gf180mcu_fd_sc_mcu7t5v0__fill_2
XFILLER_6_174 VDD VDD VSS VSS gf180mcu_fd_sc_mcu7t5v0__fill_1
X_3370_ _7723_/Q _6619_/A1 VDD VDD VSS VSS gf180mcu_fd_sc_mcu7t5v0__clkinv_1
XFILLER_98_947 VDD VDD VSS VSS gf180mcu_fd_sc_mcu7t5v0__fillcap_32
Xload_slew523 _5243_/I0 _5341_/I0 VDD VDD VSS VSS gf180mcu_fd_sc_mcu7t5v0__buf_3
Xload_slew512 wire513/Z _5309_/I0 VDD VDD VSS VSS gf180mcu_fd_sc_mcu7t5v0__buf_4
Xload_slew501 _6571_/S _6569_/S VDD VDD VSS VSS gf180mcu_fd_sc_mcu7t5v0__buf_2
Xload_slew534 _5339_/I0 _5304_/I0 VDD VDD VSS VSS gf180mcu_fd_sc_mcu7t5v0__clkbuf_4
Xload_slew545 fanout543/Z _7811_/RN VDD VDD VSS VSS gf180mcu_fd_sc_mcu7t5v0__buf_3
XFILLER_33_4 VDD VDD VSS VSS gf180mcu_fd_sc_mcu7t5v0__fill_1
X_5040_ _5068_/A1 _5050_/A2 _5040_/B _7234_/D VDD VDD VSS VSS gf180mcu_fd_sc_mcu7t5v0__oai21_1
Xload_slew556 _7733_/RN _7558_/RN VDD VDD VSS VSS gf180mcu_fd_sc_mcu7t5v0__buf_4
Xload_slew578 _7614_/RN _7595_/RN VDD VDD VSS VSS gf180mcu_fd_sc_mcu7t5v0__buf_4
Xload_slew567 _7708_/RN _7709_/RN VDD VDD VSS VSS gf180mcu_fd_sc_mcu7t5v0__buf_2
XFILLER_93_663 VDD VDD VSS VSS gf180mcu_fd_sc_mcu7t5v0__fill_1
X_6991_ _6991_/D _7070_/CLK _6991_/Q VDD VDD VSS VSS gf180mcu_fd_sc_mcu7t5v0__dffq_1
X_5942_ _7559_/Q _5677_/I _6271_/B1 _7617_/Q _5943_/A4 VDD VDD VSS VSS gf180mcu_fd_sc_mcu7t5v0__aoi22_1
XFILLER_65_376 VDD VDD VSS VSS gf180mcu_fd_sc_mcu7t5v0__fill_1
XTAP_TAPCELL_ROW_36_758 VDD VSS gf180mcu_fd_sc_mcu7t5v0__filltie
XTAP_TAPCELL_ROW_36_769 VDD VSS gf180mcu_fd_sc_mcu7t5v0__filltie
X_5873_ _5873_/A1 _5873_/A2 _5873_/B _6237_/B _5874_/B VDD VDD VSS VSS gf180mcu_fd_sc_mcu7t5v0__oai211_1
X_7612_ _7612_/D _7612_/RN _7669_/CLK _7612_/Q VDD VDD VSS VSS gf180mcu_fd_sc_mcu7t5v0__dffrnq_1
XTAP_TAPCELL_ROW_16_482 VDD VSS gf180mcu_fd_sc_mcu7t5v0__filltie
XFILLER_22_947 VDD VDD VSS VSS gf180mcu_fd_sc_mcu7t5v0__fillcap_32
X_4824_ _4824_/A1 _4826_/A2 _4824_/B _7126_/D VDD VDD VSS VSS gf180mcu_fd_sc_mcu7t5v0__oai21_1
X_4755_ _7092_/Q _4756_/A2 _4756_/B VDD VDD VSS VSS gf180mcu_fd_sc_mcu7t5v0__nand2_1
X_7543_ _7543_/D _7760_/RN _7790_/CLK _7543_/Q VDD VDD VSS VSS gf180mcu_fd_sc_mcu7t5v0__dffrnq_1
X_3706_ _6315_/A1 _5813_/A2 _3703_/Z _7783_/D VDD VDD VSS VSS gf180mcu_fd_sc_mcu7t5v0__nor3_4
X_4686_ wire291/Z _4686_/A2 _4686_/B _7057_/D VDD VDD VSS VSS gf180mcu_fd_sc_mcu7t5v0__oai21_1
X_7474_ _7474_/D _7483_/CLK _7474_/Q VDD VDD VSS VSS gf180mcu_fd_sc_mcu7t5v0__dffq_1
X_6425_ _7663_/Q _7529_/Q _6438_/A1 VDD VDD VSS VSS gf180mcu_fd_sc_mcu7t5v0__xnor2_1
X_3637_ _7881_/I input78/Z _3637_/Z VDD VDD VSS VSS gf180mcu_fd_sc_mcu7t5v0__xor2_1
XTAP_TAPCELL_ROW_112_1827 VDD VSS gf180mcu_fd_sc_mcu7t5v0__filltie
XFILLER_89_914 VDD VDD VSS VSS gf180mcu_fd_sc_mcu7t5v0__fill_1
X_6356_ _6356_/I0 input33/Z _7782_/D _7642_/D VDD VDD VSS VSS gf180mcu_fd_sc_mcu7t5v0__mux2_2
XTAP_TAPCELL_ROW_58_1070 VDD VSS gf180mcu_fd_sc_mcu7t5v0__filltie
X_3568_ _3566_/Z _3567_/Z _3568_/Z VDD VDD VSS VSS gf180mcu_fd_sc_mcu7t5v0__xor2_1
X_5307_ wire521/I _7454_/Q _5309_/S _7454_/D VDD VDD VSS VSS gf180mcu_fd_sc_mcu7t5v0__mux2_2
X_6287_ _7529_/Q _6301_/B1 _6288_/B2 VDD VDD VSS VSS gf180mcu_fd_sc_mcu7t5v0__nand2_1
XFILLER_88_457 VDD VDD VSS VSS gf180mcu_fd_sc_mcu7t5v0__fill_1
X_3499_ _3499_/I _3925_/A3 VDD VDD VSS VSS gf180mcu_fd_sc_mcu7t5v0__clkinv_1
X_5238_ _5245_/I0 _7385_/Q _5239_/S _7385_/D VDD VDD VSS VSS gf180mcu_fd_sc_mcu7t5v0__mux2_2
XFILLER_57_822 VDD VDD VSS VSS gf180mcu_fd_sc_mcu7t5v0__fillcap_8
X_5169_ wire513/Z _7316_/Q _5169_/S _7316_/D VDD VDD VSS VSS gf180mcu_fd_sc_mcu7t5v0__mux2_2
XFILLER_56_343 VDD VDD VSS VSS gf180mcu_fd_sc_mcu7t5v0__fill_2
XFILLER_57_888 VDD VDD VSS VSS gf180mcu_fd_sc_mcu7t5v0__fillcap_16
XFILLER_44_527 VDD VDD VSS VSS gf180mcu_fd_sc_mcu7t5v0__fill_1
XFILLER_71_368 VDD VDD VSS VSS gf180mcu_fd_sc_mcu7t5v0__fill_2
XFILLER_4_667 VDD VDD VSS VSS gf180mcu_fd_sc_mcu7t5v0__fillcap_64
XFILLER_48_800 VDD VDD VSS VSS gf180mcu_fd_sc_mcu7t5v0__fillcap_4
XFILLER_48_877 VDD VDD VSS VSS gf180mcu_fd_sc_mcu7t5v0__fillcap_16
XFILLER_28_590 VDD VDD VSS VSS gf180mcu_fd_sc_mcu7t5v0__fillcap_4
XTAP_TAPCELL_ROW_33_717 VDD VSS gf180mcu_fd_sc_mcu7t5v0__filltie
XTAP_TAPCELL_ROW_13_441 VDD VSS gf180mcu_fd_sc_mcu7t5v0__filltie
XFILLER_31_766 VDD VDD VSS VSS gf180mcu_fd_sc_mcu7t5v0__fillcap_4
X_4540_ _4540_/A1 _4546_/A2 _4540_/B _6984_/D VDD VDD VSS VSS gf180mcu_fd_sc_mcu7t5v0__oai21_1
X_4471_ _6950_/Q _4476_/A2 _4472_/B VDD VDD VSS VSS gf180mcu_fd_sc_mcu7t5v0__nand2_1
X_6210_ _6176_/B _6210_/A2 _6210_/A3 _6218_/B1 VDD VDD VSS VSS gf180mcu_fd_sc_mcu7t5v0__nor3_1
X_7190_ _7190_/D _7453_/CLK _7190_/Q VDD VDD VSS VSS gf180mcu_fd_sc_mcu7t5v0__dffq_1
X_3422_ _7546_/Q _3747_/C VDD VDD VSS VSS gf180mcu_fd_sc_mcu7t5v0__clkinv_1
X_6141_ _7260_/Q _6141_/A2 wire322/Z _7148_/Q _6221_/B _6142_/A2 VDD VDD VSS VSS gf180mcu_fd_sc_mcu7t5v0__oai221_1
Xload_slew320 _6198_/C2 _6092_/A2 VDD VDD VSS VSS gf180mcu_fd_sc_mcu7t5v0__buf_4
X_3353_ _7748_/Q _3930_/A1 VDD VDD VSS VSS gf180mcu_fd_sc_mcu7t5v0__clkinv_1
X_6072_ _6072_/A1 _6072_/A2 _6082_/A1 VDD VDD VSS VSS gf180mcu_fd_sc_mcu7t5v0__nor2_1
Xload_slew364 _6283_/C1 _6256_/A2 VDD VDD VSS VSS gf180mcu_fd_sc_mcu7t5v0__buf_4
Xload_slew386 _5600_/C2 _5544_/A2 VDD VDD VSS VSS gf180mcu_fd_sc_mcu7t5v0__buf_2
Xload_slew375 _5600_/B1 _5597_/B1 VDD VDD VSS VSS gf180mcu_fd_sc_mcu7t5v0__buf_4
X_5023_ _7226_/Q _5036_/A2 _5024_/B VDD VDD VSS VSS gf180mcu_fd_sc_mcu7t5v0__nand2_1
Xload_slew397 _6593_/A2 _6055_/A2 VDD VDD VSS VSS gf180mcu_fd_sc_mcu7t5v0__buf_4
XFILLER_38_376 VDD VDD VSS VSS gf180mcu_fd_sc_mcu7t5v0__fill_1
X_6974_ _6974_/D _7003_/CLK _6974_/Q VDD VDD VSS VSS gf180mcu_fd_sc_mcu7t5v0__dffq_1
X_5925_ _6850_/Q _6593_/A2 wire341/I _6843_/Q _7277_/Q _6201_/B1 _5926_/A2 VDD VDD
+ VSS VSS gf180mcu_fd_sc_mcu7t5v0__oai222_1
X_5856_ _7038_/Q _6153_/B1 _6227_/C _5857_/A2 VDD VDD VSS VSS gf180mcu_fd_sc_mcu7t5v0__oai21_1
XPHY_EDGE_ROW_3_Right_3 VDD VSS gf180mcu_fd_sc_mcu7t5v0__endcap
X_4807_ _7118_/Q _4812_/A2 _4808_/B VDD VDD VSS VSS gf180mcu_fd_sc_mcu7t5v0__nand2_1
X_5787_ _5787_/I _5788_/B VDD VDD VSS VSS gf180mcu_fd_sc_mcu7t5v0__clkinv_1
X_7526_ _7526_/D _7708_/RN _7711_/CLK _7526_/Q VDD VDD VSS VSS gf180mcu_fd_sc_mcu7t5v0__dffrnq_1
X_4738_ _4822_/A1 _4742_/A2 _4738_/B _7083_/D VDD VDD VSS VSS gf180mcu_fd_sc_mcu7t5v0__oai21_1
XFILLER_21_298 VDD VDD VSS VSS gf180mcu_fd_sc_mcu7t5v0__fill_1
X_4669_ _7049_/Q _4672_/A2 _4670_/B VDD VDD VSS VSS gf180mcu_fd_sc_mcu7t5v0__nand2_1
X_7457_ _7457_/D _7482_/CLK _7457_/Q VDD VDD VSS VSS gf180mcu_fd_sc_mcu7t5v0__dffq_1
X_6408_ _6479_/S _6407_/Z _6408_/B _7660_/D VDD VDD VSS VSS gf180mcu_fd_sc_mcu7t5v0__aoi21_1
XFILLER_107_348 VDD VDD VSS VSS gf180mcu_fd_sc_mcu7t5v0__fill_2
XFILLER_116_871 VDD VDD VSS VSS gf180mcu_fd_sc_mcu7t5v0__fillcap_4
XFILLER_1_626 VDD VDD VSS VSS gf180mcu_fd_sc_mcu7t5v0__fillcap_4
X_7388_ _7388_/D _7472_/CLK _7388_/Q VDD VDD VSS VSS gf180mcu_fd_sc_mcu7t5v0__dffq_1
X_6339_ input46/Z _6344_/S _6340_/B VDD VDD VSS VSS gf180mcu_fd_sc_mcu7t5v0__nand2_1
XFILLER_45_836 VDD VDD VSS VSS gf180mcu_fd_sc_mcu7t5v0__fillcap_4
XFILLER_13_766 VDD VDD VSS VSS gf180mcu_fd_sc_mcu7t5v0__fillcap_4
XTAP_TAPCELL_ROW_10_400 VDD VSS gf180mcu_fd_sc_mcu7t5v0__filltie
XFILLER_5_976 VDD VDD VSS VSS gf180mcu_fd_sc_mcu7t5v0__fillcap_4
XTAP_TAPCELL_ROW_95_1590 VDD VSS gf180mcu_fd_sc_mcu7t5v0__filltie
XFILLER_4_453 VDD VDD VSS VSS gf180mcu_fd_sc_mcu7t5v0__fill_2
XFILLER_83_909 VDD VDD VSS VSS gf180mcu_fd_sc_mcu7t5v0__fill_1
XTAP_TAPCELL_ROW_18_511 VDD VSS gf180mcu_fd_sc_mcu7t5v0__filltie
X_3971_ wire248/I _4336_/A2 _3971_/B _6744_/D VDD VDD VSS VSS gf180mcu_fd_sc_mcu7t5v0__oai21_1
XFILLER_23_519 VDD VDD VSS VSS gf180mcu_fd_sc_mcu7t5v0__fill_1
XFILLER_63_699 VDD VDD VSS VSS gf180mcu_fd_sc_mcu7t5v0__fill_1
X_5710_ _7615_/Q _6490_/A1 _6349_/A1 _7693_/Q _5710_/C _5715_/A1 VDD VDD VSS VSS gf180mcu_fd_sc_mcu7t5v0__aoi221_1
XTAP_TAPCELL_ROW_46_897 VDD VSS gf180mcu_fd_sc_mcu7t5v0__filltie
X_6690_ _7745_/Q _6690_/A2 _6692_/A2 VDD VDD VSS VSS gf180mcu_fd_sc_mcu7t5v0__xnor2_1
X_5641_ _7524_/Q input50/Z _5642_/S _7524_/D VDD VDD VSS VSS gf180mcu_fd_sc_mcu7t5v0__mux2_2
X_5572_ _7372_/Q wire420/I _5603_/A2 _7379_/Q _7386_/Q _5572_/C2 _5573_/A2 VDD VDD
+ VSS VSS gf180mcu_fd_sc_mcu7t5v0__oai222_1
X_4523_ _6976_/Q _4532_/A2 _4524_/B VDD VDD VSS VSS gf180mcu_fd_sc_mcu7t5v0__nand2_1
X_7311_ _7311_/D _7418_/CLK _7311_/Q VDD VDD VSS VSS gf180mcu_fd_sc_mcu7t5v0__dffq_1
XFILLER_105_808 VDD VDD VSS VSS gf180mcu_fd_sc_mcu7t5v0__fillcap_16
Xclkbuf_leaf_2_clk_i clkload0/I clkload9/I VDD VDD VSS VSS gf180mcu_fd_sc_mcu7t5v0__clkbuf_8
X_7242_ _7242_/D _7247_/CLK _7242_/Q VDD VDD VSS VSS gf180mcu_fd_sc_mcu7t5v0__dffq_1
X_4454_ _5056_/A1 _4462_/A2 _4454_/B _6941_/D VDD VDD VSS VSS gf180mcu_fd_sc_mcu7t5v0__oai21_1
X_4385_ _6907_/Q _4392_/A2 _4386_/B VDD VDD VSS VSS gf180mcu_fd_sc_mcu7t5v0__nand2_1
X_3405_ _7684_/Q _6525_/A1 VDD VDD VSS VSS gf180mcu_fd_sc_mcu7t5v0__clkinv_1
X_7173_ _7173_/D _7719_/CLK _7173_/Q VDD VDD VSS VSS gf180mcu_fd_sc_mcu7t5v0__dffq_1
X_6124_ _6124_/I0 _6124_/I1 _6124_/S _6124_/Z VDD VDD VSS VSS gf180mcu_fd_sc_mcu7t5v0__mux2_2
X_6055_ _7188_/Q _6055_/A2 _6177_/B1 _7181_/Q _7174_/Q _6241_/B1 _6056_/I VDD VDD
+ VSS VSS gf180mcu_fd_sc_mcu7t5v0__oai222_1
XFILLER_73_408 VDD VDD VSS VSS gf180mcu_fd_sc_mcu7t5v0__fill_2
X_5006_ _5006_/A1 _5008_/A2 _5006_/B _7217_/D VDD VDD VSS VSS gf180mcu_fd_sc_mcu7t5v0__oai21_1
XFILLER_27_836 VDD VDD VSS VSS gf180mcu_fd_sc_mcu7t5v0__fillcap_4
XFILLER_39_696 VDD VDD VSS VSS gf180mcu_fd_sc_mcu7t5v0__fillcap_4
XTAP_TAPCELL_ROW_107_1759 VDD VSS gf180mcu_fd_sc_mcu7t5v0__filltie
X_6957_ _6957_/D _7667_/CLK _6957_/Q VDD VDD VSS VSS gf180mcu_fd_sc_mcu7t5v0__dffq_1
XFILLER_26_368 VDD VDD VSS VSS gf180mcu_fd_sc_mcu7t5v0__fill_2
XTAP_TAPCELL_ROW_66_1180 VDD VSS gf180mcu_fd_sc_mcu7t5v0__filltie
X_6888_ _6888_/D _7008_/CLK _6888_/Q VDD VDD VSS VSS gf180mcu_fd_sc_mcu7t5v0__dffq_1
X_5908_ _5908_/A1 _5908_/A2 _6196_/B _5937_/A2 VDD VDD VSS VSS gf180mcu_fd_sc_mcu7t5v0__oai21_1
X_5839_ _5839_/A1 _5839_/A2 _5840_/B VDD VDD VSS VSS gf180mcu_fd_sc_mcu7t5v0__or2_1
XFILLER_50_872 VDD VDD VSS VSS gf180mcu_fd_sc_mcu7t5v0__fill_2
X_7509_ _7509_/D _7810_/RN clkload8/I _7509_/Q VDD VDD VSS VSS gf180mcu_fd_sc_mcu7t5v0__dffsnq_1
XPHY_EDGE_ROW_15_Left_134 VDD VSS gf180mcu_fd_sc_mcu7t5v0__endcap
XFILLER_104_874 VDD VDD VSS VSS gf180mcu_fd_sc_mcu7t5v0__fill_1
XFILLER_89_574 VDD VDD VSS VSS gf180mcu_fd_sc_mcu7t5v0__fill_1
XFILLER_2_979 VDD VDD VSS VSS gf180mcu_fd_sc_mcu7t5v0__fill_2
XFILLER_92_739 VDD VDD VSS VSS gf180mcu_fd_sc_mcu7t5v0__fill_1
XPHY_EDGE_ROW_24_Left_143 VDD VSS gf180mcu_fd_sc_mcu7t5v0__endcap
XFILLER_57_460 VDD VDD VSS VSS gf180mcu_fd_sc_mcu7t5v0__fill_1
XTAP_TAPCELL_ROW_82_1409 VDD VSS gf180mcu_fd_sc_mcu7t5v0__filltie
XFILLER_25_390 VDD VDD VSS VSS gf180mcu_fd_sc_mcu7t5v0__fill_1
XTAP_TAPCELL_ROW_43_856 VDD VSS gf180mcu_fd_sc_mcu7t5v0__filltie
XTAP_TAPCELL_ROW_43_867 VDD VSS gf180mcu_fd_sc_mcu7t5v0__filltie
XFILLER_9_545 VDD VDD VSS VSS gf180mcu_fd_sc_mcu7t5v0__fillcap_8
XTAP_TAPCELL_ROW_23_580 VDD VSS gf180mcu_fd_sc_mcu7t5v0__filltie
XPHY_EDGE_ROW_33_Left_152 VDD VSS gf180mcu_fd_sc_mcu7t5v0__endcap
X_4170_ _4170_/A1 _4226_/A3 _4179_/A2 VDD VDD VSS VSS gf180mcu_fd_sc_mcu7t5v0__nor2_1
XFILLER_110_877 VDD VDD VSS VSS gf180mcu_fd_sc_mcu7t5v0__fillcap_64
XPHY_EDGE_ROW_42_Left_161 VDD VSS gf180mcu_fd_sc_mcu7t5v0__endcap
XFILLER_67_279 VDD VDD VSS VSS gf180mcu_fd_sc_mcu7t5v0__fill_1
XFILLER_48_482 VDD VDD VSS VSS gf180mcu_fd_sc_mcu7t5v0__fill_2
X_6811_ _6811_/D _7378_/CLK _6811_/Q VDD VDD VSS VSS gf180mcu_fd_sc_mcu7t5v0__dffq_1
XFILLER_50_113 VDD VDD VSS VSS gf180mcu_fd_sc_mcu7t5v0__fill_1
X_7791_ _7791_/D _7791_/RN _7793_/CLK _7791_/Q VDD VDD VSS VSS gf180mcu_fd_sc_mcu7t5v0__dffrnq_1
X_6742_ _6742_/D _6882_/CLK _6742_/Q VDD VDD VSS VSS gf180mcu_fd_sc_mcu7t5v0__dffq_1
X_3954_ _7719_/Q _7720_/Q _3966_/A1 _4129_/A1 VDD VDD VSS VSS gf180mcu_fd_sc_mcu7t5v0__nor3_4
XTAP_TAPCELL_ROW_102_1689 VDD VSS gf180mcu_fd_sc_mcu7t5v0__filltie
XPHY_EDGE_ROW_51_Left_170 VDD VSS gf180mcu_fd_sc_mcu7t5v0__endcap
X_6673_ _6697_/A1 _6672_/Z _6694_/A2 VDD VDD VSS VSS gf180mcu_fd_sc_mcu7t5v0__nor2_1
X_3885_ _3879_/Z _3885_/A2 _6368_/I1 VDD VDD VSS VSS gf180mcu_fd_sc_mcu7t5v0__nor2_1
X_5624_ _5625_/A1 _5623_/Z _5625_/B VDD VDD VSS VSS gf180mcu_fd_sc_mcu7t5v0__nor2_1
X_5555_ _5366_/Z _5554_/Z _5556_/C VDD VDD VSS VSS gf180mcu_fd_sc_mcu7t5v0__nand2_1
X_4506_ _4506_/A1 _4518_/A2 _4506_/B _6967_/D VDD VDD VSS VSS gf180mcu_fd_sc_mcu7t5v0__oai21_1
X_5486_ _7453_/Q _5599_/A2 _5578_/A2 _7425_/Q _5488_/A1 VDD VDD VSS VSS gf180mcu_fd_sc_mcu7t5v0__oai22_1
X_4437_ _6933_/Q _4448_/A2 _4438_/B VDD VDD VSS VSS gf180mcu_fd_sc_mcu7t5v0__nand2_1
X_7225_ _7225_/D _7267_/CLK _7225_/Q VDD VDD VSS VSS gf180mcu_fd_sc_mcu7t5v0__dffq_1
Xfanout502 _7671_/Q _6576_/S VDD VDD VSS VSS gf180mcu_fd_sc_mcu7t5v0__dlyd_1
Xuart_608 racl_error_o[12] VDD VDD VSS VSS gf180mcu_fd_sc_mcu7t5v0__tiel
Xuart_619 racl_error_o[23] VDD VDD VSS VSS gf180mcu_fd_sc_mcu7t5v0__tiel
Xfanout524 _7642_/Q _6356_/I0 VDD VDD VSS VSS gf180mcu_fd_sc_mcu7t5v0__dlyd_1
X_7156_ _7156_/D _7233_/CLK _7156_/Q VDD VDD VSS VSS gf180mcu_fd_sc_mcu7t5v0__dffq_1
X_4368_ _5012_/A1 _4378_/A2 _4368_/B _6898_/D VDD VDD VSS VSS gf180mcu_fd_sc_mcu7t5v0__oai21_1
XFILLER_86_522 VDD VDD VSS VSS gf180mcu_fd_sc_mcu7t5v0__fill_2
Xfanout546 input6/Z fanout546/Z VDD VDD VSS VSS gf180mcu_fd_sc_mcu7t5v0__dlyd_1
Xfanout535 fanout538/Z _5352_/I0 VDD VDD VSS VSS gf180mcu_fd_sc_mcu7t5v0__dlyd_1
Xfanout557 input6/Z _7780_/RN VDD VDD VSS VSS gf180mcu_fd_sc_mcu7t5v0__dlyd_1
X_6107_ _7168_/Q _6241_/A2 _6239_/B1 _7175_/Q _7182_/Q _6177_/B1 _6108_/A2 VDD VDD
+ VSS VSS gf180mcu_fd_sc_mcu7t5v0__oai222_1
XFILLER_100_332 VDD VDD VSS VSS gf180mcu_fd_sc_mcu7t5v0__fill_2
X_7087_ _7087_/D _7099_/CLK _7087_/Q VDD VDD VSS VSS gf180mcu_fd_sc_mcu7t5v0__dffq_1
X_4299_ _6864_/Q _4308_/A2 _4300_/B VDD VDD VSS VSS gf180mcu_fd_sc_mcu7t5v0__nand2_1
XFILLER_47_909 VDD VDD VSS VSS gf180mcu_fd_sc_mcu7t5v0__fill_1
X_6038_ _6922_/Q _6167_/B1 _6085_/B1 _6929_/Q _6040_/A1 VDD VDD VSS VSS gf180mcu_fd_sc_mcu7t5v0__oai22_1
XTAP_TAPCELL_ROW_1_275 VDD VSS gf180mcu_fd_sc_mcu7t5v0__filltie
XFILLER_70_901 VDD VDD VSS VSS gf180mcu_fd_sc_mcu7t5v0__fillcap_4
XFILLER_41_157 VDD VDD VSS VSS gf180mcu_fd_sc_mcu7t5v0__fill_1
XTAP_TAPCELL_ROW_40_815 VDD VSS gf180mcu_fd_sc_mcu7t5v0__filltie
XTAP_TAPCELL_ROW_79_1360 VDD VSS gf180mcu_fd_sc_mcu7t5v0__filltie
XFILLER_6_537 VDD VDD VSS VSS gf180mcu_fd_sc_mcu7t5v0__fillcap_32
XFILLER_108_454 VDD VDD VSS VSS gf180mcu_fd_sc_mcu7t5v0__fill_1
XTAP_TAPCELL_ROW_79_1371 VDD VSS gf180mcu_fd_sc_mcu7t5v0__filltie
XTAP_TAPCELL_ROW_9_386 VDD VSS gf180mcu_fd_sc_mcu7t5v0__filltie
XFILLER_89_371 VDD VDD VSS VSS gf180mcu_fd_sc_mcu7t5v0__fill_2
XFILLER_37_419 VDD VDD VSS VSS gf180mcu_fd_sc_mcu7t5v0__fill_1
XTAP_TAPCELL_ROW_48_926 VDD VSS gf180mcu_fd_sc_mcu7t5v0__filltie
XFILLER_45_430 VDD VDD VSS VSS gf180mcu_fd_sc_mcu7t5v0__fill_1
XTAP_TAPCELL_ROW_48_937 VDD VSS gf180mcu_fd_sc_mcu7t5v0__filltie
XTAP_TAPCELL_ROW_28_650 VDD VSS gf180mcu_fd_sc_mcu7t5v0__filltie
XFILLER_61_912 VDD VDD VSS VSS gf180mcu_fd_sc_mcu7t5v0__fillcap_64
X_3670_ _3685_/A2 _6315_/A1 _3670_/B1 _7881_/I _3675_/A2 VDD VDD VSS VSS gf180mcu_fd_sc_mcu7t5v0__oai22_1
Xoutput116 _7805_/Q intr_rx_watermark_o VDD VDD VSS VSS gf180mcu_fd_sc_mcu7t5v0__dlyd_1
X_5340_ _5347_/I0 _7487_/Q _5344_/S _7487_/D VDD VDD VSS VSS gf180mcu_fd_sc_mcu7t5v0__mux2_2
Xoutput138 _7578_/Q tl_o[22] VDD VDD VSS VSS gf180mcu_fd_sc_mcu7t5v0__dlyd_1
Xoutput127 _7884_/Z tl_o[11] VDD VDD VSS VSS gf180mcu_fd_sc_mcu7t5v0__dlyd_1
Xoutput149 _7588_/Q tl_o[32] VDD VDD VSS VSS gf180mcu_fd_sc_mcu7t5v0__dlyd_1
Xclkbuf_leaf_82_clk_i clkbuf_3_1__f_clk_i/Z _7491_/CLK VDD VDD VSS VSS gf180mcu_fd_sc_mcu7t5v0__clkbuf_8
X_5271_ wire525/Z _7418_/Q _5274_/S _7418_/D VDD VDD VSS VSS gf180mcu_fd_sc_mcu7t5v0__mux2_2
X_7010_ _7010_/D _7099_/CLK _7010_/Q VDD VDD VSS VSS gf180mcu_fd_sc_mcu7t5v0__dffq_1
X_4222_ _7736_/Q _6657_/A2 _5309_/S VDD VDD VSS VSS gf180mcu_fd_sc_mcu7t5v0__nand2_2
X_4153_ _7732_/Q _7733_/Q _4235_/A1 VDD VDD VSS VSS gf180mcu_fd_sc_mcu7t5v0__nor2_2
X_4084_ _7723_/Q _7724_/Q _4138_/A3 VDD VDD VSS VSS gf180mcu_fd_sc_mcu7t5v0__nand2_1
XFILLER_68_599 VDD VDD VSS VSS gf180mcu_fd_sc_mcu7t5v0__fill_1
XFILLER_49_780 VDD VDD VSS VSS gf180mcu_fd_sc_mcu7t5v0__fillcap_4
XTAP_TAPCELL_ROW_104_1718 VDD VSS gf180mcu_fd_sc_mcu7t5v0__filltie
Xclkbuf_leaf_20_clk_i clkload1/I _7710_/CLK VDD VDD VSS VSS gf180mcu_fd_sc_mcu7t5v0__clkbuf_8
XFILLER_63_282 VDD VDD VSS VSS gf180mcu_fd_sc_mcu7t5v0__fill_2
X_7774_ _7774_/D _7825_/RN clkload8/I _7774_/Q VDD VDD VSS VSS gf180mcu_fd_sc_mcu7t5v0__dffrnq_1
X_4986_ _5070_/A1 _4994_/A2 _4986_/B _7207_/D VDD VDD VSS VSS gf180mcu_fd_sc_mcu7t5v0__oai21_1
X_6725_ _6733_/A4 _6725_/A2 _7761_/D VDD VDD VSS VSS gf180mcu_fd_sc_mcu7t5v0__xor2_1
X_3937_ _3937_/I _6608_/A2 VDD VDD VSS VSS gf180mcu_fd_sc_mcu7t5v0__clkinv_1
Xclkbuf_leaf_35_clk_i clkload5/I _7724_/CLK VDD VDD VSS VSS gf180mcu_fd_sc_mcu7t5v0__clkbuf_8
X_6656_ _6657_/A2 _6654_/B _6656_/A3 _7735_/D VDD VDD VSS VSS gf180mcu_fd_sc_mcu7t5v0__nor3_1
X_3868_ _6679_/I0 _3932_/A1 _3869_/B VDD VDD VSS VSS gf180mcu_fd_sc_mcu7t5v0__nor2_1
X_5607_ _6824_/Q _5607_/A2 _5607_/B1 _6802_/Q _5608_/A3 VDD VDD VSS VSS gf180mcu_fd_sc_mcu7t5v0__oai22_1
X_3799_ _7825_/D _3798_/I _3812_/A1 VDD VDD VSS VSS gf180mcu_fd_sc_mcu7t5v0__nor2_1
X_6587_ _7712_/Q _6603_/A2 _6588_/B VDD VDD VSS VSS gf180mcu_fd_sc_mcu7t5v0__nand2_1
XFILLER_117_240 VDD VDD VSS VSS gf180mcu_fd_sc_mcu7t5v0__fill_2
X_5538_ _5609_/B _5538_/A2 _5538_/A3 _5539_/B VDD VDD VSS VSS gf180mcu_fd_sc_mcu7t5v0__or3_1
XTAP_TAPCELL_ROW_115_1869 VDD VSS gf180mcu_fd_sc_mcu7t5v0__filltie
XFILLER_106_947 VDD VDD VSS VSS gf180mcu_fd_sc_mcu7t5v0__fillcap_32
X_5469_ _5469_/A1 _5469_/A2 _5479_/B1 VDD VDD VSS VSS gf180mcu_fd_sc_mcu7t5v0__nor2_1
X_7208_ _7208_/D _7251_/CLK _7208_/Q VDD VDD VSS VSS gf180mcu_fd_sc_mcu7t5v0__dffq_1
XFILLER_99_680 VDD VDD VSS VSS gf180mcu_fd_sc_mcu7t5v0__fillcap_8
Xfanout310 wire313/I _6207_/B1 VDD VDD VSS VSS gf180mcu_fd_sc_mcu7t5v0__dlyd_1
Xfanout321 fanout323/Z wire322/I VDD VDD VSS VSS gf180mcu_fd_sc_mcu7t5v0__dlyd_1
XTAP_TAPCELL_ROW_74_1290 VDD VSS gf180mcu_fd_sc_mcu7t5v0__filltie
Xfanout365 _5635_/ZN _6301_/B1 VDD VDD VSS VSS gf180mcu_fd_sc_mcu7t5v0__dlyd_1
Xfanout354 fanout358/Z wire355/I VDD VDD VSS VSS gf180mcu_fd_sc_mcu7t5v0__dlyd_1
XTAP_TAPCELL_ROW_6_345 VDD VSS gf180mcu_fd_sc_mcu7t5v0__filltie
X_7139_ _7139_/D _7233_/CLK _7139_/Q VDD VDD VSS VSS gf180mcu_fd_sc_mcu7t5v0__dffq_1
XFILLER_101_652 VDD VDD VSS VSS gf180mcu_fd_sc_mcu7t5v0__fill_1
Xfanout398 _6242_/A2 _6092_/C2 VDD VDD VSS VSS gf180mcu_fd_sc_mcu7t5v0__dlyd_1
Xfanout387 _5371_/ZN _5613_/A2 VDD VDD VSS VSS gf180mcu_fd_sc_mcu7t5v0__dlyd_1
XFILLER_101_696 VDD VDD VSS VSS gf180mcu_fd_sc_mcu7t5v0__fillcap_4
XFILLER_43_912 VDD VDD VSS VSS gf180mcu_fd_sc_mcu7t5v0__fillcap_64
XFILLER_55_794 VDD VDD VSS VSS gf180mcu_fd_sc_mcu7t5v0__fill_1
XFILLER_11_842 VDD VDD VSS VSS gf180mcu_fd_sc_mcu7t5v0__fillcap_64
XTAP_TAPCELL_ROW_53_995 VDD VSS gf180mcu_fd_sc_mcu7t5v0__filltie
Xinput18 tl_i[112] input18/Z VDD VDD VSS VSS gf180mcu_fd_sc_mcu7t5v0__dlyd_1
XFILLER_109_752 VDD VDD VSS VSS gf180mcu_fd_sc_mcu7t5v0__fillcap_4
XFILLER_6_312 VDD VDD VSS VSS gf180mcu_fd_sc_mcu7t5v0__fill_2
Xinput29 tl_i[29] input29/Z VDD VDD VSS VSS gf180mcu_fd_sc_mcu7t5v0__dlyd_1
XTAP_TAPCELL_ROW_90_1519 VDD VSS gf180mcu_fd_sc_mcu7t5v0__filltie
XFILLER_46_772 VDD VDD VSS VSS gf180mcu_fd_sc_mcu7t5v0__fill_1
X_4840_ _4952_/A1 _4840_/A2 _4840_/B _7134_/D VDD VDD VSS VSS gf180mcu_fd_sc_mcu7t5v0__oai21_1
X_6510_ _7679_/Q _6516_/A4 _6514_/A2 VDD VDD VSS VSS gf180mcu_fd_sc_mcu7t5v0__nand2_1
X_4771_ _7100_/Q _4784_/A2 _4772_/B VDD VDD VSS VSS gf180mcu_fd_sc_mcu7t5v0__nand2_1
X_7490_ _7490_/D _7490_/CLK _7490_/Q VDD VDD VSS VSS gf180mcu_fd_sc_mcu7t5v0__dffq_1
X_3722_ _3713_/Z _3733_/A2 _3723_/B VDD VDD VSS VSS gf180mcu_fd_sc_mcu7t5v0__nand2_1
X_6441_ _7665_/Q _6451_/A2 _6442_/B VDD VDD VSS VSS gf180mcu_fd_sc_mcu7t5v0__nand2_1
XTAP_TAPCELL_ROW_31_689 VDD VSS gf180mcu_fd_sc_mcu7t5v0__filltie
X_3653_ _3584_/Z _3602_/Z _3653_/Z VDD VDD VSS VSS gf180mcu_fd_sc_mcu7t5v0__xor2_1
X_6372_ _6372_/A1 _6373_/S _6372_/B _7652_/D VDD VDD VSS VSS gf180mcu_fd_sc_mcu7t5v0__oai21_1
X_5323_ _5344_/I0 _7470_/Q _5323_/S _7470_/D VDD VDD VSS VSS gf180mcu_fd_sc_mcu7t5v0__mux2_2
X_3584_ input64/Z input60/Z _3584_/Z VDD VDD VSS VSS gf180mcu_fd_sc_mcu7t5v0__xor2_1
X_5254_ _5303_/I0 _7401_/Q _5260_/S _7401_/D VDD VDD VSS VSS gf180mcu_fd_sc_mcu7t5v0__mux2_2
X_5185_ _5332_/I0 _7332_/Q _5190_/S _7332_/D VDD VDD VSS VSS gf180mcu_fd_sc_mcu7t5v0__mux2_2
X_4205_ _4238_/I0 _6818_/Q _5253_/S _6818_/D VDD VDD VSS VSS gf180mcu_fd_sc_mcu7t5v0__mux2_2
XTAP_TAPCELL_ROW_110_1799 VDD VSS gf180mcu_fd_sc_mcu7t5v0__filltie
XTAP_TAPCELL_ROW_3_304 VDD VSS gf180mcu_fd_sc_mcu7t5v0__filltie
X_4136_ _6796_/Q _5064_/A2 _4137_/B VDD VDD VSS VSS gf180mcu_fd_sc_mcu7t5v0__nand2_1
X_4067_ _6774_/Q _4756_/A2 _4068_/B VDD VDD VSS VSS gf180mcu_fd_sc_mcu7t5v0__nand2_1
XFILLER_25_912 VDD VDD VSS VSS gf180mcu_fd_sc_mcu7t5v0__fillcap_64
XFILLER_37_772 VDD VDD VSS VSS gf180mcu_fd_sc_mcu7t5v0__fillcap_64
X_7826_ _7826_/D _7827_/RN clkload8/I _7826_/Q VDD VDD VSS VSS gf180mcu_fd_sc_mcu7t5v0__dffrnq_1
XTAP_TAPCELL_ROW_61_1109 VDD VSS gf180mcu_fd_sc_mcu7t5v0__filltie
X_7757_ _7757_/D _7760_/RN _7765_/CLK _7757_/Q VDD VDD VSS VSS gf180mcu_fd_sc_mcu7t5v0__dffrnq_1
X_4969_ _7199_/Q _4980_/A2 _4970_/B VDD VDD VSS VSS gf180mcu_fd_sc_mcu7t5v0__nand2_1
X_7688_ _7688_/D _7690_/RN _7692_/CLK _7688_/Q VDD VDD VSS VSS gf180mcu_fd_sc_mcu7t5v0__dffrnq_1
XFILLER_20_661 VDD VDD VSS VSS gf180mcu_fd_sc_mcu7t5v0__fillcap_4
XTAP_TAPCELL_ROW_50_954 VDD VSS gf180mcu_fd_sc_mcu7t5v0__filltie
XTAP_TAPCELL_ROW_50_965 VDD VSS gf180mcu_fd_sc_mcu7t5v0__filltie
X_6708_ _7752_/Q _6716_/A2 _6714_/B1 _7753_/Q _6709_/I VDD VDD VSS VSS gf180mcu_fd_sc_mcu7t5v0__aoi22_1
X_6639_ _6654_/B _6639_/A2 _6638_/Z _7729_/D VDD VDD VSS VSS gf180mcu_fd_sc_mcu7t5v0__nor3_1
XFILLER_3_348 VDD VDD VSS VSS gf180mcu_fd_sc_mcu7t5v0__fill_2
XFILLER_79_628 VDD VDD VSS VSS gf180mcu_fd_sc_mcu7t5v0__fill_2
XPHY_EDGE_ROW_110_Right_110 VDD VSS gf180mcu_fd_sc_mcu7t5v0__endcap
XFILLER_59_352 VDD VDD VSS VSS gf180mcu_fd_sc_mcu7t5v0__fill_1
XFILLER_59_363 VDD VDD VSS VSS gf180mcu_fd_sc_mcu7t5v0__fill_2
Xfanout184 _6559_/A1 _6538_/A1 VDD VDD VSS VSS gf180mcu_fd_sc_mcu7t5v0__dlyd_1
XTAP_TAPCELL_ROW_87_1481 VDD VSS gf180mcu_fd_sc_mcu7t5v0__filltie
XTAP_TAPCELL_ROW_87_1470 VDD VSS gf180mcu_fd_sc_mcu7t5v0__filltie
XFILLER_74_399 VDD VDD VSS VSS gf180mcu_fd_sc_mcu7t5v0__fill_1
XFILLER_15_422 VDD VDD VSS VSS gf180mcu_fd_sc_mcu7t5v0__fill_2
XFILLER_27_282 VDD VDD VSS VSS gf180mcu_fd_sc_mcu7t5v0__fill_1
XPHY_EDGE_ROW_7_Left_126 VDD VSS gf180mcu_fd_sc_mcu7t5v0__endcap
XFILLER_7_632 VDD VDD VSS VSS gf180mcu_fd_sc_mcu7t5v0__fillcap_64
XFILLER_98_937 VDD VDD VSS VSS gf180mcu_fd_sc_mcu7t5v0__fillcap_8
Xload_slew579 _7710_/RN _7614_/RN VDD VDD VSS VSS gf180mcu_fd_sc_mcu7t5v0__buf_4
Xload_slew568 _7706_/RN _7708_/RN VDD VDD VSS VSS gf180mcu_fd_sc_mcu7t5v0__buf_4
X_6990_ _6990_/D _7248_/CLK _6990_/Q VDD VDD VSS VSS gf180mcu_fd_sc_mcu7t5v0__dffq_1
XFILLER_19_772 VDD VDD VSS VSS gf180mcu_fd_sc_mcu7t5v0__fillcap_64
X_5941_ _7698_/Q _6254_/B1 _5943_/A3 VDD VDD VSS VSS gf180mcu_fd_sc_mcu7t5v0__nand2_1
XFILLER_34_731 VDD VDD VSS VSS gf180mcu_fd_sc_mcu7t5v0__fillcap_4
XTAP_TAPCELL_ROW_36_759 VDD VSS gf180mcu_fd_sc_mcu7t5v0__filltie
XFILLER_46_591 VDD VDD VSS VSS gf180mcu_fd_sc_mcu7t5v0__fillcap_4
XFILLER_21_403 VDD VDD VSS VSS gf180mcu_fd_sc_mcu7t5v0__fill_2
X_5872_ _5872_/A1 _5872_/A2 _5873_/B VDD VDD VSS VSS gf180mcu_fd_sc_mcu7t5v0__or2_1
X_7611_ _7611_/D _7611_/RN _7668_/CLK _7611_/Q VDD VDD VSS VSS gf180mcu_fd_sc_mcu7t5v0__dffrnq_1
XTAP_TAPCELL_ROW_16_483 VDD VSS gf180mcu_fd_sc_mcu7t5v0__filltie
X_4823_ _7126_/Q _4826_/A2 _4824_/B VDD VDD VSS VSS gf180mcu_fd_sc_mcu7t5v0__nand2_1
X_4754_ _4824_/A1 _4756_/A2 _4754_/B _7091_/D VDD VDD VSS VSS gf180mcu_fd_sc_mcu7t5v0__oai21_1
X_7542_ _7542_/D _7703_/RN _7693_/CLK _7542_/Q VDD VDD VSS VSS gf180mcu_fd_sc_mcu7t5v0__dffrnq_1
X_7473_ _7473_/D _7490_/CLK _7473_/Q VDD VDD VSS VSS gf180mcu_fd_sc_mcu7t5v0__dffq_1
XFILLER_30_981 VDD VDD VSS VSS gf180mcu_fd_sc_mcu7t5v0__fill_1
X_3705_ _6315_/A1 _5813_/A2 _6247_/A2 VDD VDD VSS VSS gf180mcu_fd_sc_mcu7t5v0__nor2_1
X_4685_ _7057_/Q _4686_/A2 _4686_/B VDD VDD VSS VSS gf180mcu_fd_sc_mcu7t5v0__nand2_1
X_6424_ _7663_/Q _7529_/Q _6438_/C VDD VDD VSS VSS gf180mcu_fd_sc_mcu7t5v0__nand2_1
X_3636_ _3636_/A1 _3544_/Z _3636_/A3 _3636_/Z VDD VDD VSS VSS gf180mcu_fd_sc_mcu7t5v0__xor3_1
X_3567_ _7879_/I _7882_/I input76/Z _3567_/Z VDD VDD VSS VSS gf180mcu_fd_sc_mcu7t5v0__xor3_1
X_6355_ _7641_/Q input32/Z _7782_/D _7641_/D VDD VDD VSS VSS gf180mcu_fd_sc_mcu7t5v0__mux2_2
X_6286_ _6286_/A1 _6300_/A2 _6302_/B1 _6286_/B2 _7595_/D VDD VDD VSS VSS gf180mcu_fd_sc_mcu7t5v0__aoi22_1
XTAP_TAPCELL_ROW_112_1828 VDD VSS gf180mcu_fd_sc_mcu7t5v0__filltie
X_5306_ wire525/I _7453_/Q _5309_/S _7453_/D VDD VDD VSS VSS gf180mcu_fd_sc_mcu7t5v0__mux2_2
XTAP_TAPCELL_ROW_58_1071 VDD VSS gf180mcu_fd_sc_mcu7t5v0__filltie
X_3498_ _3505_/B _3498_/A2 _3499_/I VDD VDD VSS VSS gf180mcu_fd_sc_mcu7t5v0__nand2_1
X_5237_ _5244_/I0 _7384_/Q _5239_/S _7384_/D VDD VDD VSS VSS gf180mcu_fd_sc_mcu7t5v0__mux2_2
X_5168_ wire517/Z _7315_/Q _5169_/S _7315_/D VDD VDD VSS VSS gf180mcu_fd_sc_mcu7t5v0__mux2_2
X_5099_ _7264_/Q _5106_/A2 _5100_/B VDD VDD VSS VSS gf180mcu_fd_sc_mcu7t5v0__nand2_1
XFILLER_29_558 VDD VDD VSS VSS gf180mcu_fd_sc_mcu7t5v0__fill_2
X_4119_ _4125_/A1 _4980_/A2 _4119_/B _6790_/D VDD VDD VSS VSS gf180mcu_fd_sc_mcu7t5v0__oai21_1
XFILLER_44_517 VDD VDD VSS VSS gf180mcu_fd_sc_mcu7t5v0__fillcap_8
XFILLER_71_347 VDD VDD VSS VSS gf180mcu_fd_sc_mcu7t5v0__fill_2
X_7809_ _7809_/D _7811_/RN clkload9/I _7809_/Q VDD VDD VSS VSS gf180mcu_fd_sc_mcu7t5v0__dffrnq_1
XFILLER_24_285 VDD VDD VSS VSS gf180mcu_fd_sc_mcu7t5v0__fill_1
XFILLER_116_2 VDD VDD VSS VSS gf180mcu_fd_sc_mcu7t5v0__fill_1
XFILLER_106_563 VDD VDD VSS VSS gf180mcu_fd_sc_mcu7t5v0__fill_2
XFILLER_88_981 VDD VDD VSS VSS gf180mcu_fd_sc_mcu7t5v0__fill_1
XFILLER_0_852 VDD VDD VSS VSS gf180mcu_fd_sc_mcu7t5v0__fillcap_32
XTAP_TAPCELL_ROW_89_1510 VDD VSS gf180mcu_fd_sc_mcu7t5v0__filltie
XFILLER_63_848 VDD VDD VSS VSS gf180mcu_fd_sc_mcu7t5v0__fill_1
XFILLER_90_667 VDD VDD VSS VSS gf180mcu_fd_sc_mcu7t5v0__fill_1
XFILLER_16_731 VDD VDD VSS VSS gf180mcu_fd_sc_mcu7t5v0__fillcap_4
XFILLER_62_336 VDD VDD VSS VSS gf180mcu_fd_sc_mcu7t5v0__fill_2
XTAP_TAPCELL_ROW_33_718 VDD VSS gf180mcu_fd_sc_mcu7t5v0__filltie
XTAP_TAPCELL_ROW_13_442 VDD VSS gf180mcu_fd_sc_mcu7t5v0__filltie
XFILLER_12_981 VDD VDD VSS VSS gf180mcu_fd_sc_mcu7t5v0__fill_1
XFILLER_8_941 VDD VDD VSS VSS gf180mcu_fd_sc_mcu7t5v0__fillcap_4
X_4470_ _4540_/A1 _4476_/A2 _4470_/B _6949_/D VDD VDD VSS VSS gf180mcu_fd_sc_mcu7t5v0__oai21_1
X_3421_ _7547_/Q _3747_/B VDD VDD VSS VSS gf180mcu_fd_sc_mcu7t5v0__clkinv_1
XFILLER_98_723 VDD VDD VSS VSS gf180mcu_fd_sc_mcu7t5v0__fillcap_4
X_6140_ _7267_/Q _6198_/A2 _6140_/B1 _7225_/Q _6142_/A1 VDD VDD VSS VSS gf180mcu_fd_sc_mcu7t5v0__oai22_1
X_3352_ _7792_/Q _3860_/A1 VDD VDD VSS VSS gf180mcu_fd_sc_mcu7t5v0__clkinv_1
X_6071_ _6951_/Q _6229_/B1 _6074_/B1 _6958_/Q _6965_/Q _6222_/B1 _6072_/A2 VDD VDD
+ VSS VSS gf180mcu_fd_sc_mcu7t5v0__oai222_1
Xload_slew343 _6091_/A2 _5969_/B1 VDD VDD VSS VSS gf180mcu_fd_sc_mcu7t5v0__buf_2
Xload_slew332 _6212_/B1 _6167_/B1 VDD VDD VSS VSS gf180mcu_fd_sc_mcu7t5v0__clkbuf_4
XFILLER_100_728 VDD VDD VSS VSS gf180mcu_fd_sc_mcu7t5v0__fillcap_4
X_5022_ _5134_/A1 _5022_/A2 _5022_/B _7225_/D VDD VDD VSS VSS gf180mcu_fd_sc_mcu7t5v0__oai21_1
Xload_slew376 _5373_/Z _5612_/B1 VDD VDD VSS VSS gf180mcu_fd_sc_mcu7t5v0__buf_4
X_6973_ _6973_/D _7002_/CLK _6973_/Q VDD VDD VSS VSS gf180mcu_fd_sc_mcu7t5v0__dffq_1
XTAP_TAPCELL_ROW_109_1790 VDD VSS gf180mcu_fd_sc_mcu7t5v0__filltie
XFILLER_93_494 VDD VDD VSS VSS gf180mcu_fd_sc_mcu7t5v0__fill_1
XFILLER_0_70 VDD VDD VSS VSS gf180mcu_fd_sc_mcu7t5v0__fill_2
X_5924_ _7270_/Q _6201_/A2 _6134_/C _5926_/A1 VDD VDD VSS VSS gf180mcu_fd_sc_mcu7t5v0__oai21_1
X_5855_ _7059_/Q _6153_/A2 _6154_/A2 _7052_/Q _7045_/Q wire313/Z _5857_/A1 VDD VDD
+ VSS VSS gf180mcu_fd_sc_mcu7t5v0__oai222_1
XFILLER_34_594 VDD VDD VSS VSS gf180mcu_fd_sc_mcu7t5v0__fill_1
X_4806_ _4918_/A1 _4812_/A2 _4806_/B _7117_/D VDD VDD VSS VSS gf180mcu_fd_sc_mcu7t5v0__oai21_1
X_5786_ _7184_/Q _6055_/A2 _6177_/B1 _7177_/Q _7170_/Q _6241_/B1 _5787_/I VDD VDD
+ VSS VSS gf180mcu_fd_sc_mcu7t5v0__oai222_1
X_7525_ _7525_/D _7695_/RN _7671_/CLK _7525_/Q VDD VDD VSS VSS gf180mcu_fd_sc_mcu7t5v0__dffrnq_1
X_4737_ _7083_/Q _4742_/A2 _4738_/B VDD VDD VSS VSS gf180mcu_fd_sc_mcu7t5v0__nand2_1
X_4668_ _4752_/A1 _4672_/A2 _4668_/B _7048_/D VDD VDD VSS VSS gf180mcu_fd_sc_mcu7t5v0__oai21_1
X_7456_ _7456_/D _7456_/CLK _7456_/Q VDD VDD VSS VSS gf180mcu_fd_sc_mcu7t5v0__dffq_1
X_6407_ _7660_/Q _7526_/Q _6407_/A3 _6407_/Z VDD VDD VSS VSS gf180mcu_fd_sc_mcu7t5v0__xor3_1
X_3619_ _3614_/Z _3617_/Z _3618_/Z _3619_/Z VDD VDD VSS VSS gf180mcu_fd_sc_mcu7t5v0__xor3_1
X_4599_ _7014_/Q _4602_/A2 _4600_/B VDD VDD VSS VSS gf180mcu_fd_sc_mcu7t5v0__nand2_1
X_7387_ _7387_/D _7736_/CLK _7387_/Q VDD VDD VSS VSS gf180mcu_fd_sc_mcu7t5v0__dffq_1
XFILLER_0_104 VDD VDD VSS VSS gf180mcu_fd_sc_mcu7t5v0__fill_2
X_6338_ _7629_/Q input45/Z _6338_/S _7629_/D VDD VDD VSS VSS gf180mcu_fd_sc_mcu7t5v0__mux2_2
X_6269_ _6269_/A1 _6284_/A2 _6284_/B1 _6269_/B2 _7587_/D VDD VDD VSS VSS gf180mcu_fd_sc_mcu7t5v0__aoi22_1
XFILLER_89_789 VDD VDD VSS VSS gf180mcu_fd_sc_mcu7t5v0__fillcap_4
XFILLER_85_973 VDD VDD VSS VSS gf180mcu_fd_sc_mcu7t5v0__fillcap_4
XFILLER_72_601 VDD VDD VSS VSS gf180mcu_fd_sc_mcu7t5v0__fill_2
XPHY_EDGE_ROW_88_Left_207 VDD VSS gf180mcu_fd_sc_mcu7t5v0__endcap
XFILLER_44_325 VDD VDD VSS VSS gf180mcu_fd_sc_mcu7t5v0__fill_1
XTAP_TAPCELL_ROW_84_1440 VDD VSS gf180mcu_fd_sc_mcu7t5v0__filltie
XFILLER_60_829 VDD VDD VSS VSS gf180mcu_fd_sc_mcu7t5v0__fillcap_4
XFILLER_12_244 VDD VDD VSS VSS gf180mcu_fd_sc_mcu7t5v0__fill_1
XTAP_TAPCELL_ROW_10_401 VDD VSS gf180mcu_fd_sc_mcu7t5v0__filltie
XFILLER_40_597 VDD VDD VSS VSS gf180mcu_fd_sc_mcu7t5v0__fillcap_64
XPHY_EDGE_ROW_97_Left_216 VDD VSS gf180mcu_fd_sc_mcu7t5v0__endcap
XTAP_TAPCELL_ROW_95_1591 VDD VSS gf180mcu_fd_sc_mcu7t5v0__filltie
XFILLER_68_929 VDD VDD VSS VSS gf180mcu_fd_sc_mcu7t5v0__fillcap_16
XFILLER_95_748 VDD VDD VSS VSS gf180mcu_fd_sc_mcu7t5v0__fill_2
XFILLER_0_682 VDD VDD VSS VSS gf180mcu_fd_sc_mcu7t5v0__fillcap_32
XFILLER_94_247 VDD VDD VSS VSS gf180mcu_fd_sc_mcu7t5v0__fill_2
XPHY_EDGE_ROW_13_Right_13 VDD VSS gf180mcu_fd_sc_mcu7t5v0__endcap
XFILLER_47_152 VDD VDD VSS VSS gf180mcu_fd_sc_mcu7t5v0__fill_2
XTAP_TAPCELL_ROW_18_512 VDD VSS gf180mcu_fd_sc_mcu7t5v0__filltie
X_3970_ _6744_/Q _4336_/A2 _3971_/B VDD VDD VSS VSS gf180mcu_fd_sc_mcu7t5v0__nand2_1
XFILLER_16_594 VDD VDD VSS VSS gf180mcu_fd_sc_mcu7t5v0__fill_1
XTAP_TAPCELL_ROW_46_898 VDD VSS gf180mcu_fd_sc_mcu7t5v0__filltie
X_5640_ _7523_/Q input49/Z _5642_/S _7523_/D VDD VDD VSS VSS gf180mcu_fd_sc_mcu7t5v0__mux2_2
XPHY_EDGE_ROW_22_Right_22 VDD VSS gf180mcu_fd_sc_mcu7t5v0__endcap
X_5571_ _7393_/Q _5604_/A2 _6634_/B _5573_/A1 VDD VDD VSS VSS gf180mcu_fd_sc_mcu7t5v0__oai21_1
X_4522_ _5124_/A1 _4532_/A2 _4522_/B _6975_/D VDD VDD VSS VSS gf180mcu_fd_sc_mcu7t5v0__oai21_1
X_7310_ _7310_/D _7489_/CLK _7310_/Q VDD VDD VSS VSS gf180mcu_fd_sc_mcu7t5v0__dffq_1
X_4453_ _6941_/Q _4462_/A2 _4454_/B VDD VDD VSS VSS gf180mcu_fd_sc_mcu7t5v0__nand2_1
X_7241_ _7241_/D _7247_/CLK _7241_/Q VDD VDD VSS VSS gf180mcu_fd_sc_mcu7t5v0__dffq_1
Xwire190 wire190/I _6246_/C VDD VDD VSS VSS gf180mcu_fd_sc_mcu7t5v0__buf_2
X_3404_ _7625_/Q _6333_/A1 VDD VDD VSS VSS gf180mcu_fd_sc_mcu7t5v0__clkinv_1
XFILLER_113_842 VDD VDD VSS VSS gf180mcu_fd_sc_mcu7t5v0__fillcap_64
X_4384_ _5014_/A1 _4392_/A2 _4384_/B _6906_/D VDD VDD VSS VSS gf180mcu_fd_sc_mcu7t5v0__oai21_1
XTAP_TAPCELL_ROW_55_1030 VDD VSS gf180mcu_fd_sc_mcu7t5v0__filltie
X_7172_ _7172_/D _7189_/CLK _7172_/Q VDD VDD VSS VSS gf180mcu_fd_sc_mcu7t5v0__dffq_1
X_6123_ _6122_/C _6123_/A2 _6123_/B _6124_/I1 VDD VDD VSS VSS gf180mcu_fd_sc_mcu7t5v0__oai21_1
XPHY_EDGE_ROW_31_Right_31 VDD VSS gf180mcu_fd_sc_mcu7t5v0__endcap
X_6054_ _7160_/Q _6055_/A2 _6241_/A2 _7132_/Q _6238_/B _6058_/A2 VDD VDD VSS VSS gf180mcu_fd_sc_mcu7t5v0__oai221_1
X_5005_ _7217_/Q _5008_/A2 _5006_/B VDD VDD VSS VSS gf180mcu_fd_sc_mcu7t5v0__nand2_1
Xload_slew195 _6326_/A2 _6338_/S VDD VDD VSS VSS gf180mcu_fd_sc_mcu7t5v0__buf_2
XFILLER_67_973 VDD VDD VSS VSS gf180mcu_fd_sc_mcu7t5v0__fillcap_4
XFILLER_54_634 VDD VDD VSS VSS gf180mcu_fd_sc_mcu7t5v0__fill_1
X_6956_ _6956_/D _7687_/CLK _6956_/Q VDD VDD VSS VSS gf180mcu_fd_sc_mcu7t5v0__dffq_1
XFILLER_42_807 VDD VDD VSS VSS gf180mcu_fd_sc_mcu7t5v0__fillcap_64
XFILLER_54_667 VDD VDD VSS VSS gf180mcu_fd_sc_mcu7t5v0__fill_2
X_5907_ _7186_/Q _6055_/A2 _6177_/B1 _7179_/Q _7165_/Q _6177_/C2 _5908_/A2 VDD VDD
+ VSS VSS gf180mcu_fd_sc_mcu7t5v0__oai222_1
XTAP_TAPCELL_ROW_66_1181 VDD VSS gf180mcu_fd_sc_mcu7t5v0__filltie
X_6887_ _6887_/D _7148_/CLK _6887_/Q VDD VDD VSS VSS gf180mcu_fd_sc_mcu7t5v0__dffq_1
X_5838_ _6968_/Q _6073_/A2 _5969_/B1 _6961_/Q _6162_/C _5839_/A2 VDD VDD VSS VSS gf180mcu_fd_sc_mcu7t5v0__oai221_1
XPHY_EDGE_ROW_40_Right_40 VDD VSS gf180mcu_fd_sc_mcu7t5v0__endcap
X_5769_ _7261_/Q _6225_/A2 _6212_/B1 _7142_/Q _5771_/A1 VDD VDD VSS VSS gf180mcu_fd_sc_mcu7t5v0__oai22_1
XFILLER_10_737 VDD VDD VSS VSS gf180mcu_fd_sc_mcu7t5v0__fillcap_64
XFILLER_22_597 VDD VDD VSS VSS gf180mcu_fd_sc_mcu7t5v0__fillcap_64
X_7508_ _7508_/D _7810_/RN _7765_/CLK _7508_/Q VDD VDD VSS VSS gf180mcu_fd_sc_mcu7t5v0__dffsnq_1
X_7439_ _7439_/D _7482_/CLK _7439_/Q VDD VDD VSS VSS gf180mcu_fd_sc_mcu7t5v0__dffq_1
XFILLER_2_947 VDD VDD VSS VSS gf180mcu_fd_sc_mcu7t5v0__fillcap_32
XFILLER_49_417 VDD VDD VSS VSS gf180mcu_fd_sc_mcu7t5v0__fill_2
XFILLER_72_442 VDD VDD VSS VSS gf180mcu_fd_sc_mcu7t5v0__fill_1
XFILLER_32_317 VDD VDD VSS VSS gf180mcu_fd_sc_mcu7t5v0__fill_2
XFILLER_44_177 VDD VDD VSS VSS gf180mcu_fd_sc_mcu7t5v0__fill_1
XFILLER_13_542 VDD VDD VSS VSS gf180mcu_fd_sc_mcu7t5v0__fillcap_16
XTAP_TAPCELL_ROW_43_857 VDD VSS gf180mcu_fd_sc_mcu7t5v0__filltie
XFILLER_9_557 VDD VDD VSS VSS gf180mcu_fd_sc_mcu7t5v0__fill_2
XTAP_TAPCELL_ROW_23_581 VDD VSS gf180mcu_fd_sc_mcu7t5v0__filltie
XTAP_TAPCELL_ROW_97_1620 VDD VSS gf180mcu_fd_sc_mcu7t5v0__filltie
XFILLER_24_807 VDD VDD VSS VSS gf180mcu_fd_sc_mcu7t5v0__fillcap_64
X_6810_ _6810_/D _7378_/CLK _6810_/Q VDD VDD VSS VSS gf180mcu_fd_sc_mcu7t5v0__dffq_1
XFILLER_36_667 VDD VDD VSS VSS gf180mcu_fd_sc_mcu7t5v0__fillcap_64
X_7790_ _7790_/D _7785_/RN _7790_/CLK _7790_/Q VDD VDD VSS VSS gf180mcu_fd_sc_mcu7t5v0__dffsnq_1
X_3953_ wire248/I _4280_/A2 _3953_/B _6740_/D VDD VDD VSS VSS gf180mcu_fd_sc_mcu7t5v0__oai21_1
X_6741_ _6741_/D _6882_/CLK _6741_/Q VDD VDD VSS VSS gf180mcu_fd_sc_mcu7t5v0__dffq_1
X_6672_ _7791_/Q _6694_/A1 _6672_/Z VDD VDD VSS VSS gf180mcu_fd_sc_mcu7t5v0__and2_1
X_3884_ _7650_/Q _3873_/Z _6362_/B _3885_/A2 VDD VDD VSS VSS gf180mcu_fd_sc_mcu7t5v0__oai21_1
X_5623_ _5399_/Z _5431_/Z _5622_/Z _5623_/Z VDD VDD VSS VSS gf180mcu_fd_sc_mcu7t5v0__xor3_1
X_5554_ _5554_/I0 _5554_/I1 _5584_/S _5554_/Z VDD VDD VSS VSS gf180mcu_fd_sc_mcu7t5v0__mux2_2
XFILLER_118_978 VDD VDD VSS VSS gf180mcu_fd_sc_mcu7t5v0__fillcap_4
X_4505_ _6967_/Q _4518_/A2 _4506_/B VDD VDD VSS VSS gf180mcu_fd_sc_mcu7t5v0__nand2_1
X_5485_ _5485_/A1 _5485_/A2 _5492_/A3 VDD VDD VSS VSS gf180mcu_fd_sc_mcu7t5v0__nor2_1
X_4436_ _5080_/A1 _4448_/A2 _4436_/B _6932_/D VDD VDD VSS VSS gf180mcu_fd_sc_mcu7t5v0__oai21_1
X_7224_ _7224_/D _7259_/CLK _7224_/Q VDD VDD VSS VSS gf180mcu_fd_sc_mcu7t5v0__dffq_1
X_4367_ _6898_/Q _4378_/A2 _4368_/B VDD VDD VSS VSS gf180mcu_fd_sc_mcu7t5v0__nand2_1
Xuart_609 racl_error_o[13] VDD VDD VSS VSS gf180mcu_fd_sc_mcu7t5v0__tiel
Xfanout514 wire517/I _5245_/I0 VDD VDD VSS VSS gf180mcu_fd_sc_mcu7t5v0__dlyd_1
X_7155_ _7155_/D _7253_/CLK _7155_/Q VDD VDD VSS VSS gf180mcu_fd_sc_mcu7t5v0__dffq_1
XFILLER_101_834 VDD VDD VSS VSS gf180mcu_fd_sc_mcu7t5v0__fillcap_4
XFILLER_101_812 VDD VDD VSS VSS gf180mcu_fd_sc_mcu7t5v0__fill_1
X_6106_ _7189_/Q _6132_/A2 _6242_/C _6108_/A1 VDD VDD VSS VSS gf180mcu_fd_sc_mcu7t5v0__oai21_1
X_4298_ _5012_/A1 _4308_/A2 _4298_/B _6863_/D VDD VDD VSS VSS gf180mcu_fd_sc_mcu7t5v0__oai21_1
X_7086_ _7086_/D _7118_/CLK _7086_/Q VDD VDD VSS VSS gf180mcu_fd_sc_mcu7t5v0__dffq_1
Xfanout558 _7791_/RN _7742_/RN VDD VDD VSS VSS gf180mcu_fd_sc_mcu7t5v0__dlyd_1
XFILLER_58_247 VDD VDD VSS VSS gf180mcu_fd_sc_mcu7t5v0__fill_1
Xfanout569 _7693_/RN _7705_/RN VDD VDD VSS VSS gf180mcu_fd_sc_mcu7t5v0__dlyd_1
X_6037_ _6037_/A1 _6037_/A2 _6047_/A1 VDD VDD VSS VSS gf180mcu_fd_sc_mcu7t5v0__nor2_1
XFILLER_67_781 VDD VDD VSS VSS gf180mcu_fd_sc_mcu7t5v0__fill_1
XTAP_TAPCELL_ROW_68_1210 VDD VSS gf180mcu_fd_sc_mcu7t5v0__filltie
XFILLER_82_773 VDD VDD VSS VSS gf180mcu_fd_sc_mcu7t5v0__fill_1
XTAP_TAPCELL_ROW_1_276 VDD VSS gf180mcu_fd_sc_mcu7t5v0__filltie
XFILLER_55_976 VDD VDD VSS VSS gf180mcu_fd_sc_mcu7t5v0__fillcap_4
XFILLER_26_177 VDD VDD VSS VSS gf180mcu_fd_sc_mcu7t5v0__fill_2
X_6939_ _6939_/D _6939_/CLK _6939_/Q VDD VDD VSS VSS gf180mcu_fd_sc_mcu7t5v0__dffq_1
XFILLER_70_979 VDD VDD VSS VSS gf180mcu_fd_sc_mcu7t5v0__fill_2
XTAP_TAPCELL_ROW_40_816 VDD VSS gf180mcu_fd_sc_mcu7t5v0__filltie
XFILLER_109_912 VDD VDD VSS VSS gf180mcu_fd_sc_mcu7t5v0__fillcap_64
XTAP_TAPCELL_ROW_20_540 VDD VSS gf180mcu_fd_sc_mcu7t5v0__filltie
XTAP_TAPCELL_ROW_79_1361 VDD VSS gf180mcu_fd_sc_mcu7t5v0__filltie
XFILLER_9_2 VDD VDD VSS VSS gf180mcu_fd_sc_mcu7t5v0__fill_2
XTAP_TAPCELL_ROW_92_1550 VDD VSS gf180mcu_fd_sc_mcu7t5v0__filltie
XTAP_TAPCELL_ROW_9_387 VDD VSS gf180mcu_fd_sc_mcu7t5v0__filltie
XTAP_TAPCELL_ROW_48_927 VDD VSS gf180mcu_fd_sc_mcu7t5v0__filltie
XFILLER_73_740 VDD VDD VSS VSS gf180mcu_fd_sc_mcu7t5v0__fill_1
XFILLER_18_667 VDD VDD VSS VSS gf180mcu_fd_sc_mcu7t5v0__fillcap_64
XTAP_TAPCELL_ROW_28_651 VDD VSS gf180mcu_fd_sc_mcu7t5v0__filltie
XFILLER_61_902 VDD VDD VSS VSS gf180mcu_fd_sc_mcu7t5v0__fillcap_8
Xclkbuf_leaf_1_clk_i clkload0/I clkload8/I VDD VDD VSS VSS gf180mcu_fd_sc_mcu7t5v0__clkbuf_8
XFILLER_33_626 VDD VDD VSS VSS gf180mcu_fd_sc_mcu7t5v0__fillcap_4
Xoutput128 _6312_/A1 tl_o[12] VDD VDD VSS VSS gf180mcu_fd_sc_mcu7t5v0__dlyd_1
Xoutput139 _7579_/Q tl_o[23] VDD VDD VSS VSS gf180mcu_fd_sc_mcu7t5v0__dlyd_1
X_5270_ _5354_/I0 _7417_/Q _5274_/S _7417_/D VDD VDD VSS VSS gf180mcu_fd_sc_mcu7t5v0__mux2_2
Xoutput117 _7806_/Q intr_tx_done_o VDD VDD VSS VSS gf180mcu_fd_sc_mcu7t5v0__dlyd_1
X_4221_ _4221_/A1 _4221_/A2 _4226_/A3 _6657_/A2 VDD VDD VSS VSS gf180mcu_fd_sc_mcu7t5v0__nor3_1
X_4152_ wire248/I _5134_/A2 _4152_/B _6801_/D VDD VDD VSS VSS gf180mcu_fd_sc_mcu7t5v0__oai21_1
XFILLER_110_664 VDD VDD VSS VSS gf180mcu_fd_sc_mcu7t5v0__fill_1
X_4083_ _4125_/A1 _4826_/A2 _4083_/B _6779_/D VDD VDD VSS VSS gf180mcu_fd_sc_mcu7t5v0__oai21_1
XFILLER_37_976 VDD VDD VSS VSS gf180mcu_fd_sc_mcu7t5v0__fillcap_4
XTAP_TAPCELL_ROW_104_1719 VDD VSS gf180mcu_fd_sc_mcu7t5v0__filltie
XTAP_TAPCELL_ROW_104_1708 VDD VSS gf180mcu_fd_sc_mcu7t5v0__filltie
X_7773_ _7773_/D _7825_/RN clkload7/I _7773_/Q VDD VDD VSS VSS gf180mcu_fd_sc_mcu7t5v0__dffrnq_1
XFILLER_52_979 VDD VDD VSS VSS gf180mcu_fd_sc_mcu7t5v0__fill_2
X_4985_ _7207_/Q _4994_/A2 _4986_/B VDD VDD VSS VSS gf180mcu_fd_sc_mcu7t5v0__nand2_1
X_6724_ _7761_/Q _6732_/A1 _6724_/B _6725_/A2 VDD VDD VSS VSS gf180mcu_fd_sc_mcu7t5v0__oai21_1
X_3936_ _3928_/I _5696_/A2 _3937_/I VDD VDD VSS VSS gf180mcu_fd_sc_mcu7t5v0__or2_1
XTAP_TAPCELL_ROW_63_1140 VDD VSS gf180mcu_fd_sc_mcu7t5v0__filltie
X_6655_ _7735_/Q _6654_/C _6656_/A3 VDD VDD VSS VSS gf180mcu_fd_sc_mcu7t5v0__nor2_1
X_3867_ _7538_/Q _7752_/Q _3867_/B wire231/I VDD VDD VSS VSS gf180mcu_fd_sc_mcu7t5v0__aoi21_2
X_5606_ _6827_/Q wire428/Z _5606_/B1 _6813_/Q _5608_/A2 VDD VDD VSS VSS gf180mcu_fd_sc_mcu7t5v0__oai22_1
X_3798_ _3798_/I _3849_/B VDD VDD VSS VSS gf180mcu_fd_sc_mcu7t5v0__clkinv_1
X_6586_ _6621_/B _6605_/A1 _6603_/A2 VDD VDD VSS VSS gf180mcu_fd_sc_mcu7t5v0__nor2_1
XFILLER_118_764 VDD VDD VSS VSS gf180mcu_fd_sc_mcu7t5v0__fillcap_16
X_5537_ _7301_/Q _5579_/A2 _5610_/C2 _7504_/Q _5538_/A3 VDD VDD VSS VSS gf180mcu_fd_sc_mcu7t5v0__oai22_1
X_5468_ _7369_/Q _5507_/B1 _5511_/C2 _7376_/Q _7390_/Q wire428/I _5469_/A2 VDD VDD
+ VSS VSS gf180mcu_fd_sc_mcu7t5v0__oai222_1
X_7207_ _7207_/D _7216_/CLK _7207_/Q VDD VDD VSS VSS gf180mcu_fd_sc_mcu7t5v0__dffq_1
XFILLER_114_981 VDD VDD VSS VSS gf180mcu_fd_sc_mcu7t5v0__fill_1
X_4419_ _6924_/Q _4420_/A2 _4420_/B VDD VDD VSS VSS gf180mcu_fd_sc_mcu7t5v0__nand2_1
Xfanout300 _6228_/B1 _6197_/A2 VDD VDD VSS VSS gf180mcu_fd_sc_mcu7t5v0__dlyd_1
XTAP_TAPCELL_ROW_74_1291 VDD VSS gf180mcu_fd_sc_mcu7t5v0__filltie
X_5399_ _5399_/I0 _5399_/I1 _5616_/S _5399_/Z VDD VDD VSS VSS gf180mcu_fd_sc_mcu7t5v0__mux2_2
Xfanout333 _6227_/A2 _6151_/A2 VDD VDD VSS VSS gf180mcu_fd_sc_mcu7t5v0__dlyd_1
Xfanout366 _5603_/A2 _5511_/C2 VDD VDD VSS VSS gf180mcu_fd_sc_mcu7t5v0__dlyd_1
XTAP_TAPCELL_ROW_6_346 VDD VSS gf180mcu_fd_sc_mcu7t5v0__filltie
X_7138_ _7138_/D _7248_/CLK _7138_/Q VDD VDD VSS VSS gf180mcu_fd_sc_mcu7t5v0__dffq_1
XFILLER_87_876 VDD VDD VSS VSS gf180mcu_fd_sc_mcu7t5v0__fillcap_4
X_7069_ _7069_/D _7070_/CLK _7069_/Q VDD VDD VSS VSS gf180mcu_fd_sc_mcu7t5v0__dffq_1
Xfanout377 _5613_/A2 _5412_/B1 VDD VDD VSS VSS gf180mcu_fd_sc_mcu7t5v0__dlyd_1
XFILLER_15_626 VDD VDD VSS VSS gf180mcu_fd_sc_mcu7t5v0__fillcap_4
XFILLER_36_88 VDD VDD VSS VSS gf180mcu_fd_sc_mcu7t5v0__fill_2
XTAP_TAPCELL_ROW_25_610 VDD VSS gf180mcu_fd_sc_mcu7t5v0__filltie
XFILLER_27_497 VDD VDD VSS VSS gf180mcu_fd_sc_mcu7t5v0__fill_2
XTAP_TAPCELL_ROW_53_996 VDD VSS gf180mcu_fd_sc_mcu7t5v0__filltie
Xinput19 tl_i[113] _3378_/I VDD VDD VSS VSS gf180mcu_fd_sc_mcu7t5v0__dlyd_1
XFILLER_109_742 VDD VDD VSS VSS gf180mcu_fd_sc_mcu7t5v0__fill_2
XFILLER_7_836 VDD VDD VSS VSS gf180mcu_fd_sc_mcu7t5v0__fillcap_4
XFILLER_109_764 VDD VDD VSS VSS gf180mcu_fd_sc_mcu7t5v0__fillcap_4
XPHY_EDGE_ROW_70_Left_189 VDD VSS gf180mcu_fd_sc_mcu7t5v0__endcap
XFILLER_28_8 VDD VDD VSS VSS gf180mcu_fd_sc_mcu7t5v0__fill_1
XFILLER_93_824 VDD VDD VSS VSS gf180mcu_fd_sc_mcu7t5v0__fillcap_4
XFILLER_19_976 VDD VDD VSS VSS gf180mcu_fd_sc_mcu7t5v0__fillcap_4
XFILLER_34_979 VDD VDD VSS VSS gf180mcu_fd_sc_mcu7t5v0__fill_2
XFILLER_60_264 VDD VDD VSS VSS gf180mcu_fd_sc_mcu7t5v0__fill_1
X_4770_ _5008_/A1 _4770_/A2 _4770_/B _7099_/D VDD VDD VSS VSS gf180mcu_fd_sc_mcu7t5v0__oai21_1
X_3721_ _6654_/A1 _5549_/C _3721_/B _3733_/A2 VDD VDD VSS VSS gf180mcu_fd_sc_mcu7t5v0__oai21_1
X_6440_ _6432_/Z _6439_/B _6440_/A3 _6440_/Z VDD VDD VSS VSS gf180mcu_fd_sc_mcu7t5v0__and3_1
X_3652_ _3605_/Z _3612_/Z _3619_/Z _3663_/A2 _3658_/A1 VDD VDD VSS VSS gf180mcu_fd_sc_mcu7t5v0__oai22_1
X_6371_ input31/Z _6373_/S _6372_/B VDD VDD VSS VSS gf180mcu_fd_sc_mcu7t5v0__nand2_1
X_3583_ input62/Z _3581_/Z _3582_/Z _3583_/Z VDD VDD VSS VSS gf180mcu_fd_sc_mcu7t5v0__xor3_1
X_5322_ _5343_/I0 _7469_/Q _5323_/S _7469_/D VDD VDD VSS VSS gf180mcu_fd_sc_mcu7t5v0__mux2_2
X_5253_ _5309_/I0 _7400_/Q _5253_/S _7400_/D VDD VDD VSS VSS gf180mcu_fd_sc_mcu7t5v0__mux2_2
XFILLER_87_139 VDD VDD VSS VSS gf180mcu_fd_sc_mcu7t5v0__fill_1
X_4204_ _4235_/A1 _4210_/A2 _5253_/S VDD VDD VSS VSS gf180mcu_fd_sc_mcu7t5v0__nand2_1
X_5184_ _6353_/I0 _7331_/Q _5190_/S _7331_/D VDD VDD VSS VSS gf180mcu_fd_sc_mcu7t5v0__mux2_2
XTAP_TAPCELL_ROW_3_305 VDD VSS gf180mcu_fd_sc_mcu7t5v0__filltie
X_4135_ _4141_/A2 _4135_/A2 _5064_/A2 VDD VDD VSS VSS gf180mcu_fd_sc_mcu7t5v0__nand2_1
XFILLER_69_898 VDD VDD VSS VSS gf180mcu_fd_sc_mcu7t5v0__fill_1
XFILLER_113_38 VDD VDD VSS VSS gf180mcu_fd_sc_mcu7t5v0__fill_1
XFILLER_95_194 VDD VDD VSS VSS gf180mcu_fd_sc_mcu7t5v0__fill_1
XFILLER_84_879 VDD VDD VSS VSS gf180mcu_fd_sc_mcu7t5v0__fill_1
X_4066_ _4120_/A1 _4081_/A2 _4756_/A2 VDD VDD VSS VSS gf180mcu_fd_sc_mcu7t5v0__nand2_1
XFILLER_36_261 VDD VDD VSS VSS gf180mcu_fd_sc_mcu7t5v0__fill_2
X_7825_ _7825_/D _7825_/RN clkload8/I _7825_/Q VDD VDD VSS VSS gf180mcu_fd_sc_mcu7t5v0__dffrnq_1
X_7756_ _7756_/D wire565/Z _7792_/CLK _7756_/Q VDD VDD VSS VSS gf180mcu_fd_sc_mcu7t5v0__dffrnq_1
X_4968_ _4996_/A1 _4980_/A2 _4968_/B _7198_/D VDD VDD VSS VSS gf180mcu_fd_sc_mcu7t5v0__oai21_1
X_3919_ _7574_/Q _7575_/Q _7578_/Q _3919_/Z VDD VDD VSS VSS gf180mcu_fd_sc_mcu7t5v0__xor3_1
X_7687_ _7687_/D _7690_/RN _7687_/CLK _7687_/Q VDD VDD VSS VSS gf180mcu_fd_sc_mcu7t5v0__dffrnq_1
XTAP_TAPCELL_ROW_50_955 VDD VSS gf180mcu_fd_sc_mcu7t5v0__filltie
X_4899_ _7164_/Q _4910_/A2 _4900_/B VDD VDD VSS VSS gf180mcu_fd_sc_mcu7t5v0__nand2_1
X_6707_ _6707_/I _7751_/D VDD VDD VSS VSS gf180mcu_fd_sc_mcu7t5v0__clkinv_1
X_6638_ _5493_/S _6635_/Z _6638_/Z VDD VDD VSS VSS gf180mcu_fd_sc_mcu7t5v0__and2_1
XFILLER_106_734 VDD VDD VSS VSS gf180mcu_fd_sc_mcu7t5v0__fill_1
XTAP_TAPCELL_ROW_76_1320 VDD VSS gf180mcu_fd_sc_mcu7t5v0__filltie
X_6569_ _7704_/Q _7703_/Q _6569_/S _7704_/D VDD VDD VSS VSS gf180mcu_fd_sc_mcu7t5v0__mux2_2
Xfanout185 _4138_/ZN _6621_/C VDD VDD VSS VSS gf180mcu_fd_sc_mcu7t5v0__dlyd_1
XFILLER_47_559 VDD VDD VSS VSS gf180mcu_fd_sc_mcu7t5v0__fill_1
XTAP_TAPCELL_ROW_87_1471 VDD VSS gf180mcu_fd_sc_mcu7t5v0__filltie
XTAP_TAPCELL_ROW_87_1482 VDD VSS gf180mcu_fd_sc_mcu7t5v0__filltie
XTAP_TAPCELL_ROW_38_790 VDD VSS gf180mcu_fd_sc_mcu7t5v0__filltie
XFILLER_16_979 VDD VDD VSS VSS gf180mcu_fd_sc_mcu7t5v0__fill_2
Xclkbuf_leaf_81_clk_i clkbuf_3_1__f_clk_i/Z _7504_/CLK VDD VDD VSS VSS gf180mcu_fd_sc_mcu7t5v0__clkbuf_8
XPHY_EDGE_ROW_69_Right_69 VDD VSS gf180mcu_fd_sc_mcu7t5v0__endcap
XFILLER_15_489 VDD VDD VSS VSS gf180mcu_fd_sc_mcu7t5v0__fill_1
XFILLER_98_905 VDD VDD VSS VSS gf180mcu_fd_sc_mcu7t5v0__fillcap_32
XPHY_EDGE_ROW_78_Right_78 VDD VSS gf180mcu_fd_sc_mcu7t5v0__endcap
XFILLER_112_737 VDD VDD VSS VSS gf180mcu_fd_sc_mcu7t5v0__fillcap_4
Xload_slew536 _5352_/I0 _5345_/I0 VDD VDD VSS VSS gf180mcu_fd_sc_mcu7t5v0__buf_3
XFILLER_2_382 VDD VDD VSS VSS gf180mcu_fd_sc_mcu7t5v0__fill_2
Xload_slew547 fanout546/Z _7827_/RN VDD VDD VSS VSS gf180mcu_fd_sc_mcu7t5v0__clkbuf_4
XPHY_EDGE_ROW_108_Left_227 VDD VSS gf180mcu_fd_sc_mcu7t5v0__endcap
Xclkbuf_leaf_34_clk_i clkload5/I _7683_/CLK VDD VDD VSS VSS gf180mcu_fd_sc_mcu7t5v0__clkbuf_8
X_5940_ _7545_/Q _6247_/A2 _6256_/A2 _7537_/Q _5691_/I _7567_/Q _5943_/A2 VDD VDD
+ VSS VSS gf180mcu_fd_sc_mcu7t5v0__aoi222_1
XPHY_EDGE_ROW_87_Right_87 VDD VSS gf180mcu_fd_sc_mcu7t5v0__endcap
X_7610_ _7610_/D _7611_/RN _7667_/CLK _7610_/Q VDD VDD VSS VSS gf180mcu_fd_sc_mcu7t5v0__dffrnq_1
Xclkbuf_leaf_49_clk_i clkload6/I _7064_/CLK VDD VDD VSS VSS gf180mcu_fd_sc_mcu7t5v0__clkbuf_8
X_5871_ _7192_/Q _6098_/A2 _6232_/A2 _7199_/Q _7213_/Q _6097_/A2 _5872_/A2 VDD VDD
+ VSS VSS gf180mcu_fd_sc_mcu7t5v0__oai222_1
XFILLER_61_562 VDD VDD VSS VSS gf180mcu_fd_sc_mcu7t5v0__fillcap_4
XTAP_TAPCELL_ROW_16_484 VDD VSS gf180mcu_fd_sc_mcu7t5v0__filltie
XFILLER_33_264 VDD VDD VSS VSS gf180mcu_fd_sc_mcu7t5v0__fill_1
X_4822_ _4822_/A1 _4826_/A2 _4822_/B _7125_/D VDD VDD VSS VSS gf180mcu_fd_sc_mcu7t5v0__oai21_1
XPHY_EDGE_ROW_117_Left_236 VDD VSS gf180mcu_fd_sc_mcu7t5v0__endcap
X_4753_ _7091_/Q _4756_/A2 _4754_/B VDD VDD VSS VSS gf180mcu_fd_sc_mcu7t5v0__nand2_1
X_7541_ _7541_/D _7705_/RN _7703_/CLK _7541_/Q VDD VDD VSS VSS gf180mcu_fd_sc_mcu7t5v0__dffrnq_1
X_7472_ _7472_/D _7472_/CLK _7472_/Q VDD VDD VSS VSS gf180mcu_fd_sc_mcu7t5v0__dffq_1
X_3704_ _5808_/A1 _5810_/A1 _3703_/Z _7782_/D VDD VDD VSS VSS gf180mcu_fd_sc_mcu7t5v0__nor3_4
X_6423_ _6479_/S _6422_/Z _6423_/B _7662_/D VDD VDD VSS VSS gf180mcu_fd_sc_mcu7t5v0__aoi21_1
X_4684_ _4964_/A1 _4686_/A2 _4684_/B _7056_/D VDD VDD VSS VSS gf180mcu_fd_sc_mcu7t5v0__oai21_1
XPHY_EDGE_ROW_96_Right_96 VDD VSS gf180mcu_fd_sc_mcu7t5v0__endcap
X_3635_ _3533_/Z _3632_/Z _3634_/Z _3659_/A3 VDD VDD VSS VSS gf180mcu_fd_sc_mcu7t5v0__xnor3_1
X_3566_ input18/Z input67/Z input21/Z _3566_/Z VDD VDD VSS VSS gf180mcu_fd_sc_mcu7t5v0__xor3_1
X_6354_ _6354_/I0 input31/Z _7782_/D _7640_/D VDD VDD VSS VSS gf180mcu_fd_sc_mcu7t5v0__mux2_2
XTAP_TAPCELL_ROW_112_1829 VDD VSS gf180mcu_fd_sc_mcu7t5v0__filltie
X_6285_ _7638_/Q _6285_/A2 _6301_/B1 _7528_/Q _6286_/B2 VDD VDD VSS VSS gf180mcu_fd_sc_mcu7t5v0__aoi22_1
XFILLER_103_715 VDD VDD VSS VSS gf180mcu_fd_sc_mcu7t5v0__fillcap_4
X_3497_ _6619_/A1 _6184_/C _3498_/A2 VDD VDD VSS VSS gf180mcu_fd_sc_mcu7t5v0__nand2_1
XFILLER_0_308 VDD VDD VSS VSS gf180mcu_fd_sc_mcu7t5v0__fill_2
X_5305_ _7641_/Q _7452_/Q _5309_/S _7452_/D VDD VDD VSS VSS gf180mcu_fd_sc_mcu7t5v0__mux2_2
Xclkbuf_3_4__f_clk_i clkbuf_0_clk_i/Z clkload3/I VDD VDD VSS VSS gf180mcu_fd_sc_mcu7t5v0__clkbuf_16
XTAP_TAPCELL_ROW_58_1072 VDD VSS gf180mcu_fd_sc_mcu7t5v0__filltie
XFILLER_88_437 VDD VDD VSS VSS gf180mcu_fd_sc_mcu7t5v0__fill_1
X_5236_ _5243_/I0 _7383_/Q _5239_/S _7383_/D VDD VDD VSS VSS gf180mcu_fd_sc_mcu7t5v0__mux2_2
XTAP_TAPCELL_ROW_71_1250 VDD VSS gf180mcu_fd_sc_mcu7t5v0__filltie
X_5167_ wire521/Z _7314_/Q _5169_/S _7314_/D VDD VDD VSS VSS gf180mcu_fd_sc_mcu7t5v0__mux2_2
X_5098_ _5098_/A1 _5106_/A2 _5098_/B _7263_/D VDD VDD VSS VSS gf180mcu_fd_sc_mcu7t5v0__oai21_1
XFILLER_83_142 VDD VDD VSS VSS gf180mcu_fd_sc_mcu7t5v0__fill_2
X_4118_ _6790_/Q _4980_/A2 _4119_/B VDD VDD VSS VSS gf180mcu_fd_sc_mcu7t5v0__nand2_1
XFILLER_57_857 VDD VDD VSS VSS gf180mcu_fd_sc_mcu7t5v0__fill_2
X_4049_ _4143_/A1 _4672_/A2 _4049_/B _6768_/D VDD VDD VSS VSS gf180mcu_fd_sc_mcu7t5v0__oai21_1
XFILLER_80_871 VDD VDD VSS VSS gf180mcu_fd_sc_mcu7t5v0__fillcap_4
X_7808_ _7808_/D _7811_/RN clkload7/I _7808_/Q VDD VDD VSS VSS gf180mcu_fd_sc_mcu7t5v0__dffrnq_1
X_7739_ _7739_/D _7783_/RN _7782_/CLK _7739_/Q VDD VDD VSS VSS gf180mcu_fd_sc_mcu7t5v0__dffrnq_1
XTAP_TAPCELL_ROW_89_1511 VDD VSS gf180mcu_fd_sc_mcu7t5v0__filltie
XTAP_TAPCELL_ROW_89_1500 VDD VSS gf180mcu_fd_sc_mcu7t5v0__filltie
XFILLER_0_886 VDD VDD VSS VSS gf180mcu_fd_sc_mcu7t5v0__fillcap_32
XFILLER_87_492 VDD VDD VSS VSS gf180mcu_fd_sc_mcu7t5v0__fill_2
XFILLER_90_602 VDD VDD VSS VSS gf180mcu_fd_sc_mcu7t5v0__fill_1
XFILLER_31_702 VDD VDD VSS VSS gf180mcu_fd_sc_mcu7t5v0__fillcap_64
XTAP_TAPCELL_ROW_33_719 VDD VSS gf180mcu_fd_sc_mcu7t5v0__filltie
XFILLER_43_562 VDD VDD VSS VSS gf180mcu_fd_sc_mcu7t5v0__fillcap_4
XTAP_TAPCELL_ROW_13_443 VDD VSS gf180mcu_fd_sc_mcu7t5v0__filltie
X_3420_ _7550_/Q _5673_/A1 VDD VDD VSS VSS gf180mcu_fd_sc_mcu7t5v0__clkinv_1
Xload_slew311 _6207_/B1 _6085_/B1 VDD VDD VSS VSS gf180mcu_fd_sc_mcu7t5v0__clkbuf_4
X_6070_ _6972_/Q _6073_/A2 _6162_/C _6072_/A1 VDD VDD VSS VSS gf180mcu_fd_sc_mcu7t5v0__oai21_1
Xload_slew344 _6198_/B1 _6091_/A2 VDD VDD VSS VSS gf180mcu_fd_sc_mcu7t5v0__buf_4
X_5021_ _7225_/Q _5022_/A2 _5022_/B VDD VDD VSS VSS gf180mcu_fd_sc_mcu7t5v0__nand2_1
XFILLER_24_2 VDD VDD VSS VSS gf180mcu_fd_sc_mcu7t5v0__fill_1
Xload_slew388 _5613_/A2 _5596_/A2 VDD VDD VSS VSS gf180mcu_fd_sc_mcu7t5v0__buf_4
XFILLER_94_941 VDD VDD VSS VSS gf180mcu_fd_sc_mcu7t5v0__fillcap_4
Xload_slew399 _6092_/C2 _6073_/A2 VDD VDD VSS VSS gf180mcu_fd_sc_mcu7t5v0__clkbuf_4
X_6972_ _6972_/D _7003_/CLK _6972_/Q VDD VDD VSS VSS gf180mcu_fd_sc_mcu7t5v0__dffq_1
XTAP_TAPCELL_ROW_109_1791 VDD VSS gf180mcu_fd_sc_mcu7t5v0__filltie
XTAP_TAPCELL_ROW_109_1780 VDD VSS gf180mcu_fd_sc_mcu7t5v0__filltie
X_5923_ _5923_/A1 _5923_/A2 _5933_/A1 VDD VDD VSS VSS gf180mcu_fd_sc_mcu7t5v0__nor2_1
X_5854_ _5854_/A1 _5854_/A2 _5854_/B _6216_/B _5861_/C VDD VDD VSS VSS gf180mcu_fd_sc_mcu7t5v0__oai211_1
XFILLER_21_212 VDD VDD VSS VSS gf180mcu_fd_sc_mcu7t5v0__fill_2
X_4805_ _7117_/Q _4812_/A2 _4806_/B VDD VDD VSS VSS gf180mcu_fd_sc_mcu7t5v0__nand2_1
X_7524_ _7524_/D _7709_/RN _7711_/CLK _7524_/Q VDD VDD VSS VSS gf180mcu_fd_sc_mcu7t5v0__dffrnq_1
X_5785_ _5785_/A1 _5785_/A2 _6237_/B _5792_/A2 VDD VDD VSS VSS gf180mcu_fd_sc_mcu7t5v0__oai21_1
XFILLER_108_807 VDD VDD VSS VSS gf180mcu_fd_sc_mcu7t5v0__fillcap_8
X_4736_ _4988_/A1 _4742_/A2 _4736_/B _7082_/D VDD VDD VSS VSS gf180mcu_fd_sc_mcu7t5v0__oai21_1
X_4667_ _7048_/Q _4672_/A2 _4668_/B VDD VDD VSS VSS gf180mcu_fd_sc_mcu7t5v0__nand2_1
X_7455_ _7455_/D _7754_/CLK _7455_/Q VDD VDD VSS VSS gf180mcu_fd_sc_mcu7t5v0__dffq_1
X_6406_ _7660_/Q _7526_/Q _6421_/A1 VDD VDD VSS VSS gf180mcu_fd_sc_mcu7t5v0__nor2_1
X_3618_ _3386_/I _3542_/Z _3606_/Z _3618_/Z VDD VDD VSS VSS gf180mcu_fd_sc_mcu7t5v0__xor3_1
X_7386_ _7386_/D _7735_/CLK _7386_/Q VDD VDD VSS VSS gf180mcu_fd_sc_mcu7t5v0__dffq_1
X_6337_ _6337_/A1 _6338_/S _6337_/B _7628_/D VDD VDD VSS VSS gf180mcu_fd_sc_mcu7t5v0__oai21_1
X_4598_ wire240/Z _4602_/A2 _4598_/B _7013_/D VDD VDD VSS VSS gf180mcu_fd_sc_mcu7t5v0__oai21_1
X_3549_ input61/Z input60/Z input56/Z _3549_/Z VDD VDD VSS VSS gf180mcu_fd_sc_mcu7t5v0__xor3_1
X_6268_ _7630_/Q _6285_/A2 _6268_/B1 _7711_/Q _6269_/B2 VDD VDD VSS VSS gf180mcu_fd_sc_mcu7t5v0__aoi22_1
XFILLER_89_768 VDD VDD VSS VSS gf180mcu_fd_sc_mcu7t5v0__fill_2
XFILLER_0_138 VDD VDD VSS VSS gf180mcu_fd_sc_mcu7t5v0__fill_2
XFILLER_103_578 VDD VDD VSS VSS gf180mcu_fd_sc_mcu7t5v0__fill_2
X_6199_ _6199_/A1 _6199_/A2 _6203_/B1 VDD VDD VSS VSS gf180mcu_fd_sc_mcu7t5v0__nor2_1
X_5219_ _5352_/I0 _7366_/Q _5225_/S _7366_/D VDD VDD VSS VSS gf180mcu_fd_sc_mcu7t5v0__mux2_2
XTAP_TAPCELL_ROW_84_1441 VDD VSS gf180mcu_fd_sc_mcu7t5v0__filltie
XTAP_TAPCELL_ROW_84_1430 VDD VSS gf180mcu_fd_sc_mcu7t5v0__filltie
XFILLER_13_702 VDD VDD VSS VSS gf180mcu_fd_sc_mcu7t5v0__fillcap_64
XFILLER_25_562 VDD VDD VSS VSS gf180mcu_fd_sc_mcu7t5v0__fillcap_64
XFILLER_8_205 VDD VDD VSS VSS gf180mcu_fd_sc_mcu7t5v0__fill_1
XTAP_TAPCELL_ROW_10_402 VDD VSS gf180mcu_fd_sc_mcu7t5v0__filltie
XFILLER_5_912 VDD VDD VSS VSS gf180mcu_fd_sc_mcu7t5v0__fillcap_64
XFILLER_5_38 VDD VDD VSS VSS gf180mcu_fd_sc_mcu7t5v0__fill_2
XTAP_TAPCELL_ROW_95_1592 VDD VSS gf180mcu_fd_sc_mcu7t5v0__filltie
XTAP_TAPCELL_ROW_18_513 VDD VSS gf180mcu_fd_sc_mcu7t5v0__filltie
XFILLER_91_977 VDD VDD VSS VSS gf180mcu_fd_sc_mcu7t5v0__fill_2
XTAP_TAPCELL_ROW_46_899 VDD VSS gf180mcu_fd_sc_mcu7t5v0__filltie
XFILLER_31_543 VDD VDD VSS VSS gf180mcu_fd_sc_mcu7t5v0__fillcap_16
X_5570_ _5397_/B _5570_/A2 _5570_/A3 _5570_/B1 _5570_/B2 _5584_/I0 VDD VDD VSS VSS
+ gf180mcu_fd_sc_mcu7t5v0__oai32_1
X_4521_ _6975_/Q _4532_/A2 _4522_/B VDD VDD VSS VSS gf180mcu_fd_sc_mcu7t5v0__nand2_1
X_4452_ _4550_/A1 _4462_/A2 _4452_/B _6940_/D VDD VDD VSS VSS gf180mcu_fd_sc_mcu7t5v0__oai21_1
X_7240_ _7240_/D _7247_/CLK _7240_/Q VDD VDD VSS VSS gf180mcu_fd_sc_mcu7t5v0__dffq_1
X_3403_ _7681_/Q _5724_/A2 VDD VDD VSS VSS gf180mcu_fd_sc_mcu7t5v0__clkinv_1
X_4383_ _6906_/Q _4392_/A2 _4384_/B VDD VDD VSS VSS gf180mcu_fd_sc_mcu7t5v0__nand2_1
X_7171_ _7171_/D _7748_/CLK _7171_/Q VDD VDD VSS VSS gf180mcu_fd_sc_mcu7t5v0__dffq_1
XTAP_TAPCELL_ROW_55_1031 VDD VSS gf180mcu_fd_sc_mcu7t5v0__filltie
XFILLER_59_908 VDD VDD VSS VSS gf180mcu_fd_sc_mcu7t5v0__fill_2
X_6122_ _6122_/A1 _6122_/A2 _6122_/B1 _6176_/B _6122_/C _6123_/B VDD VDD VSS VSS gf180mcu_fd_sc_mcu7t5v0__oai221_1
X_6053_ _7153_/Q wire341/Z _6239_/B1 _7139_/Q _6058_/A1 VDD VDD VSS VSS gf180mcu_fd_sc_mcu7t5v0__oai22_1
Xload_slew196 _6326_/A2 _6344_/S VDD VDD VSS VSS gf180mcu_fd_sc_mcu7t5v0__buf_4
XFILLER_39_632 VDD VDD VSS VSS gf180mcu_fd_sc_mcu7t5v0__fillcap_64
X_5004_ wire241/Z _5008_/A2 _5004_/B _7216_/D VDD VDD VSS VSS gf180mcu_fd_sc_mcu7t5v0__oai21_1
XFILLER_67_941 VDD VDD VSS VSS gf180mcu_fd_sc_mcu7t5v0__fillcap_32
X_6955_ _6955_/D _7276_/CLK _6955_/Q VDD VDD VSS VSS gf180mcu_fd_sc_mcu7t5v0__dffq_1
X_5906_ _7172_/Q _6239_/B1 _6242_/C _5908_/A1 VDD VDD VSS VSS gf180mcu_fd_sc_mcu7t5v0__oai21_1
X_6886_ _6886_/D _7148_/CLK _6886_/Q VDD VDD VSS VSS gf180mcu_fd_sc_mcu7t5v0__dffq_1
XTAP_TAPCELL_ROW_66_1182 VDD VSS gf180mcu_fd_sc_mcu7t5v0__filltie
X_5837_ _6947_/Q _6092_/A2 _6092_/B1 _6954_/Q _5839_/A1 VDD VDD VSS VSS gf180mcu_fd_sc_mcu7t5v0__oai22_1
XFILLER_22_576 VDD VDD VSS VSS gf180mcu_fd_sc_mcu7t5v0__fillcap_16
XFILLER_50_874 VDD VDD VSS VSS gf180mcu_fd_sc_mcu7t5v0__fill_1
X_5768_ _5768_/A1 _5768_/A2 _5771_/B VDD VDD VSS VSS gf180mcu_fd_sc_mcu7t5v0__or2_1
X_4719_ _7074_/Q _4728_/A2 _4720_/B VDD VDD VSS VSS gf180mcu_fd_sc_mcu7t5v0__nand2_1
X_7507_ _7507_/D _7764_/RN _7765_/CLK _7507_/Q VDD VDD VSS VSS gf180mcu_fd_sc_mcu7t5v0__dffsnq_1
X_7438_ _7438_/D _7483_/CLK _7438_/Q VDD VDD VSS VSS gf180mcu_fd_sc_mcu7t5v0__dffq_1
X_5699_ _5699_/A1 _5699_/A2 _5700_/B VDD VDD VSS VSS gf180mcu_fd_sc_mcu7t5v0__nand2_1
X_7369_ _7369_/D _7489_/CLK _7369_/Q VDD VDD VSS VSS gf180mcu_fd_sc_mcu7t5v0__dffq_1
XFILLER_77_716 VDD VDD VSS VSS gf180mcu_fd_sc_mcu7t5v0__fillcap_4
XFILLER_76_259 VDD VDD VSS VSS gf180mcu_fd_sc_mcu7t5v0__fill_1
XFILLER_58_930 VDD VDD VSS VSS gf180mcu_fd_sc_mcu7t5v0__fillcap_8
XFILLER_73_955 VDD VDD VSS VSS gf180mcu_fd_sc_mcu7t5v0__fillcap_16
XPHY_EDGE_ROW_105_Right_105 VDD VSS gf180mcu_fd_sc_mcu7t5v0__endcap
XFILLER_26_871 VDD VDD VSS VSS gf180mcu_fd_sc_mcu7t5v0__fillcap_4
XFILLER_13_521 VDD VDD VSS VSS gf180mcu_fd_sc_mcu7t5v0__fillcap_4
XTAP_TAPCELL_ROW_43_858 VDD VSS gf180mcu_fd_sc_mcu7t5v0__filltie
XTAP_TAPCELL_ROW_23_582 VDD VSS gf180mcu_fd_sc_mcu7t5v0__filltie
XFILLER_40_384 VDD VDD VSS VSS gf180mcu_fd_sc_mcu7t5v0__fill_1
XTAP_TAPCELL_ROW_97_1621 VDD VSS gf180mcu_fd_sc_mcu7t5v0__filltie
XTAP_TAPCELL_ROW_97_1610 VDD VSS gf180mcu_fd_sc_mcu7t5v0__filltie
XFILLER_64_944 VDD VDD VSS VSS gf180mcu_fd_sc_mcu7t5v0__fill_1
XFILLER_90_262 VDD VDD VSS VSS gf180mcu_fd_sc_mcu7t5v0__fill_2
X_6740_ _6740_/D _7279_/CLK _6740_/Q VDD VDD VSS VSS gf180mcu_fd_sc_mcu7t5v0__dffq_1
X_3952_ _6740_/Q _4280_/A2 _3953_/B VDD VDD VSS VSS gf180mcu_fd_sc_mcu7t5v0__nand2_1
X_6671_ _6671_/A1 _6671_/A2 _6692_/C _7741_/D VDD VDD VSS VSS gf180mcu_fd_sc_mcu7t5v0__oai21_1
X_3883_ _6362_/B _3882_/Z _6370_/A2 VDD VDD VSS VSS gf180mcu_fd_sc_mcu7t5v0__nand2_1
X_5622_ _5461_/Z _5493_/Z _5622_/Z VDD VDD VSS VSS gf180mcu_fd_sc_mcu7t5v0__xor2_1
X_5553_ _5553_/A1 _5553_/A2 _5553_/B1 _5493_/S _5554_/I1 VDD VDD VSS VSS gf180mcu_fd_sc_mcu7t5v0__oai22_1
X_4504_ _4532_/A1 _4504_/A2 _4504_/B _6966_/D VDD VDD VSS VSS gf180mcu_fd_sc_mcu7t5v0__oai21_1
XFILLER_8_591 VDD VDD VSS VSS gf180mcu_fd_sc_mcu7t5v0__fillcap_4
X_5484_ _7327_/Q _5535_/C2 _5562_/A2 _7320_/Q _5514_/C _5485_/A2 VDD VDD VSS VSS gf180mcu_fd_sc_mcu7t5v0__oai221_1
X_4435_ _6932_/Q _4448_/A2 _4436_/B VDD VDD VSS VSS gf180mcu_fd_sc_mcu7t5v0__nand2_1
XTAP_TAPCELL_ROW_117_1890 VDD VSS gf180mcu_fd_sc_mcu7t5v0__filltie
X_7223_ _7223_/D _7267_/CLK _7223_/Q VDD VDD VSS VSS gf180mcu_fd_sc_mcu7t5v0__dffq_1
X_4366_ _4506_/A1 _4378_/A2 _4366_/B _6897_/D VDD VDD VSS VSS gf180mcu_fd_sc_mcu7t5v0__oai21_1
Xfanout504 _4223_/I0 _4234_/I0 VDD VDD VSS VSS gf180mcu_fd_sc_mcu7t5v0__dlyd_1
X_7154_ _7154_/D _7248_/CLK _7154_/Q VDD VDD VSS VSS gf180mcu_fd_sc_mcu7t5v0__dffq_1
XFILLER_86_524 VDD VDD VSS VSS gf180mcu_fd_sc_mcu7t5v0__fill_1
Xfanout537 fanout538/Z _5303_/I0 VDD VDD VSS VSS gf180mcu_fd_sc_mcu7t5v0__dlyd_1
Xfanout548 _7653_/RN _7764_/RN VDD VDD VSS VSS gf180mcu_fd_sc_mcu7t5v0__dlyd_1
X_6105_ _6105_/A1 _6105_/A2 _6109_/B1 VDD VDD VSS VSS gf180mcu_fd_sc_mcu7t5v0__nor2_1
XFILLER_100_312 VDD VDD VSS VSS gf180mcu_fd_sc_mcu7t5v0__fill_2
X_4297_ _6863_/Q _4308_/A2 _4298_/B VDD VDD VSS VSS gf180mcu_fd_sc_mcu7t5v0__nand2_1
X_7085_ _7085_/D _7099_/CLK _7085_/Q VDD VDD VSS VSS gf180mcu_fd_sc_mcu7t5v0__dffq_1
X_6036_ _6908_/Q _6162_/A2 _6076_/A2 _6901_/Q _6887_/Q wire322/Z _6037_/A2 VDD VDD
+ VSS VSS gf180mcu_fd_sc_mcu7t5v0__oai222_1
XTAP_TAPCELL_ROW_68_1211 VDD VSS gf180mcu_fd_sc_mcu7t5v0__filltie
XTAP_TAPCELL_ROW_1_266 VDD VSS gf180mcu_fd_sc_mcu7t5v0__filltie
XTAP_TAPCELL_ROW_1_277 VDD VSS gf180mcu_fd_sc_mcu7t5v0__filltie
XFILLER_70_947 VDD VDD VSS VSS gf180mcu_fd_sc_mcu7t5v0__fillcap_32
X_6938_ _6938_/D _6944_/CLK _6938_/Q VDD VDD VSS VSS gf180mcu_fd_sc_mcu7t5v0__dffq_1
X_6869_ _6869_/D _7683_/CLK _6869_/Q VDD VDD VSS VSS gf180mcu_fd_sc_mcu7t5v0__dffq_1
XTAP_TAPCELL_ROW_40_817 VDD VSS gf180mcu_fd_sc_mcu7t5v0__filltie
XFILLER_50_660 VDD VDD VSS VSS gf180mcu_fd_sc_mcu7t5v0__fillcap_4
XFILLER_10_524 VDD VDD VSS VSS gf180mcu_fd_sc_mcu7t5v0__fill_1
XTAP_TAPCELL_ROW_20_541 VDD VSS gf180mcu_fd_sc_mcu7t5v0__filltie
XTAP_TAPCELL_ROW_79_1362 VDD VSS gf180mcu_fd_sc_mcu7t5v0__filltie
XTAP_TAPCELL_ROW_92_1551 VDD VSS gf180mcu_fd_sc_mcu7t5v0__filltie
XTAP_TAPCELL_ROW_92_1540 VDD VSS gf180mcu_fd_sc_mcu7t5v0__filltie
XFILLER_89_373 VDD VDD VSS VSS gf180mcu_fd_sc_mcu7t5v0__fill_1
XTAP_TAPCELL_ROW_9_388 VDD VSS gf180mcu_fd_sc_mcu7t5v0__filltie
XFILLER_49_204 VDD VDD VSS VSS gf180mcu_fd_sc_mcu7t5v0__fill_1
XFILLER_77_557 VDD VDD VSS VSS gf180mcu_fd_sc_mcu7t5v0__fill_2
XTAP_TAPCELL_ROW_48_928 VDD VSS gf180mcu_fd_sc_mcu7t5v0__filltie
XTAP_TAPCELL_ROW_28_652 VDD VSS gf180mcu_fd_sc_mcu7t5v0__filltie
Xoutput129 _7885_/Z tl_o[13] VDD VDD VSS VSS gf180mcu_fd_sc_mcu7t5v0__dlyd_1
Xoutput118 _7804_/Q intr_tx_empty_o VDD VDD VSS VSS gf180mcu_fd_sc_mcu7t5v0__dlyd_1
X_4220_ _4223_/I0 _6825_/Q _5302_/S _6825_/D VDD VDD VSS VSS gf180mcu_fd_sc_mcu7t5v0__mux2_2
X_4151_ _6801_/Q _5134_/A2 _4152_/B VDD VDD VSS VSS gf180mcu_fd_sc_mcu7t5v0__nand2_1
XFILLER_68_524 VDD VDD VSS VSS gf180mcu_fd_sc_mcu7t5v0__fill_1
X_4082_ _6779_/Q _4826_/A2 _4083_/B VDD VDD VSS VSS gf180mcu_fd_sc_mcu7t5v0__nand2_1
XFILLER_36_454 VDD VDD VSS VSS gf180mcu_fd_sc_mcu7t5v0__fill_1
XTAP_TAPCELL_ROW_104_1709 VDD VSS gf180mcu_fd_sc_mcu7t5v0__filltie
X_7772_ _7772_/D _7825_/RN clkload8/I _7772_/Q VDD VDD VSS VSS gf180mcu_fd_sc_mcu7t5v0__dffsnq_1
XFILLER_52_947 VDD VDD VSS VSS gf180mcu_fd_sc_mcu7t5v0__fillcap_32
X_4984_ _4984_/A1 _4994_/A2 _4984_/B _7206_/D VDD VDD VSS VSS gf180mcu_fd_sc_mcu7t5v0__oai21_1
XFILLER_63_284 VDD VDD VSS VSS gf180mcu_fd_sc_mcu7t5v0__fill_1
X_6723_ _7785_/D _6723_/A2 _7760_/D VDD VDD VSS VSS gf180mcu_fd_sc_mcu7t5v0__nor2_1
X_3935_ _7792_/Q _7756_/Q _5699_/A2 _5696_/A2 VDD VDD VSS VSS gf180mcu_fd_sc_mcu7t5v0__nand3_1
XTAP_TAPCELL_ROW_63_1141 VDD VSS gf180mcu_fd_sc_mcu7t5v0__filltie
X_6654_ _6654_/A1 _6654_/A2 _6654_/B _6654_/C _7734_/D VDD VDD VSS VSS gf180mcu_fd_sc_mcu7t5v0__aoi211_1
X_5605_ _5605_/A1 _5605_/A2 _5615_/A2 VDD VDD VSS VSS gf180mcu_fd_sc_mcu7t5v0__nor2_1
XFILLER_20_877 VDD VDD VSS VSS gf180mcu_fd_sc_mcu7t5v0__fillcap_64
X_3866_ _6679_/I0 _3866_/A2 _3867_/B VDD VDD VSS VSS gf180mcu_fd_sc_mcu7t5v0__nor2_1
X_3797_ _5810_/A1 _3703_/Z _3797_/A3 _3797_/B _3798_/I VDD VDD VSS VSS gf180mcu_fd_sc_mcu7t5v0__oai31_1
X_6585_ _6601_/A1 _6605_/A2 _6585_/Z VDD VDD VSS VSS gf180mcu_fd_sc_mcu7t5v0__or2_1
XFILLER_117_242 VDD VDD VSS VSS gf180mcu_fd_sc_mcu7t5v0__fill_1
X_5536_ _7294_/Q _5562_/A2 _5596_/B1 _7497_/Q _5538_/A2 VDD VDD VSS VSS gf180mcu_fd_sc_mcu7t5v0__oai22_1
X_5467_ _7383_/Q _5572_/C2 _6634_/B _5469_/A1 VDD VDD VSS VSS gf180mcu_fd_sc_mcu7t5v0__oai21_1
X_4418_ _4460_/A1 _4420_/A2 _4418_/B _6923_/D VDD VDD VSS VSS gf180mcu_fd_sc_mcu7t5v0__oai21_1
X_7206_ _7206_/D _7251_/CLK _7206_/Q VDD VDD VSS VSS gf180mcu_fd_sc_mcu7t5v0__dffq_1
XFILLER_99_671 VDD VDD VSS VSS gf180mcu_fd_sc_mcu7t5v0__fill_1
Xfanout312 _6211_/B1 wire313/I VDD VDD VSS VSS gf180mcu_fd_sc_mcu7t5v0__dlyd_1
Xfanout323 _6201_/A2 fanout323/Z VDD VDD VSS VSS gf180mcu_fd_sc_mcu7t5v0__dlyd_1
X_5398_ _5614_/B _5398_/A2 _5398_/A3 _5398_/B1 _5398_/B2 _5399_/I1 VDD VDD VSS VSS
+ gf180mcu_fd_sc_mcu7t5v0__oai32_1
X_4349_ _6889_/Q _4350_/A2 _4350_/B VDD VDD VSS VSS gf180mcu_fd_sc_mcu7t5v0__nand2_1
Xfanout345 fanout346/Z _6222_/B1 VDD VDD VSS VSS gf180mcu_fd_sc_mcu7t5v0__dlyd_1
XFILLER_101_632 VDD VDD VSS VSS gf180mcu_fd_sc_mcu7t5v0__fill_1
Xfanout356 _6225_/B1 _6144_/A2 VDD VDD VSS VSS gf180mcu_fd_sc_mcu7t5v0__dlyd_1
XTAP_TAPCELL_ROW_74_1292 VDD VSS gf180mcu_fd_sc_mcu7t5v0__filltie
XTAP_TAPCELL_ROW_6_347 VDD VSS gf180mcu_fd_sc_mcu7t5v0__filltie
XTAP_TAPCELL_ROW_6_336 VDD VSS gf180mcu_fd_sc_mcu7t5v0__filltie
XFILLER_59_535 VDD VDD VSS VSS gf180mcu_fd_sc_mcu7t5v0__fill_2
X_7137_ _7137_/D _7189_/CLK _7137_/Q VDD VDD VSS VSS gf180mcu_fd_sc_mcu7t5v0__dffq_1
XFILLER_101_643 VDD VDD VSS VSS gf180mcu_fd_sc_mcu7t5v0__fill_1
X_7068_ _7068_/D _7070_/CLK _7068_/Q VDD VDD VSS VSS gf180mcu_fd_sc_mcu7t5v0__dffq_1
XFILLER_101_687 VDD VDD VSS VSS gf180mcu_fd_sc_mcu7t5v0__fill_1
X_6019_ _6019_/A1 _6019_/A2 _6202_/B _6020_/B2 VDD VDD VSS VSS gf180mcu_fd_sc_mcu7t5v0__oai21_1
XTAP_TAPCELL_ROW_25_611 VDD VSS gf180mcu_fd_sc_mcu7t5v0__filltie
XFILLER_42_457 VDD VDD VSS VSS gf180mcu_fd_sc_mcu7t5v0__fill_1
XTAP_TAPCELL_ROW_53_997 VDD VSS gf180mcu_fd_sc_mcu7t5v0__filltie
XFILLER_6_314 VDD VDD VSS VSS gf180mcu_fd_sc_mcu7t5v0__fill_1
XFILLER_10_387 VDD VDD VSS VSS gf180mcu_fd_sc_mcu7t5v0__fill_2
XFILLER_111_418 VDD VDD VSS VSS gf180mcu_fd_sc_mcu7t5v0__fill_2
XFILLER_2_597 VDD VDD VSS VSS gf180mcu_fd_sc_mcu7t5v0__fillcap_64
XFILLER_78_877 VDD VDD VSS VSS gf180mcu_fd_sc_mcu7t5v0__fill_2
XFILLER_77_343 VDD VDD VSS VSS gf180mcu_fd_sc_mcu7t5v0__fill_2
XFILLER_93_847 VDD VDD VSS VSS gf180mcu_fd_sc_mcu7t5v0__fillcap_8
XFILLER_65_516 VDD VDD VSS VSS gf180mcu_fd_sc_mcu7t5v0__fill_2
XFILLER_34_947 VDD VDD VSS VSS gf180mcu_fd_sc_mcu7t5v0__fillcap_32
XFILLER_61_766 VDD VDD VSS VSS gf180mcu_fd_sc_mcu7t5v0__fillcap_4
X_3720_ _3730_/A1 _3720_/A2 _3721_/B VDD VDD VSS VSS gf180mcu_fd_sc_mcu7t5v0__nand2_1
X_3651_ _3560_/Z _3564_/Z _3650_/Z _3651_/Z VDD VDD VSS VSS gf180mcu_fd_sc_mcu7t5v0__xor3_1
X_6370_ _6677_/A1 _6370_/A2 _6370_/B _7651_/D VDD VDD VSS VSS gf180mcu_fd_sc_mcu7t5v0__oai21_1
X_3582_ input47/Z _3592_/A3 _3579_/Z _3582_/Z VDD VDD VSS VSS gf180mcu_fd_sc_mcu7t5v0__xor3_1
X_5321_ _5342_/I0 _7468_/Q _5323_/S _7468_/D VDD VDD VSS VSS gf180mcu_fd_sc_mcu7t5v0__mux2_2
XFILLER_54_2 VDD VDD VSS VSS gf180mcu_fd_sc_mcu7t5v0__fill_2
XTAP_TAPCELL_ROW_114_1860 VDD VSS gf180mcu_fd_sc_mcu7t5v0__filltie
X_5252_ wire517/Z _7399_/Q _5253_/S _7399_/D VDD VDD VSS VSS gf180mcu_fd_sc_mcu7t5v0__mux2_2
X_5183_ _5344_/I0 _7330_/Q _5183_/S _7330_/D VDD VDD VSS VSS gf180mcu_fd_sc_mcu7t5v0__mux2_2
X_4203_ _4203_/A1 _4212_/A2 _4210_/A2 VDD VDD VSS VSS gf180mcu_fd_sc_mcu7t5v0__nor2_1
XFILLER_96_663 VDD VDD VSS VSS gf180mcu_fd_sc_mcu7t5v0__fill_2
XTAP_TAPCELL_ROW_3_306 VDD VSS gf180mcu_fd_sc_mcu7t5v0__filltie
X_4134_ _4140_/A1 _5050_/A2 _4134_/B _6795_/D VDD VDD VSS VSS gf180mcu_fd_sc_mcu7t5v0__oai21_1
XFILLER_68_387 VDD VDD VSS VSS gf180mcu_fd_sc_mcu7t5v0__fill_2
X_4065_ _4071_/A1 _4742_/A2 _4065_/B _6773_/D VDD VDD VSS VSS gf180mcu_fd_sc_mcu7t5v0__oai21_1
X_7824_ _7824_/D _7823_/RN clkload7/I _7877_/I VDD VDD VSS VSS gf180mcu_fd_sc_mcu7t5v0__dffsnq_1
X_7755_ _7755_/D _7755_/RN _7755_/CLK _7755_/Q VDD VDD VSS VSS gf180mcu_fd_sc_mcu7t5v0__dffrnq_1
X_4967_ _7198_/Q _4980_/A2 _4968_/B VDD VDD VSS VSS gf180mcu_fd_sc_mcu7t5v0__nand2_1
X_3918_ _3914_/Z _3917_/Z _3918_/Z VDD VDD VSS VSS gf180mcu_fd_sc_mcu7t5v0__xor2_1
X_7686_ _7686_/D _7802_/RN _7692_/CLK _7686_/Q VDD VDD VSS VSS gf180mcu_fd_sc_mcu7t5v0__dffrnq_1
XTAP_TAPCELL_ROW_50_956 VDD VSS gf180mcu_fd_sc_mcu7t5v0__filltie
X_4898_ _4940_/A1 _4910_/A2 _4898_/B _7163_/D VDD VDD VSS VSS gf180mcu_fd_sc_mcu7t5v0__oai21_1
X_6706_ _7751_/Q _6716_/A2 _6714_/B1 _7752_/Q _6707_/I VDD VDD VSS VSS gf180mcu_fd_sc_mcu7t5v0__aoi22_1
X_3849_ _7774_/Q _3518_/B _3849_/B _7826_/D VDD VDD VSS VSS gf180mcu_fd_sc_mcu7t5v0__aoi21_1
X_6637_ _6637_/A1 _6635_/Z _6639_/A2 VDD VDD VSS VSS gf180mcu_fd_sc_mcu7t5v0__nor2_1
XFILLER_4_807 VDD VDD VSS VSS gf180mcu_fd_sc_mcu7t5v0__fillcap_64
XTAP_TAPCELL_ROW_30_680 VDD VSS gf180mcu_fd_sc_mcu7t5v0__filltie
X_6568_ _7703_/Q _7702_/Q _6569_/S _7703_/D VDD VDD VSS VSS gf180mcu_fd_sc_mcu7t5v0__mux2_2
XTAP_TAPCELL_ROW_76_1321 VDD VSS gf180mcu_fd_sc_mcu7t5v0__filltie
X_5519_ _5584_/S _5519_/A2 _5519_/A3 _5519_/B1 _5519_/B2 _5523_/A2 VDD VDD VSS VSS
+ gf180mcu_fd_sc_mcu7t5v0__oai32_1
Xclkbuf_leaf_0_clk_i clkload0/I clkload7/I VDD VDD VSS VSS gf180mcu_fd_sc_mcu7t5v0__clkbuf_8
X_6499_ _6499_/A1 _6495_/Z _6499_/Z VDD VDD VSS VSS gf180mcu_fd_sc_mcu7t5v0__xor2_1
XFILLER_79_608 VDD VDD VSS VSS gf180mcu_fd_sc_mcu7t5v0__fill_2
XFILLER_87_696 VDD VDD VSS VSS gf180mcu_fd_sc_mcu7t5v0__fillcap_4
XFILLER_75_825 VDD VDD VSS VSS gf180mcu_fd_sc_mcu7t5v0__fillcap_8
XFILLER_59_365 VDD VDD VSS VSS gf180mcu_fd_sc_mcu7t5v0__fill_1
XTAP_TAPCELL_ROW_87_1472 VDD VSS gf180mcu_fd_sc_mcu7t5v0__filltie
XTAP_TAPCELL_ROW_87_1483 VDD VSS gf180mcu_fd_sc_mcu7t5v0__filltie
XFILLER_16_947 VDD VDD VSS VSS gf180mcu_fd_sc_mcu7t5v0__fillcap_32
XFILLER_15_424 VDD VDD VSS VSS gf180mcu_fd_sc_mcu7t5v0__fill_1
XTAP_TAPCELL_ROW_38_791 VDD VSS gf180mcu_fd_sc_mcu7t5v0__filltie
XFILLER_31_906 VDD VDD VSS VSS gf180mcu_fd_sc_mcu7t5v0__fillcap_4
XFILLER_43_755 VDD VDD VSS VSS gf180mcu_fd_sc_mcu7t5v0__fillcap_8
Xwire521 wire521/I wire521/Z VDD VDD VSS VSS gf180mcu_fd_sc_mcu7t5v0__clkbuf_4
XFILLER_11_696 VDD VDD VSS VSS gf180mcu_fd_sc_mcu7t5v0__fillcap_4
Xwire565 wire565/I wire565/Z VDD VDD VSS VSS gf180mcu_fd_sc_mcu7t5v0__clkbuf_4
XFILLER_78_630 VDD VDD VSS VSS gf180mcu_fd_sc_mcu7t5v0__fill_1
Xload_slew526 _6356_/I0 wire525/I VDD VDD VSS VSS gf180mcu_fd_sc_mcu7t5v0__buf_2
Xload_slew515 _5245_/I0 _5343_/I0 VDD VDD VSS VSS gf180mcu_fd_sc_mcu7t5v0__clkbuf_4
Xload_slew559 _7740_/RN _7783_/RN VDD VDD VSS VSS gf180mcu_fd_sc_mcu7t5v0__buf_4
XFILLER_46_560 VDD VDD VSS VSS gf180mcu_fd_sc_mcu7t5v0__fill_2
X_5870_ _7206_/Q wire353/Z _6174_/B _5872_/A1 VDD VDD VSS VSS gf180mcu_fd_sc_mcu7t5v0__oai21_1
X_4821_ _7125_/Q _4826_/A2 _4822_/B VDD VDD VSS VSS gf180mcu_fd_sc_mcu7t5v0__nand2_1
XTAP_TAPCELL_ROW_60_1100 VDD VSS gf180mcu_fd_sc_mcu7t5v0__filltie
X_4752_ _4752_/A1 _4756_/A2 _4752_/B _7090_/D VDD VDD VSS VSS gf180mcu_fd_sc_mcu7t5v0__oai21_1
XTAP_TAPCELL_ROW_16_485 VDD VSS gf180mcu_fd_sc_mcu7t5v0__filltie
X_7540_ _7540_/D _7740_/RN _7793_/CLK _7540_/Q VDD VDD VSS VSS gf180mcu_fd_sc_mcu7t5v0__dffrnq_1
X_4683_ _7056_/Q _4686_/A2 _4684_/B VDD VDD VSS VSS gf180mcu_fd_sc_mcu7t5v0__nand2_1
X_3703_ input18/Z _3695_/C _5883_/C _3702_/Z _3703_/Z VDD VDD VSS VSS gf180mcu_fd_sc_mcu7t5v0__or4_1
X_7471_ _7471_/D _7489_/CLK _7471_/Q VDD VDD VSS VSS gf180mcu_fd_sc_mcu7t5v0__dffq_1
X_6422_ _6422_/A1 _6426_/A2 _6422_/Z VDD VDD VSS VSS gf180mcu_fd_sc_mcu7t5v0__xor2_1
X_3634_ input81/Z _3627_/Z _3633_/Z _3634_/Z VDD VDD VSS VSS gf180mcu_fd_sc_mcu7t5v0__xor3_1
X_3565_ _3677_/S input68/Z input94/Z _3565_/Z VDD VDD VSS VSS gf180mcu_fd_sc_mcu7t5v0__xor3_1
X_6353_ _6353_/I0 input29/Z _7782_/D _7639_/D VDD VDD VSS VSS gf180mcu_fd_sc_mcu7t5v0__mux2_2
X_6284_ _6284_/A1 _6284_/A2 _6284_/B1 _6284_/B2 _7594_/D VDD VDD VSS VSS gf180mcu_fd_sc_mcu7t5v0__aoi22_1
X_3496_ _7723_/Q _6122_/C _3505_/B VDD VDD VSS VSS gf180mcu_fd_sc_mcu7t5v0__nand2_1
X_5304_ _5304_/I0 _7451_/Q _5309_/S _7451_/D VDD VDD VSS VSS gf180mcu_fd_sc_mcu7t5v0__mux2_2
XTAP_TAPCELL_ROW_58_1073 VDD VSS gf180mcu_fd_sc_mcu7t5v0__filltie
XFILLER_115_587 VDD VDD VSS VSS gf180mcu_fd_sc_mcu7t5v0__fill_2
X_5235_ _5235_/I0 _7382_/Q _5239_/S _7382_/D VDD VDD VSS VSS gf180mcu_fd_sc_mcu7t5v0__mux2_2
XTAP_TAPCELL_ROW_71_1251 VDD VSS gf180mcu_fd_sc_mcu7t5v0__filltie
XFILLER_96_471 VDD VDD VSS VSS gf180mcu_fd_sc_mcu7t5v0__fill_2
X_5166_ wire525/Z _7313_/Q _5169_/S _7313_/D VDD VDD VSS VSS gf180mcu_fd_sc_mcu7t5v0__mux2_2
X_5097_ _7263_/Q _5106_/A2 _5098_/B VDD VDD VSS VSS gf180mcu_fd_sc_mcu7t5v0__nand2_1
X_4117_ _4150_/A2 _4135_/A2 _4980_/A2 VDD VDD VSS VSS gf180mcu_fd_sc_mcu7t5v0__nand2_1
X_4048_ _6768_/Q _4672_/A2 _4049_/B VDD VDD VSS VSS gf180mcu_fd_sc_mcu7t5v0__nand2_1
XFILLER_71_349 VDD VDD VSS VSS gf180mcu_fd_sc_mcu7t5v0__fill_1
XFILLER_13_906 VDD VDD VSS VSS gf180mcu_fd_sc_mcu7t5v0__fillcap_4
XFILLER_24_243 VDD VDD VSS VSS gf180mcu_fd_sc_mcu7t5v0__fill_2
XFILLER_25_766 VDD VDD VSS VSS gf180mcu_fd_sc_mcu7t5v0__fillcap_4
XTAP_TAPCELL_ROW_35_750 VDD VSS gf180mcu_fd_sc_mcu7t5v0__filltie
X_5999_ _5997_/C _5999_/A2 _5999_/B _6000_/A2 VDD VDD VSS VSS gf180mcu_fd_sc_mcu7t5v0__oai21_1
X_7807_ _7807_/D _7811_/RN clkload9/I _7807_/Q VDD VDD VSS VSS gf180mcu_fd_sc_mcu7t5v0__dffrnq_1
X_7738_ _7738_/D _7740_/RN _7782_/CLK _7738_/Q VDD VDD VSS VSS gf180mcu_fd_sc_mcu7t5v0__dffrnq_1
X_7669_ _7669_/D _7671_/RN _7669_/CLK _7669_/Q VDD VDD VSS VSS gf180mcu_fd_sc_mcu7t5v0__dffrnq_1
XFILLER_106_565 VDD VDD VSS VSS gf180mcu_fd_sc_mcu7t5v0__fill_1
XTAP_TAPCELL_ROW_89_1501 VDD VSS gf180mcu_fd_sc_mcu7t5v0__filltie
XFILLER_47_324 VDD VDD VSS VSS gf180mcu_fd_sc_mcu7t5v0__fill_1
XFILLER_62_305 VDD VDD VSS VSS gf180mcu_fd_sc_mcu7t5v0__fill_2
XFILLER_63_839 VDD VDD VSS VSS gf180mcu_fd_sc_mcu7t5v0__fill_1
XFILLER_71_850 VDD VDD VSS VSS gf180mcu_fd_sc_mcu7t5v0__fillcap_4
XTAP_TAPCELL_ROW_13_444 VDD VSS gf180mcu_fd_sc_mcu7t5v0__filltie
XFILLER_99_61 VDD VDD VSS VSS gf180mcu_fd_sc_mcu7t5v0__fill_1
Xload_slew301 _6140_/B1 _6076_/B1 VDD VDD VSS VSS gf180mcu_fd_sc_mcu7t5v0__buf_2
XFILLER_97_246 VDD VDD VSS VSS gf180mcu_fd_sc_mcu7t5v0__fill_2
X_5020_ wire231/Z _5022_/A2 _5020_/B _7224_/D VDD VDD VSS VSS gf180mcu_fd_sc_mcu7t5v0__oai21_1
Xload_slew334 _6151_/A2 _6153_/B1 VDD VDD VSS VSS gf180mcu_fd_sc_mcu7t5v0__buf_4
Xload_slew367 _5511_/C2 _5606_/B1 VDD VDD VSS VSS gf180mcu_fd_sc_mcu7t5v0__buf_4
Xload_slew378 _5607_/A2 _5511_/B1 VDD VDD VSS VSS gf180mcu_fd_sc_mcu7t5v0__buf_4
XFILLER_39_836 VDD VDD VSS VSS gf180mcu_fd_sc_mcu7t5v0__fillcap_4
Xload_slew389 _4110_/A1 _3967_/I VDD VDD VSS VSS gf180mcu_fd_sc_mcu7t5v0__buf_4
XFILLER_17_2 VDD VDD VSS VSS gf180mcu_fd_sc_mcu7t5v0__fill_1
X_6971_ _6971_/D _7003_/CLK _6971_/Q VDD VDD VSS VSS gf180mcu_fd_sc_mcu7t5v0__dffq_1
XTAP_TAPCELL_ROW_109_1781 VDD VSS gf180mcu_fd_sc_mcu7t5v0__filltie
X_5922_ _6878_/Q _6132_/A2 _6131_/A2 _6864_/Q _6242_/C _5923_/A2 VDD VDD VSS VSS gf180mcu_fd_sc_mcu7t5v0__oai221_1
XFILLER_0_72 VDD VDD VSS VSS gf180mcu_fd_sc_mcu7t5v0__fill_1
X_5853_ _5853_/A1 _5853_/A2 _5854_/B VDD VDD VSS VSS gf180mcu_fd_sc_mcu7t5v0__or2_1
XFILLER_62_872 VDD VDD VSS VSS gf180mcu_fd_sc_mcu7t5v0__fill_2
X_5784_ _5784_/A1 _5784_/A2 _5792_/A1 VDD VDD VSS VSS gf180mcu_fd_sc_mcu7t5v0__nor2_1
X_4804_ _5070_/A1 _4812_/A2 _4804_/B _7116_/D VDD VDD VSS VSS gf180mcu_fd_sc_mcu7t5v0__oai21_1
X_7523_ _7523_/D _7695_/RN _7695_/CLK _7523_/Q VDD VDD VSS VSS gf180mcu_fd_sc_mcu7t5v0__dffrnq_1
X_4735_ _7082_/Q _4742_/A2 _4736_/B VDD VDD VSS VSS gf180mcu_fd_sc_mcu7t5v0__nand2_1
X_4666_ _4708_/A1 _4672_/A2 _4666_/B _7047_/D VDD VDD VSS VSS gf180mcu_fd_sc_mcu7t5v0__oai21_1
X_7454_ _7454_/D _7748_/CLK _7454_/Q VDD VDD VSS VSS gf180mcu_fd_sc_mcu7t5v0__dffq_1
X_6405_ _6399_/Z _6411_/B2 _6411_/C _6407_/A3 VDD VDD VSS VSS gf180mcu_fd_sc_mcu7t5v0__aoi21_1
X_4597_ _7013_/Q _4602_/A2 _4598_/B VDD VDD VSS VSS gf180mcu_fd_sc_mcu7t5v0__nand2_1
X_3617_ input92/Z _3615_/Z _3616_/Z _3617_/Z VDD VDD VSS VSS gf180mcu_fd_sc_mcu7t5v0__xor3_1
X_7385_ _7385_/D _7734_/CLK _7385_/Q VDD VDD VSS VSS gf180mcu_fd_sc_mcu7t5v0__dffq_1
X_3548_ _3533_/Z _3538_/Z _3542_/Z _3548_/Z VDD VDD VSS VSS gf180mcu_fd_sc_mcu7t5v0__xor3_1
X_6336_ input44/Z _6331_/S _6337_/B VDD VDD VSS VSS gf180mcu_fd_sc_mcu7t5v0__nand2_1
Xclkbuf_leaf_80_clk_i clkbuf_3_1__f_clk_i/Z _7492_/CLK VDD VDD VSS VSS gf180mcu_fd_sc_mcu7t5v0__clkbuf_8
XFILLER_0_106 VDD VDD VSS VSS gf180mcu_fd_sc_mcu7t5v0__fill_1
X_6267_ _6267_/A1 _5744_/B _6274_/B1 _6267_/B2 _7586_/D VDD VDD VSS VSS gf180mcu_fd_sc_mcu7t5v0__aoi22_1
X_3479_ _7720_/Q _7713_/Q _3481_/B VDD VDD VSS VSS gf180mcu_fd_sc_mcu7t5v0__xnor2_1
X_6198_ _6740_/Q _6198_/A2 _6198_/B1 _6739_/Q _6800_/Q _6198_/C2 _6199_/A2 VDD VDD
+ VSS VSS gf180mcu_fd_sc_mcu7t5v0__oai222_1
X_5218_ _5344_/I0 _7365_/Q _5218_/S _7365_/D VDD VDD VSS VSS gf180mcu_fd_sc_mcu7t5v0__mux2_2
XFILLER_84_430 VDD VDD VSS VSS gf180mcu_fd_sc_mcu7t5v0__fill_2
X_5149_ _5352_/I0 _7296_/Q _5155_/S _7296_/D VDD VDD VSS VSS gf180mcu_fd_sc_mcu7t5v0__mux2_2
XFILLER_57_644 VDD VDD VSS VSS gf180mcu_fd_sc_mcu7t5v0__fill_2
XFILLER_72_603 VDD VDD VSS VSS gf180mcu_fd_sc_mcu7t5v0__fill_1
XFILLER_57_699 VDD VDD VSS VSS gf180mcu_fd_sc_mcu7t5v0__fill_1
XTAP_TAPCELL_ROW_84_1431 VDD VSS gf180mcu_fd_sc_mcu7t5v0__filltie
XFILLER_44_89 VDD VDD VSS VSS gf180mcu_fd_sc_mcu7t5v0__fill_1
XTAP_TAPCELL_ROW_10_403 VDD VSS gf180mcu_fd_sc_mcu7t5v0__filltie
Xclkbuf_leaf_33_clk_i clkload2/I _7692_/CLK VDD VDD VSS VSS gf180mcu_fd_sc_mcu7t5v0__clkbuf_8
XFILLER_20_290 VDD VDD VSS VSS gf180mcu_fd_sc_mcu7t5v0__fill_2
XTAP_TAPCELL_ROW_95_1582 VDD VSS gf180mcu_fd_sc_mcu7t5v0__filltie
Xclkbuf_leaf_48_clk_i clkload6/I _7055_/CLK VDD VDD VSS VSS gf180mcu_fd_sc_mcu7t5v0__clkbuf_8
XTAP_TAPCELL_ROW_95_1593 VDD VSS gf180mcu_fd_sc_mcu7t5v0__filltie
XFILLER_4_489 VDD VDD VSS VSS gf180mcu_fd_sc_mcu7t5v0__fill_1
XFILLER_76_920 VDD VDD VSS VSS gf180mcu_fd_sc_mcu7t5v0__fillcap_16
XTAP_TAPCELL_ROW_18_514 VDD VSS gf180mcu_fd_sc_mcu7t5v0__filltie
XFILLER_16_574 VDD VDD VSS VSS gf180mcu_fd_sc_mcu7t5v0__fillcap_16
XFILLER_44_872 VDD VDD VSS VSS gf180mcu_fd_sc_mcu7t5v0__fill_2
XFILLER_43_393 VDD VDD VSS VSS gf180mcu_fd_sc_mcu7t5v0__fill_1
X_4520_ _5122_/A1 _4532_/A2 _4520_/B _6974_/D VDD VDD VSS VSS gf180mcu_fd_sc_mcu7t5v0__oai21_1
X_4451_ _6940_/Q _4462_/A2 _4452_/B VDD VDD VSS VSS gf180mcu_fd_sc_mcu7t5v0__nand2_1
X_3402_ _7623_/Q _6330_/A1 VDD VDD VSS VSS gf180mcu_fd_sc_mcu7t5v0__clkinv_1
X_7170_ _7170_/D _7748_/CLK _7170_/Q VDD VDD VSS VSS gf180mcu_fd_sc_mcu7t5v0__dffq_1
X_4382_ _4550_/A1 _4392_/A2 _4382_/B _6905_/D VDD VDD VSS VSS gf180mcu_fd_sc_mcu7t5v0__oai21_1
X_6121_ _6121_/A1 _6121_/A2 _6121_/B _6122_/B1 VDD VDD VSS VSS gf180mcu_fd_sc_mcu7t5v0__oai21_1
XTAP_TAPCELL_ROW_55_1032 VDD VSS gf180mcu_fd_sc_mcu7t5v0__filltie
XFILLER_86_706 VDD VDD VSS VSS gf180mcu_fd_sc_mcu7t5v0__fill_2
XFILLER_112_354 VDD VDD VSS VSS gf180mcu_fd_sc_mcu7t5v0__fill_1
XPHY_EDGE_ROW_7_Right_7 VDD VSS gf180mcu_fd_sc_mcu7t5v0__endcap
X_6052_ _6052_/A1 _6052_/A2 _6052_/B1 _6052_/B2 _6237_/B _6059_/B VDD VDD VSS VSS
+ gf180mcu_fd_sc_mcu7t5v0__oai221_1
X_5003_ _7216_/Q _5008_/A2 _5004_/B VDD VDD VSS VSS gf180mcu_fd_sc_mcu7t5v0__nand2_1
Xload_slew186 _5075_/A2 _5074_/A2 VDD VDD VSS VSS gf180mcu_fd_sc_mcu7t5v0__buf_2
X_6954_ _6954_/D _7667_/CLK _6954_/Q VDD VDD VSS VSS gf180mcu_fd_sc_mcu7t5v0__dffq_1
XFILLER_41_308 VDD VDD VSS VSS gf180mcu_fd_sc_mcu7t5v0__fill_2
X_5905_ _5905_/A1 _5905_/A2 _5937_/A1 VDD VDD VSS VSS gf180mcu_fd_sc_mcu7t5v0__nor2_1
X_6885_ _6885_/D _7148_/CLK _6885_/Q VDD VDD VSS VSS gf180mcu_fd_sc_mcu7t5v0__dffq_1
XFILLER_22_544 VDD VDD VSS VSS gf180mcu_fd_sc_mcu7t5v0__fillcap_32
XFILLER_34_393 VDD VDD VSS VSS gf180mcu_fd_sc_mcu7t5v0__fill_2
XFILLER_50_820 VDD VDD VSS VSS gf180mcu_fd_sc_mcu7t5v0__fill_1
XTAP_TAPCELL_ROW_66_1183 VDD VSS gf180mcu_fd_sc_mcu7t5v0__filltie
X_5836_ _6975_/Q _6092_/A2 _6092_/B1 _6982_/Q _6996_/Q _5969_/B1 _5840_/A2 VDD VDD
+ VSS VSS gf180mcu_fd_sc_mcu7t5v0__oai222_1
X_5767_ _7065_/Q _6192_/A2 _6233_/B1 _6988_/Q _6834_/Q _6008_/B1 _5768_/A2 VDD VDD
+ VSS VSS gf180mcu_fd_sc_mcu7t5v0__oai222_1
X_4718_ wire268/Z _4728_/A2 _4718_/B _7073_/D VDD VDD VSS VSS gf180mcu_fd_sc_mcu7t5v0__oai21_1
X_7506_ _7506_/D _7764_/RN _7765_/CLK _7506_/Q VDD VDD VSS VSS gf180mcu_fd_sc_mcu7t5v0__dffsnq_1
X_5698_ input33/Z _5738_/A2 _5698_/B _7564_/D VDD VDD VSS VSS gf180mcu_fd_sc_mcu7t5v0__aoi21_1
X_4649_ _7039_/Q _4658_/A2 _4650_/B VDD VDD VSS VSS gf180mcu_fd_sc_mcu7t5v0__nand2_1
X_7437_ _7437_/D clkload7/I _7437_/Q VDD VDD VSS VSS gf180mcu_fd_sc_mcu7t5v0__dffq_1
XFILLER_104_800 VDD VDD VSS VSS gf180mcu_fd_sc_mcu7t5v0__fillcap_4
XFILLER_89_500 VDD VDD VSS VSS gf180mcu_fd_sc_mcu7t5v0__fill_2
X_7368_ _7368_/D _7735_/CLK _7368_/Q VDD VDD VSS VSS gf180mcu_fd_sc_mcu7t5v0__dffq_1
X_7299_ _7299_/D _7505_/CLK _7299_/Q VDD VDD VSS VSS gf180mcu_fd_sc_mcu7t5v0__dffq_1
X_6319_ input32/Z _6326_/A2 _6320_/B VDD VDD VSS VSS gf180mcu_fd_sc_mcu7t5v0__nand2_1
XFILLER_104_899 VDD VDD VSS VSS gf180mcu_fd_sc_mcu7t5v0__fillcap_4
XFILLER_49_419 VDD VDD VSS VSS gf180mcu_fd_sc_mcu7t5v0__fill_1
XFILLER_58_942 VDD VDD VSS VSS gf180mcu_fd_sc_mcu7t5v0__fill_2
XFILLER_85_772 VDD VDD VSS VSS gf180mcu_fd_sc_mcu7t5v0__fill_1
XFILLER_73_912 VDD VDD VSS VSS gf180mcu_fd_sc_mcu7t5v0__fill_2
XFILLER_73_923 VDD VDD VSS VSS gf180mcu_fd_sc_mcu7t5v0__fillcap_32
XFILLER_41_842 VDD VDD VSS VSS gf180mcu_fd_sc_mcu7t5v0__fillcap_64
XTAP_TAPCELL_ROW_43_859 VDD VSS gf180mcu_fd_sc_mcu7t5v0__filltie
XFILLER_9_515 VDD VDD VSS VSS gf180mcu_fd_sc_mcu7t5v0__fill_1
XFILLER_9_559 VDD VDD VSS VSS gf180mcu_fd_sc_mcu7t5v0__fill_1
XTAP_TAPCELL_ROW_23_583 VDD VSS gf180mcu_fd_sc_mcu7t5v0__filltie
XTAP_TAPCELL_ROW_97_1622 VDD VSS gf180mcu_fd_sc_mcu7t5v0__filltie
XTAP_TAPCELL_ROW_97_1611 VDD VSS gf180mcu_fd_sc_mcu7t5v0__filltie
XFILLER_114_619 VDD VDD VSS VSS gf180mcu_fd_sc_mcu7t5v0__fill_2
XFILLER_110_803 VDD VDD VSS VSS gf180mcu_fd_sc_mcu7t5v0__fill_2
XFILLER_95_558 VDD VDD VSS VSS gf180mcu_fd_sc_mcu7t5v0__fill_2
XFILLER_91_731 VDD VDD VSS VSS gf180mcu_fd_sc_mcu7t5v0__fill_2
XPHY_EDGE_ROW_11_Left_130 VDD VSS gf180mcu_fd_sc_mcu7t5v0__endcap
XTAP_TAPCELL_ROW_106_1740 VDD VSS gf180mcu_fd_sc_mcu7t5v0__filltie
X_3951_ _4150_/A1 _4012_/A1 _4280_/A2 VDD VDD VSS VSS gf180mcu_fd_sc_mcu7t5v0__nand2_1
XFILLER_16_382 VDD VDD VSS VSS gf180mcu_fd_sc_mcu7t5v0__fill_2
X_6670_ _7540_/Q _6670_/A2 _6671_/A2 VDD VDD VSS VSS gf180mcu_fd_sc_mcu7t5v0__nand2_1
X_3882_ _7651_/Q _3879_/Z _3882_/Z VDD VDD VSS VSS gf180mcu_fd_sc_mcu7t5v0__xor2_1
X_5621_ _5621_/A1 _5554_/Z _5620_/Z _5625_/A1 VDD VDD VSS VSS gf180mcu_fd_sc_mcu7t5v0__xnor3_1
X_5552_ _5549_/C _5552_/A2 _5552_/A3 _5552_/B _5553_/B1 VDD VDD VSS VSS gf180mcu_fd_sc_mcu7t5v0__oai31_1
X_4503_ _6966_/Q _4504_/A2 _4504_/B VDD VDD VSS VSS gf180mcu_fd_sc_mcu7t5v0__nand2_1
XFILLER_105_619 VDD VDD VSS VSS gf180mcu_fd_sc_mcu7t5v0__fill_2
X_5483_ _7306_/Q _5515_/A2 _5516_/C2 _7313_/Q _5485_/A1 VDD VDD VSS VSS gf180mcu_fd_sc_mcu7t5v0__oai22_1
XTAP_TAPCELL_ROW_117_1891 VDD VSS gf180mcu_fd_sc_mcu7t5v0__filltie
X_4434_ wire292/Z _4434_/A2 _4434_/B _6931_/D VDD VDD VSS VSS gf180mcu_fd_sc_mcu7t5v0__oai21_1
X_7222_ _7222_/D _7266_/CLK _7222_/Q VDD VDD VSS VSS gf180mcu_fd_sc_mcu7t5v0__dffq_1
X_4365_ _6897_/Q _4378_/A2 _4366_/B VDD VDD VSS VSS gf180mcu_fd_sc_mcu7t5v0__nand2_1
X_7153_ _7153_/D _7233_/CLK _7153_/Q VDD VDD VSS VSS gf180mcu_fd_sc_mcu7t5v0__dffq_1
X_7084_ _7084_/D _7101_/CLK _7084_/Q VDD VDD VSS VSS gf180mcu_fd_sc_mcu7t5v0__dffq_1
Xfanout527 _5235_/I0 _5347_/I0 VDD VDD VSS VSS gf180mcu_fd_sc_mcu7t5v0__dlyd_1
Xfanout538 _7639_/Q fanout538/Z VDD VDD VSS VSS gf180mcu_fd_sc_mcu7t5v0__dlyd_1
Xfanout516 _7644_/Q wire517/I VDD VDD VSS VSS gf180mcu_fd_sc_mcu7t5v0__dlyd_1
X_6104_ _7154_/Q _6104_/A2 _6104_/B1 _7133_/Q _6174_/B _6105_/A2 VDD VDD VSS VSS gf180mcu_fd_sc_mcu7t5v0__oai221_1
X_6035_ _6894_/Q _6076_/B1 _6212_/C _6037_/A1 VDD VDD VSS VSS gf180mcu_fd_sc_mcu7t5v0__oai21_1
XFILLER_98_396 VDD VDD VSS VSS gf180mcu_fd_sc_mcu7t5v0__fill_2
X_4296_ _4324_/A1 _4308_/A2 _4296_/B _6862_/D VDD VDD VSS VSS gf180mcu_fd_sc_mcu7t5v0__oai21_1
XFILLER_55_901 VDD VDD VSS VSS gf180mcu_fd_sc_mcu7t5v0__fillcap_8
XFILLER_55_912 VDD VDD VSS VSS gf180mcu_fd_sc_mcu7t5v0__fillcap_64
XTAP_TAPCELL_ROW_68_1212 VDD VSS gf180mcu_fd_sc_mcu7t5v0__filltie
XTAP_TAPCELL_ROW_1_267 VDD VSS gf180mcu_fd_sc_mcu7t5v0__filltie
XTAP_TAPCELL_ROW_1_278 VDD VSS gf180mcu_fd_sc_mcu7t5v0__filltie
X_6937_ _6937_/D _6944_/CLK _6937_/Q VDD VDD VSS VSS gf180mcu_fd_sc_mcu7t5v0__dffq_1
XFILLER_23_842 VDD VDD VSS VSS gf180mcu_fd_sc_mcu7t5v0__fillcap_64
X_6868_ _6868_/D _6882_/CLK _6868_/Q VDD VDD VSS VSS gf180mcu_fd_sc_mcu7t5v0__dffq_1
XTAP_TAPCELL_ROW_40_818 VDD VSS gf180mcu_fd_sc_mcu7t5v0__filltie
XFILLER_22_374 VDD VDD VSS VSS gf180mcu_fd_sc_mcu7t5v0__fill_1
X_5819_ _5748_/Z _5819_/A2 _5819_/B1 _5819_/B2 _5819_/C _5820_/B2 VDD VDD VSS VSS
+ gf180mcu_fd_sc_mcu7t5v0__oai221_1
X_6799_ _6799_/D _7261_/CLK _6799_/Q VDD VDD VSS VSS gf180mcu_fd_sc_mcu7t5v0__dffq_1
XTAP_TAPCELL_ROW_20_542 VDD VSS gf180mcu_fd_sc_mcu7t5v0__filltie
XTAP_TAPCELL_ROW_79_1363 VDD VSS gf180mcu_fd_sc_mcu7t5v0__filltie
XTAP_TAPCELL_ROW_92_1552 VDD VSS gf180mcu_fd_sc_mcu7t5v0__filltie
XTAP_TAPCELL_ROW_92_1541 VDD VSS gf180mcu_fd_sc_mcu7t5v0__filltie
XFILLER_1_212 VDD VDD VSS VSS gf180mcu_fd_sc_mcu7t5v0__fill_2
XTAP_TAPCELL_ROW_9_389 VDD VSS gf180mcu_fd_sc_mcu7t5v0__filltie
XTAP_TAPCELL_ROW_9_378 VDD VSS gf180mcu_fd_sc_mcu7t5v0__filltie
XTAP_TAPCELL_ROW_48_929 VDD VSS gf180mcu_fd_sc_mcu7t5v0__filltie
XFILLER_58_772 VDD VDD VSS VSS gf180mcu_fd_sc_mcu7t5v0__fillcap_4
XFILLER_57_282 VDD VDD VSS VSS gf180mcu_fd_sc_mcu7t5v0__fill_2
XFILLER_73_786 VDD VDD VSS VSS gf180mcu_fd_sc_mcu7t5v0__fill_1
XFILLER_17_168 VDD VDD VSS VSS gf180mcu_fd_sc_mcu7t5v0__fill_1
XFILLER_17_157 VDD VDD VSS VSS gf180mcu_fd_sc_mcu7t5v0__fill_1
XTAP_TAPCELL_ROW_28_653 VDD VSS gf180mcu_fd_sc_mcu7t5v0__filltie
XTAP_TAPCELL_ROW_101_1670 VDD VSS gf180mcu_fd_sc_mcu7t5v0__filltie
XFILLER_115_906 VDD VDD VSS VSS gf180mcu_fd_sc_mcu7t5v0__fillcap_4
XFILLER_5_562 VDD VDD VSS VSS gf180mcu_fd_sc_mcu7t5v0__fillcap_64
XFILLER_5_551 VDD VDD VSS VSS gf180mcu_fd_sc_mcu7t5v0__fillcap_8
Xoutput108 _7877_/Z alert_tx_o[0] VDD VDD VSS VSS gf180mcu_fd_sc_mcu7t5v0__dlyd_1
Xoutput119 _7803_/Q intr_tx_watermark_o VDD VDD VSS VSS gf180mcu_fd_sc_mcu7t5v0__dlyd_1
X_4150_ _4150_/A1 _4150_/A2 _5134_/A2 VDD VDD VSS VSS gf180mcu_fd_sc_mcu7t5v0__nand2_1
XFILLER_96_845 VDD VDD VSS VSS gf180mcu_fd_sc_mcu7t5v0__fill_1
XFILLER_95_311 VDD VDD VSS VSS gf180mcu_fd_sc_mcu7t5v0__fill_2
X_4081_ _4110_/A1 _4081_/A2 _4826_/A2 VDD VDD VSS VSS gf180mcu_fd_sc_mcu7t5v0__nand2_1
XFILLER_37_912 VDD VDD VSS VSS gf180mcu_fd_sc_mcu7t5v0__fillcap_64
XFILLER_48_260 VDD VDD VSS VSS gf180mcu_fd_sc_mcu7t5v0__fill_1
X_7771_ _7771_/D _7822_/RN _7822_/CLK _7771_/Q VDD VDD VSS VSS gf180mcu_fd_sc_mcu7t5v0__dffrnq_1
X_4983_ _7206_/Q _4994_/A2 _4984_/B VDD VDD VSS VSS gf180mcu_fd_sc_mcu7t5v0__nand2_1
XFILLER_20_801 VDD VDD VSS VSS gf180mcu_fd_sc_mcu7t5v0__fillcap_4
X_6722_ _7759_/Q _3777_/Z _7760_/Q _6723_/A2 VDD VDD VSS VSS gf180mcu_fd_sc_mcu7t5v0__aoi21_1
X_3934_ _7792_/Q _6679_/I0 _3933_/Z _5699_/A2 VDD VDD VSS VSS gf180mcu_fd_sc_mcu7t5v0__nand3_1
XTAP_TAPCELL_ROW_63_1142 VDD VSS gf180mcu_fd_sc_mcu7t5v0__filltie
X_6653_ _4155_/Z _6653_/A2 _6654_/A2 VDD VDD VSS VSS gf180mcu_fd_sc_mcu7t5v0__nand2_1
XFILLER_32_661 VDD VDD VSS VSS gf180mcu_fd_sc_mcu7t5v0__fillcap_4
X_3865_ _6679_/I0 _7752_/Q _3865_/B _3865_/ZN VDD VDD VSS VSS gf180mcu_fd_sc_mcu7t5v0__oai21_2
XFILLER_60_981 VDD VDD VSS VSS gf180mcu_fd_sc_mcu7t5v0__fill_1
X_5604_ _6831_/Q _5604_/A2 _5607_/A2 _6830_/Q _6828_/Q wire420/I _5605_/A2 VDD VDD
+ VSS VSS gf180mcu_fd_sc_mcu7t5v0__oai222_1
XFILLER_118_711 VDD VDD VSS VSS gf180mcu_fd_sc_mcu7t5v0__fill_2
X_3796_ input29/Z _5690_/A2 _3797_/A3 VDD VDD VSS VSS gf180mcu_fd_sc_mcu7t5v0__nand2_1
X_6584_ _6122_/C _6231_/C _6600_/A2 _6605_/A2 VDD VDD VSS VSS gf180mcu_fd_sc_mcu7t5v0__nor3_1
X_5535_ _7308_/Q _5613_/B1 _5610_/C2 _7315_/Q _7329_/Q _5535_/C2 _5539_/A2 VDD VDD
+ VSS VSS gf180mcu_fd_sc_mcu7t5v0__oai222_1
X_5466_ _7510_/Q _6733_/A4 _5496_/A1 VDD VDD VSS VSS gf180mcu_fd_sc_mcu7t5v0__nand2_1
X_4417_ _6923_/Q _4420_/A2 _4418_/B VDD VDD VSS VSS gf180mcu_fd_sc_mcu7t5v0__nand2_1
X_7205_ _7205_/D _7251_/CLK _7205_/Q VDD VDD VSS VSS gf180mcu_fd_sc_mcu7t5v0__dffq_1
X_5397_ _5590_/B _5397_/A2 _5397_/A3 _5397_/B _5398_/B2 VDD VDD VSS VSS gf180mcu_fd_sc_mcu7t5v0__oai31_1
X_4348_ _5132_/A1 _4350_/A2 _4348_/B _6888_/D VDD VDD VSS VSS gf180mcu_fd_sc_mcu7t5v0__oai21_1
Xfanout346 _6228_/A2 fanout346/Z VDD VDD VSS VSS gf180mcu_fd_sc_mcu7t5v0__dlyd_1
XTAP_TAPCELL_ROW_74_1293 VDD VSS gf180mcu_fd_sc_mcu7t5v0__filltie
XTAP_TAPCELL_ROW_6_348 VDD VSS gf180mcu_fd_sc_mcu7t5v0__filltie
XTAP_TAPCELL_ROW_6_337 VDD VSS gf180mcu_fd_sc_mcu7t5v0__filltie
X_7136_ _7136_/D _7233_/CLK _7136_/Q VDD VDD VSS VSS gf180mcu_fd_sc_mcu7t5v0__dffq_1
Xfanout335 _6590_/A2 _6227_/A2 VDD VDD VSS VSS gf180mcu_fd_sc_mcu7t5v0__dlyd_1
X_4279_ _6854_/Q _4280_/A2 _4280_/B VDD VDD VSS VSS gf180mcu_fd_sc_mcu7t5v0__nand2_1
X_7067_ _7067_/D _7252_/CLK _7067_/Q VDD VDD VSS VSS gf180mcu_fd_sc_mcu7t5v0__dffq_1
Xfanout368 _5612_/B1 _5603_/A2 VDD VDD VSS VSS gf180mcu_fd_sc_mcu7t5v0__dlyd_1
X_6018_ _6880_/Q _6198_/A2 _6076_/A2 _6873_/Q _6221_/B _6019_/A2 VDD VDD VSS VSS gf180mcu_fd_sc_mcu7t5v0__oai221_1
XTAP_TAPCELL_ROW_25_612 VDD VSS gf180mcu_fd_sc_mcu7t5v0__filltie
XFILLER_27_499 VDD VDD VSS VSS gf180mcu_fd_sc_mcu7t5v0__fill_1
XTAP_TAPCELL_ROW_53_998 VDD VSS gf180mcu_fd_sc_mcu7t5v0__filltie
XFILLER_2_521 VDD VDD VSS VSS gf180mcu_fd_sc_mcu7t5v0__fillcap_4
XFILLER_78_812 VDD VDD VSS VSS gf180mcu_fd_sc_mcu7t5v0__fill_1
XFILLER_19_912 VDD VDD VSS VSS gf180mcu_fd_sc_mcu7t5v0__fillcap_64
XFILLER_46_731 VDD VDD VSS VSS gf180mcu_fd_sc_mcu7t5v0__fillcap_4
XFILLER_73_572 VDD VDD VSS VSS gf180mcu_fd_sc_mcu7t5v0__fillcap_4
XFILLER_45_296 VDD VDD VSS VSS gf180mcu_fd_sc_mcu7t5v0__fill_2
XFILLER_61_734 VDD VDD VSS VSS gf180mcu_fd_sc_mcu7t5v0__fill_2
XFILLER_61_745 VDD VDD VSS VSS gf180mcu_fd_sc_mcu7t5v0__fill_1
XFILLER_14_661 VDD VDD VSS VSS gf180mcu_fd_sc_mcu7t5v0__fillcap_4
XFILLER_42_981 VDD VDD VSS VSS gf180mcu_fd_sc_mcu7t5v0__fill_1
XFILLER_13_171 VDD VDD VSS VSS gf180mcu_fd_sc_mcu7t5v0__fill_2
X_3650_ _3559_/Z _3562_/Z _3565_/Z _3650_/Z VDD VDD VSS VSS gf180mcu_fd_sc_mcu7t5v0__xor3_1
X_3581_ input57/Z input64/Z _3580_/Z _3581_/Z VDD VDD VSS VSS gf180mcu_fd_sc_mcu7t5v0__xor3_1
X_5320_ _5341_/I0 _7467_/Q _5323_/S _7467_/D VDD VDD VSS VSS gf180mcu_fd_sc_mcu7t5v0__mux2_2
XFILLER_6_871 VDD VDD VSS VSS gf180mcu_fd_sc_mcu7t5v0__fillcap_4
XTAP_TAPCELL_ROW_114_1850 VDD VSS gf180mcu_fd_sc_mcu7t5v0__filltie
X_5251_ wire521/Z _7398_/Q _5253_/S _7398_/D VDD VDD VSS VSS gf180mcu_fd_sc_mcu7t5v0__mux2_2
XFILLER_115_769 VDD VDD VSS VSS gf180mcu_fd_sc_mcu7t5v0__fill_1
XTAP_TAPCELL_ROW_114_1861 VDD VSS gf180mcu_fd_sc_mcu7t5v0__filltie
X_4202_ _7735_/Q _7736_/Q _4212_/A2 VDD VDD VSS VSS gf180mcu_fd_sc_mcu7t5v0__nand2_1
X_5182_ wire517/Z _7329_/Q _5183_/S _7329_/D VDD VDD VSS VSS gf180mcu_fd_sc_mcu7t5v0__mux2_2
XTAP_TAPCELL_ROW_3_307 VDD VSS gf180mcu_fd_sc_mcu7t5v0__filltie
X_4133_ _6795_/Q _5050_/A2 _4134_/B VDD VDD VSS VSS gf180mcu_fd_sc_mcu7t5v0__nand2_1
X_4064_ _6773_/Q _4742_/A2 _4065_/B VDD VDD VSS VSS gf180mcu_fd_sc_mcu7t5v0__nand2_1
X_7823_ _7823_/D _7823_/RN _7823_/CLK _7878_/I VDD VDD VSS VSS gf180mcu_fd_sc_mcu7t5v0__dffrnq_1
XFILLER_52_734 VDD VDD VSS VSS gf180mcu_fd_sc_mcu7t5v0__fill_1
X_7754_ _7754_/D _7755_/RN _7754_/CLK _7754_/Q VDD VDD VSS VSS gf180mcu_fd_sc_mcu7t5v0__dffrnq_1
X_6705_ _6705_/I _7750_/D VDD VDD VSS VSS gf180mcu_fd_sc_mcu7t5v0__clkinv_1
X_4966_ _5008_/A1 _4966_/A2 _4966_/B _7197_/D VDD VDD VSS VSS gf180mcu_fd_sc_mcu7t5v0__oai21_1
X_3917_ _3915_/Z _3916_/Z _3917_/Z VDD VDD VSS VSS gf180mcu_fd_sc_mcu7t5v0__xor2_1
X_7685_ _7685_/D _7802_/RN _7692_/CLK _7685_/Q VDD VDD VSS VSS gf180mcu_fd_sc_mcu7t5v0__dffrnq_1
XTAP_TAPCELL_ROW_50_957 VDD VSS gf180mcu_fd_sc_mcu7t5v0__filltie
X_4897_ _7163_/Q _4910_/A2 _4898_/B VDD VDD VSS VSS gf180mcu_fd_sc_mcu7t5v0__nand2_1
X_3848_ _7786_/Q input5/Z _7520_/Q _3848_/Z VDD VDD VSS VSS gf180mcu_fd_sc_mcu7t5v0__mux2_2
X_6636_ _6654_/B _6636_/A2 _6635_/Z _7728_/D VDD VDD VSS VSS gf180mcu_fd_sc_mcu7t5v0__nor3_1
X_3779_ _7790_/D _7537_/Q _7789_/D _3781_/A2 VDD VDD VSS VSS gf180mcu_fd_sc_mcu7t5v0__aoi21_1
XTAP_TAPCELL_ROW_30_681 VDD VSS gf180mcu_fd_sc_mcu7t5v0__filltie
X_6567_ _7702_/Q _7701_/Q _6569_/S _7702_/D VDD VDD VSS VSS gf180mcu_fd_sc_mcu7t5v0__mux2_2
XTAP_TAPCELL_ROW_76_1322 VDD VSS gf180mcu_fd_sc_mcu7t5v0__filltie
X_5518_ _5549_/C _5518_/A2 _5518_/A3 _5584_/S _5519_/B1 VDD VDD VSS VSS gf180mcu_fd_sc_mcu7t5v0__oai31_1
X_6498_ _7675_/Q _6495_/Z _6502_/A2 VDD VDD VSS VSS gf180mcu_fd_sc_mcu7t5v0__nand2_1
X_5449_ _5590_/B _5449_/A2 _5449_/A3 _5458_/B1 VDD VDD VSS VSS gf180mcu_fd_sc_mcu7t5v0__nor3_1
X_7119_ _7119_/D _7196_/CLK _7119_/Q VDD VDD VSS VSS gf180mcu_fd_sc_mcu7t5v0__dffq_1
Xfanout198 _5883_/ZN _6274_/B1 VDD VDD VSS VSS gf180mcu_fd_sc_mcu7t5v0__dlyd_1
XFILLER_75_837 VDD VDD VSS VSS gf180mcu_fd_sc_mcu7t5v0__fill_2
XFILLER_90_807 VDD VDD VSS VSS gf180mcu_fd_sc_mcu7t5v0__fill_2
XFILLER_74_325 VDD VDD VSS VSS gf180mcu_fd_sc_mcu7t5v0__fill_2
XFILLER_28_731 VDD VDD VSS VSS gf180mcu_fd_sc_mcu7t5v0__fillcap_4
XFILLER_62_509 VDD VDD VSS VSS gf180mcu_fd_sc_mcu7t5v0__fill_2
XTAP_TAPCELL_ROW_87_1473 VDD VSS gf180mcu_fd_sc_mcu7t5v0__filltie
XTAP_TAPCELL_ROW_38_792 VDD VSS gf180mcu_fd_sc_mcu7t5v0__filltie
XFILLER_43_767 VDD VDD VSS VSS gf180mcu_fd_sc_mcu7t5v0__fill_2
XFILLER_24_981 VDD VDD VSS VSS gf180mcu_fd_sc_mcu7t5v0__fill_1
XFILLER_70_597 VDD VDD VSS VSS gf180mcu_fd_sc_mcu7t5v0__fillcap_4
Xwire500 _6569_/S _6566_/S VDD VDD VSS VSS gf180mcu_fd_sc_mcu7t5v0__clkbuf_4
Xload_slew505 _4234_/I0 _4238_/I0 VDD VDD VSS VSS gf180mcu_fd_sc_mcu7t5v0__buf_4
XFILLER_2_384 VDD VDD VSS VSS gf180mcu_fd_sc_mcu7t5v0__fill_1
Xload_slew549 _7764_/RN _7810_/RN VDD VDD VSS VSS gf180mcu_fd_sc_mcu7t5v0__clkbuf_4
XFILLER_93_689 VDD VDD VSS VSS gf180mcu_fd_sc_mcu7t5v0__fill_2
XFILLER_74_870 VDD VDD VSS VSS gf180mcu_fd_sc_mcu7t5v0__fillcap_4
XFILLER_92_177 VDD VDD VSS VSS gf180mcu_fd_sc_mcu7t5v0__fill_1
X_4820_ _4988_/A1 _4826_/A2 _4820_/B _7124_/D VDD VDD VSS VSS gf180mcu_fd_sc_mcu7t5v0__oai21_1
XTAP_TAPCELL_ROW_60_1101 VDD VSS gf180mcu_fd_sc_mcu7t5v0__filltie
X_4751_ _7090_/Q _4756_/A2 _4752_/B VDD VDD VSS VSS gf180mcu_fd_sc_mcu7t5v0__nand2_1
XTAP_TAPCELL_ROW_16_486 VDD VSS gf180mcu_fd_sc_mcu7t5v0__filltie
X_4682_ _4752_/A1 _4686_/A2 _4682_/B _7055_/D VDD VDD VSS VSS gf180mcu_fd_sc_mcu7t5v0__oai21_1
X_3702_ _3775_/A2 _3702_/A2 _3702_/A3 _3702_/Z VDD VDD VSS VSS gf180mcu_fd_sc_mcu7t5v0__or3_1
X_7470_ _7470_/D _7490_/CLK _7470_/Q VDD VDD VSS VSS gf180mcu_fd_sc_mcu7t5v0__dffq_1
X_6421_ _6421_/A1 _6421_/A2 _6421_/A3 _6421_/B _6426_/A2 VDD VDD VSS VSS gf180mcu_fd_sc_mcu7t5v0__oai31_1
X_3633_ input88/Z input91/Z _3615_/Z _3633_/Z VDD VDD VSS VSS gf180mcu_fd_sc_mcu7t5v0__xor3_1
X_6352_ _7638_/Q input55/Z _6352_/S _7638_/D VDD VDD VSS VSS gf180mcu_fd_sc_mcu7t5v0__mux2_2
X_3564_ input25/Z input26/Z _3563_/Z _3564_/Z VDD VDD VSS VSS gf180mcu_fd_sc_mcu7t5v0__xor3_1
XFILLER_89_907 VDD VDD VSS VSS gf180mcu_fd_sc_mcu7t5v0__fill_2
X_6283_ _7637_/Q _6283_/A2 _6283_/B1 _7802_/D _6283_/C1 _7527_/Q _6284_/B2 VDD VDD
+ VSS VSS gf180mcu_fd_sc_mcu7t5v0__aoi222_1
X_5303_ _5303_/I0 _7450_/Q _5309_/S _7450_/D VDD VDD VSS VSS gf180mcu_fd_sc_mcu7t5v0__mux2_2
XTAP_TAPCELL_ROW_58_1074 VDD VSS gf180mcu_fd_sc_mcu7t5v0__filltie
X_3495_ _3925_/A2 _3500_/A2 _7799_/D VDD VDD VSS VSS gf180mcu_fd_sc_mcu7t5v0__xor2_1
X_5234_ _5332_/I0 _7381_/Q _5239_/S _7381_/D VDD VDD VSS VSS gf180mcu_fd_sc_mcu7t5v0__mux2_2
X_5165_ _5228_/I0 _7312_/Q _5169_/S _7312_/D VDD VDD VSS VSS gf180mcu_fd_sc_mcu7t5v0__mux2_2
XTAP_TAPCELL_ROW_71_1252 VDD VSS gf180mcu_fd_sc_mcu7t5v0__filltie
XFILLER_111_772 VDD VDD VSS VSS gf180mcu_fd_sc_mcu7t5v0__fillcap_64
X_4116_ _4125_/A1 _4966_/A2 _4116_/B _6789_/D VDD VDD VSS VSS gf180mcu_fd_sc_mcu7t5v0__oai21_1
X_5096_ _5110_/A1 _5106_/A2 _5096_/B _7262_/D VDD VDD VSS VSS gf180mcu_fd_sc_mcu7t5v0__oai21_1
XPHY_EDGE_ROW_3_Left_122 VDD VSS gf180mcu_fd_sc_mcu7t5v0__endcap
X_4047_ _4132_/A1 _4053_/A2 _4672_/A2 VDD VDD VSS VSS gf180mcu_fd_sc_mcu7t5v0__nand2_1
XFILLER_65_881 VDD VDD VSS VSS gf180mcu_fd_sc_mcu7t5v0__fill_1
X_7806_ _7806_/D _7810_/RN clkload8/I _7806_/Q VDD VDD VSS VSS gf180mcu_fd_sc_mcu7t5v0__dffrnq_1
X_5998_ _5998_/A1 _5998_/A2 _5998_/B _5999_/A2 VDD VDD VSS VSS gf180mcu_fd_sc_mcu7t5v0__oai21_1
XTAP_TAPCELL_ROW_35_751 VDD VSS gf180mcu_fd_sc_mcu7t5v0__filltie
XFILLER_40_737 VDD VDD VSS VSS gf180mcu_fd_sc_mcu7t5v0__fillcap_64
X_7737_ _7737_/D _7742_/RN _7793_/CLK _7737_/Q VDD VDD VSS VSS gf180mcu_fd_sc_mcu7t5v0__dffrnq_1
X_4949_ _7189_/Q _4952_/A2 _4950_/B VDD VDD VSS VSS gf180mcu_fd_sc_mcu7t5v0__nand2_1
X_7668_ _7668_/D _7668_/RN _7668_/CLK _7668_/Q VDD VDD VSS VSS gf180mcu_fd_sc_mcu7t5v0__dffrnq_1
XPHY_EDGE_ROW_49_Left_168 VDD VSS gf180mcu_fd_sc_mcu7t5v0__endcap
X_6619_ _6619_/A1 _6617_/C _6619_/Z VDD VDD VSS VSS gf180mcu_fd_sc_mcu7t5v0__xor2_1
X_7599_ _7599_/D _7599_/RN _7613_/CLK _7599_/Q VDD VDD VSS VSS gf180mcu_fd_sc_mcu7t5v0__dffrnq_1
XFILLER_106_522 VDD VDD VSS VSS gf180mcu_fd_sc_mcu7t5v0__fill_2
XFILLER_102_783 VDD VDD VSS VSS gf180mcu_fd_sc_mcu7t5v0__fill_2
XTAP_TAPCELL_ROW_89_1502 VDD VSS gf180mcu_fd_sc_mcu7t5v0__filltie
XFILLER_48_804 VDD VDD VSS VSS gf180mcu_fd_sc_mcu7t5v0__fill_1
XPHY_EDGE_ROW_58_Left_177 VDD VSS gf180mcu_fd_sc_mcu7t5v0__endcap
XFILLER_102_794 VDD VDD VSS VSS gf180mcu_fd_sc_mcu7t5v0__fill_2
XFILLER_28_594 VDD VDD VSS VSS gf180mcu_fd_sc_mcu7t5v0__fill_1
XFILLER_62_317 VDD VDD VSS VSS gf180mcu_fd_sc_mcu7t5v0__fill_2
XFILLER_43_597 VDD VDD VSS VSS gf180mcu_fd_sc_mcu7t5v0__fill_2
XTAP_TAPCELL_ROW_13_445 VDD VSS gf180mcu_fd_sc_mcu7t5v0__filltie
XTAP_TAPCELL_ROW_13_434 VDD VSS gf180mcu_fd_sc_mcu7t5v0__filltie
XPHY_EDGE_ROW_67_Left_186 VDD VSS gf180mcu_fd_sc_mcu7t5v0__endcap
Xwire341 wire341/I wire341/Z VDD VDD VSS VSS gf180mcu_fd_sc_mcu7t5v0__clkbuf_4
XFILLER_7_432 VDD VDD VSS VSS gf180mcu_fd_sc_mcu7t5v0__fill_2
XFILLER_7_487 VDD VDD VSS VSS gf180mcu_fd_sc_mcu7t5v0__fill_2
Xload_slew302 _6197_/A2 _6140_/B1 VDD VDD VSS VSS gf180mcu_fd_sc_mcu7t5v0__buf_2
XFILLER_100_709 VDD VDD VSS VSS gf180mcu_fd_sc_mcu7t5v0__fill_1
Xload_slew324 fanout323/Z _6229_/B1 VDD VDD VSS VSS gf180mcu_fd_sc_mcu7t5v0__clkbuf_4
XPHY_EDGE_ROW_76_Left_195 VDD VSS gf180mcu_fd_sc_mcu7t5v0__endcap
Xload_slew357 _6144_/A2 _6154_/A2 VDD VDD VSS VSS gf180mcu_fd_sc_mcu7t5v0__buf_4
Xload_slew379 _5412_/B1 _5607_/A2 VDD VDD VSS VSS gf180mcu_fd_sc_mcu7t5v0__clkbuf_4
XFILLER_93_431 VDD VDD VSS VSS gf180mcu_fd_sc_mcu7t5v0__fill_1
XFILLER_38_325 VDD VDD VSS VSS gf180mcu_fd_sc_mcu7t5v0__fill_2
X_6970_ _6970_/D _7687_/CLK _6970_/Q VDD VDD VSS VSS gf180mcu_fd_sc_mcu7t5v0__dffq_1
XFILLER_54_807 VDD VDD VSS VSS gf180mcu_fd_sc_mcu7t5v0__fillcap_4
XFILLER_66_667 VDD VDD VSS VSS gf180mcu_fd_sc_mcu7t5v0__fillcap_4
XTAP_TAPCELL_ROW_109_1782 VDD VSS gf180mcu_fd_sc_mcu7t5v0__filltie
X_5921_ _6871_/Q wire341/Z _6177_/C2 _6857_/Q _5923_/A1 VDD VDD VSS VSS gf180mcu_fd_sc_mcu7t5v0__oai22_1
XFILLER_65_199 VDD VDD VSS VSS gf180mcu_fd_sc_mcu7t5v0__fill_1
X_5852_ _7094_/Q _6097_/A2 wire353/Z _7087_/Q _7080_/Q _6112_/A2 _5853_/A2 VDD VDD
+ VSS VSS gf180mcu_fd_sc_mcu7t5v0__oai222_1
XFILLER_34_564 VDD VDD VSS VSS gf180mcu_fd_sc_mcu7t5v0__fillcap_16
XFILLER_22_737 VDD VDD VSS VSS gf180mcu_fd_sc_mcu7t5v0__fillcap_64
XTAP_TAPCELL_ROW_32_710 VDD VSS gf180mcu_fd_sc_mcu7t5v0__filltie
XFILLER_34_597 VDD VDD VSS VSS gf180mcu_fd_sc_mcu7t5v0__fillcap_64
X_5783_ _7212_/Q _6233_/A2 wire353/Z _7205_/Q _7191_/Q _6098_/A2 _5784_/A2 VDD VDD
+ VSS VSS gf180mcu_fd_sc_mcu7t5v0__oai222_1
X_4803_ _7116_/Q _4812_/A2 _4804_/B VDD VDD VSS VSS gf180mcu_fd_sc_mcu7t5v0__nand2_1
X_7522_ _7522_/D _7657_/RN _7695_/CLK _7522_/Q VDD VDD VSS VSS gf180mcu_fd_sc_mcu7t5v0__dffrnq_1
X_4734_ _4762_/A1 _4742_/A2 _4734_/B _7081_/D VDD VDD VSS VSS gf180mcu_fd_sc_mcu7t5v0__oai21_1
XFILLER_21_258 VDD VDD VSS VSS gf180mcu_fd_sc_mcu7t5v0__fill_1
X_4665_ _7047_/Q _4672_/A2 _4666_/B VDD VDD VSS VSS gf180mcu_fd_sc_mcu7t5v0__nand2_1
X_7453_ _7453_/D _7453_/CLK _7453_/Q VDD VDD VSS VSS gf180mcu_fd_sc_mcu7t5v0__dffq_1
X_3616_ input91/Z input90/Z input89/Z _3616_/Z VDD VDD VSS VSS gf180mcu_fd_sc_mcu7t5v0__xor3_1
X_6404_ _7660_/Q _6479_/S _6408_/B VDD VDD VSS VSS gf180mcu_fd_sc_mcu7t5v0__nor2_1
X_4596_ _5100_/A1 _4602_/A2 _4596_/B _7012_/D VDD VDD VSS VSS gf180mcu_fd_sc_mcu7t5v0__oai21_1
X_7384_ _7384_/D _7472_/CLK _7384_/Q VDD VDD VSS VSS gf180mcu_fd_sc_mcu7t5v0__dffq_1
X_3547_ _3543_/Z _3544_/Z _3546_/Z _3547_/Z VDD VDD VSS VSS gf180mcu_fd_sc_mcu7t5v0__xor3_1
XFILLER_89_715 VDD VDD VSS VSS gf180mcu_fd_sc_mcu7t5v0__fillcap_4
X_6335_ _7627_/Q input43/Z _6341_/S _7627_/D VDD VDD VSS VSS gf180mcu_fd_sc_mcu7t5v0__mux2_2
X_6266_ _7629_/Q _6285_/A2 _6268_/B1 _7710_/Q _6267_/B2 VDD VDD VSS VSS gf180mcu_fd_sc_mcu7t5v0__aoi22_1
X_3478_ _3962_/A2 _7713_/Q _3480_/A2 VDD VDD VSS VSS gf180mcu_fd_sc_mcu7t5v0__nand2_1
X_6197_ _6801_/Q _6197_/A2 _6197_/B _6199_/A1 VDD VDD VSS VSS gf180mcu_fd_sc_mcu7t5v0__oai21_1
X_5217_ _5343_/I0 _7364_/Q _5218_/S _7364_/D VDD VDD VSS VSS gf180mcu_fd_sc_mcu7t5v0__mux2_2
XFILLER_57_601 VDD VDD VSS VSS gf180mcu_fd_sc_mcu7t5v0__fill_2
X_5148_ wire513/Z _7295_/Q _5148_/S _7295_/D VDD VDD VSS VSS gf180mcu_fd_sc_mcu7t5v0__mux2_2
X_5079_ _7254_/Q _5092_/A2 _5080_/B VDD VDD VSS VSS gf180mcu_fd_sc_mcu7t5v0__nand2_1
XFILLER_85_965 VDD VDD VSS VSS gf180mcu_fd_sc_mcu7t5v0__fillcap_8
XTAP_TAPCELL_ROW_84_1432 VDD VSS gf180mcu_fd_sc_mcu7t5v0__filltie
XFILLER_52_350 VDD VDD VSS VSS gf180mcu_fd_sc_mcu7t5v0__fill_2
XFILLER_12_247 VDD VDD VSS VSS gf180mcu_fd_sc_mcu7t5v0__fill_1
XTAP_TAPCELL_ROW_10_404 VDD VSS gf180mcu_fd_sc_mcu7t5v0__filltie
XFILLER_4_457 VDD VDD VSS VSS gf180mcu_fd_sc_mcu7t5v0__fill_2
XTAP_TAPCELL_ROW_95_1594 VDD VSS gf180mcu_fd_sc_mcu7t5v0__filltie
XTAP_TAPCELL_ROW_95_1583 VDD VSS gf180mcu_fd_sc_mcu7t5v0__filltie
XFILLER_106_396 VDD VDD VSS VSS gf180mcu_fd_sc_mcu7t5v0__fill_2
XFILLER_95_718 VDD VDD VSS VSS gf180mcu_fd_sc_mcu7t5v0__fill_1
XFILLER_36_807 VDD VDD VSS VSS gf180mcu_fd_sc_mcu7t5v0__fillcap_64
XFILLER_75_497 VDD VDD VSS VSS gf180mcu_fd_sc_mcu7t5v0__fill_1
XTAP_TAPCELL_ROW_18_515 VDD VSS gf180mcu_fd_sc_mcu7t5v0__filltie
XTAP_TAPCELL_ROW_18_504 VDD VSS gf180mcu_fd_sc_mcu7t5v0__filltie
XFILLER_91_979 VDD VDD VSS VSS gf180mcu_fd_sc_mcu7t5v0__fill_1
XFILLER_16_542 VDD VDD VSS VSS gf180mcu_fd_sc_mcu7t5v0__fillcap_32
XFILLER_16_597 VDD VDD VSS VSS gf180mcu_fd_sc_mcu7t5v0__fillcap_64
X_4450_ _5080_/A1 _4462_/A2 _4450_/B _6939_/D VDD VDD VSS VSS gf180mcu_fd_sc_mcu7t5v0__oai21_1
X_4381_ _6905_/Q _4392_/A2 _4382_/B VDD VDD VSS VSS gf180mcu_fd_sc_mcu7t5v0__nand2_1
X_3401_ _7678_/Q _6508_/A1 VDD VDD VSS VSS gf180mcu_fd_sc_mcu7t5v0__clkinv_1
X_6120_ _7056_/Q _6154_/A2 _6120_/B _6204_/B _6121_/B VDD VDD VSS VSS gf180mcu_fd_sc_mcu7t5v0__oai211_1
XPHY_EDGE_ROW_84_Left_203 VDD VSS gf180mcu_fd_sc_mcu7t5v0__endcap
XTAP_TAPCELL_ROW_55_1022 VDD VSS gf180mcu_fd_sc_mcu7t5v0__filltie
XTAP_TAPCELL_ROW_55_1033 VDD VSS gf180mcu_fd_sc_mcu7t5v0__filltie
X_6051_ _7230_/Q _6236_/A2 _6171_/A2 _7237_/Q _7244_/Q _6235_/B1 _6052_/B2 VDD VDD
+ VSS VSS gf180mcu_fd_sc_mcu7t5v0__oai222_1
X_5002_ _5072_/A1 _5008_/A2 _5002_/B _7215_/D VDD VDD VSS VSS gf180mcu_fd_sc_mcu7t5v0__oai21_1
Xload_slew187 _6621_/C _5075_/A2 VDD VDD VSS VSS gf180mcu_fd_sc_mcu7t5v0__buf_4
XFILLER_26_317 VDD VDD VSS VSS gf180mcu_fd_sc_mcu7t5v0__fill_1
XFILLER_38_177 VDD VDD VSS VSS gf180mcu_fd_sc_mcu7t5v0__fill_2
X_6953_ _6953_/D _7003_/CLK _6953_/Q VDD VDD VSS VSS gf180mcu_fd_sc_mcu7t5v0__dffq_1
XPHY_EDGE_ROW_93_Left_212 VDD VSS gf180mcu_fd_sc_mcu7t5v0__endcap
XFILLER_82_979 VDD VDD VSS VSS gf180mcu_fd_sc_mcu7t5v0__fill_2
X_6884_ _6884_/D _6939_/CLK _6884_/Q VDD VDD VSS VSS gf180mcu_fd_sc_mcu7t5v0__dffq_1
X_5904_ _7130_/Q _6241_/A2 _6239_/B1 _7137_/Q _6229_/C _5905_/A2 VDD VDD VSS VSS gf180mcu_fd_sc_mcu7t5v0__oai221_1
X_5835_ _7003_/Q _6073_/A2 _6090_/C _5840_/A1 VDD VDD VSS VSS gf180mcu_fd_sc_mcu7t5v0__oai21_1
XTAP_TAPCELL_ROW_45_890 VDD VSS gf180mcu_fd_sc_mcu7t5v0__filltie
XTAP_TAPCELL_ROW_66_1184 VDD VSS gf180mcu_fd_sc_mcu7t5v0__filltie
X_5766_ _6911_/Q _6207_/B1 _6084_/C _5768_/A1 VDD VDD VSS VSS gf180mcu_fd_sc_mcu7t5v0__oai21_1
X_4717_ _7073_/Q _4728_/A2 _4718_/B VDD VDD VSS VSS gf180mcu_fd_sc_mcu7t5v0__nand2_1
X_7505_ _7505_/D _7505_/CLK _7505_/Q VDD VDD VSS VSS gf180mcu_fd_sc_mcu7t5v0__dffq_1
X_5697_ input33/Z _6373_/S _5697_/B _7564_/Q _5698_/B VDD VDD VSS VSS gf180mcu_fd_sc_mcu7t5v0__aoi211_1
X_4648_ _4998_/A1 _4658_/A2 _4648_/B _7038_/D VDD VDD VSS VSS gf180mcu_fd_sc_mcu7t5v0__oai21_1
X_7436_ _7436_/D _7482_/CLK _7436_/Q VDD VDD VSS VSS gf180mcu_fd_sc_mcu7t5v0__dffq_1
XFILLER_30_37 VDD VDD VSS VSS gf180mcu_fd_sc_mcu7t5v0__fill_1
X_4579_ _7004_/Q _4588_/A2 _4580_/B VDD VDD VSS VSS gf180mcu_fd_sc_mcu7t5v0__nand2_1
X_7367_ _7367_/D _7472_/CLK _7367_/Q VDD VDD VSS VSS gf180mcu_fd_sc_mcu7t5v0__dffq_1
X_7298_ _7298_/D _7504_/CLK _7298_/Q VDD VDD VSS VSS gf180mcu_fd_sc_mcu7t5v0__dffq_1
X_6318_ _7616_/Q input31/Z _6325_/S _7616_/D VDD VDD VSS VSS gf180mcu_fd_sc_mcu7t5v0__mux2_2
X_6249_ _7703_/Q _6254_/B1 _6271_/B1 _7622_/Q _6250_/A4 VDD VDD VSS VSS gf180mcu_fd_sc_mcu7t5v0__aoi22_1
XFILLER_18_807 VDD VDD VSS VSS gf180mcu_fd_sc_mcu7t5v0__fillcap_64
XFILLER_45_637 VDD VDD VSS VSS gf180mcu_fd_sc_mcu7t5v0__fillcap_4
XFILLER_73_979 VDD VDD VSS VSS gf180mcu_fd_sc_mcu7t5v0__fill_1
XTAP_TAPCELL_ROW_97_1623 VDD VSS gf180mcu_fd_sc_mcu7t5v0__filltie
XTAP_TAPCELL_ROW_97_1612 VDD VSS gf180mcu_fd_sc_mcu7t5v0__filltie
XTAP_TAPCELL_ROW_23_584 VDD VSS gf180mcu_fd_sc_mcu7t5v0__filltie
XFILLER_5_766 VDD VDD VSS VSS gf180mcu_fd_sc_mcu7t5v0__fillcap_4
XFILLER_0_482 VDD VDD VSS VSS gf180mcu_fd_sc_mcu7t5v0__fill_2
XFILLER_49_976 VDD VDD VSS VSS gf180mcu_fd_sc_mcu7t5v0__fillcap_4
XFILLER_64_979 VDD VDD VSS VSS gf180mcu_fd_sc_mcu7t5v0__fill_2
XTAP_TAPCELL_ROW_106_1741 VDD VSS gf180mcu_fd_sc_mcu7t5v0__filltie
XFILLER_51_629 VDD VDD VSS VSS gf180mcu_fd_sc_mcu7t5v0__fill_1
X_3950_ _7721_/Q _6611_/A2 _4012_/A1 VDD VDD VSS VSS gf180mcu_fd_sc_mcu7t5v0__nor2_2
XFILLER_44_681 VDD VDD VSS VSS gf180mcu_fd_sc_mcu7t5v0__fill_1
X_3881_ _6362_/B _3889_/A2 VDD VDD VSS VSS gf180mcu_fd_sc_mcu7t5v0__clkinv_1
X_5620_ _5584_/Z _5616_/Z _5620_/Z VDD VDD VSS VSS gf180mcu_fd_sc_mcu7t5v0__xor2_1
X_5551_ _7357_/Q _6632_/A1 _5594_/B1 _7343_/Q _5552_/A3 VDD VDD VSS VSS gf180mcu_fd_sc_mcu7t5v0__oai22_1
X_4502_ _5118_/A1 _4504_/A2 _4502_/B _6965_/D VDD VDD VSS VSS gf180mcu_fd_sc_mcu7t5v0__oai21_1
X_7221_ _7221_/D _7267_/CLK _7221_/Q VDD VDD VSS VSS gf180mcu_fd_sc_mcu7t5v0__dffq_1
X_5482_ _5514_/C _5482_/A2 _5482_/A3 _5492_/A2 VDD VDD VSS VSS gf180mcu_fd_sc_mcu7t5v0__nor3_1
XTAP_TAPCELL_ROW_117_1892 VDD VSS gf180mcu_fd_sc_mcu7t5v0__filltie
X_4433_ _6931_/Q _4434_/A2 _4434_/B VDD VDD VSS VSS gf180mcu_fd_sc_mcu7t5v0__nand2_1
X_4364_ _4532_/A1 _4364_/A2 _4364_/B _6896_/D VDD VDD VSS VSS gf180mcu_fd_sc_mcu7t5v0__oai21_1
XFILLER_99_832 VDD VDD VSS VSS gf180mcu_fd_sc_mcu7t5v0__fillcap_8
Xfanout506 _7646_/Q wire507/I VDD VDD VSS VSS gf180mcu_fd_sc_mcu7t5v0__dlyd_1
X_7152_ _7152_/D _7248_/CLK _7152_/Q VDD VDD VSS VSS gf180mcu_fd_sc_mcu7t5v0__dffq_1
X_4295_ _6862_/Q _4308_/A2 _4296_/B VDD VDD VSS VSS gf180mcu_fd_sc_mcu7t5v0__nand2_1
X_7083_ _7083_/D _7097_/CLK _7083_/Q VDD VDD VSS VSS gf180mcu_fd_sc_mcu7t5v0__dffq_1
X_6103_ _7161_/Q _6235_/A2 _6236_/B1 _7140_/Q _6105_/A1 VDD VDD VSS VSS gf180mcu_fd_sc_mcu7t5v0__oai22_1
XFILLER_101_826 VDD VDD VSS VSS gf180mcu_fd_sc_mcu7t5v0__fillcap_8
XFILLER_100_314 VDD VDD VSS VSS gf180mcu_fd_sc_mcu7t5v0__fill_1
X_6034_ _6034_/A1 _6034_/A2 _6061_/A2 VDD VDD VSS VSS gf180mcu_fd_sc_mcu7t5v0__nand2_1
Xclkbuf_leaf_32_clk_i clkload2/I _7687_/CLK VDD VDD VSS VSS gf180mcu_fd_sc_mcu7t5v0__clkbuf_8
XFILLER_27_626 VDD VDD VSS VSS gf180mcu_fd_sc_mcu7t5v0__fillcap_4
XTAP_TAPCELL_ROW_68_1213 VDD VSS gf180mcu_fd_sc_mcu7t5v0__filltie
XFILLER_82_732 VDD VDD VSS VSS gf180mcu_fd_sc_mcu7t5v0__fill_2
X_6936_ _6936_/D _6944_/CLK _6936_/Q VDD VDD VSS VSS gf180mcu_fd_sc_mcu7t5v0__dffq_1
XTAP_TAPCELL_ROW_1_268 VDD VSS gf180mcu_fd_sc_mcu7t5v0__filltie
XTAP_TAPCELL_ROW_1_279 VDD VSS gf180mcu_fd_sc_mcu7t5v0__filltie
Xclkbuf_leaf_47_clk_i clkload6/I _7261_/CLK VDD VDD VSS VSS gf180mcu_fd_sc_mcu7t5v0__clkbuf_8
X_6867_ _6867_/D _7279_/CLK _6867_/Q VDD VDD VSS VSS gf180mcu_fd_sc_mcu7t5v0__dffq_1
X_6798_ _6798_/D _7261_/CLK _6798_/Q VDD VDD VSS VSS gf180mcu_fd_sc_mcu7t5v0__dffq_1
XFILLER_10_515 VDD VDD VSS VSS gf180mcu_fd_sc_mcu7t5v0__fill_2
XTAP_TAPCELL_ROW_40_819 VDD VSS gf180mcu_fd_sc_mcu7t5v0__filltie
X_5818_ _7696_/Q _6254_/B1 _6271_/B1 _7615_/Q _5818_/C _5819_/C VDD VDD VSS VSS gf180mcu_fd_sc_mcu7t5v0__aoi221_1
XFILLER_109_904 VDD VDD VSS VSS gf180mcu_fd_sc_mcu7t5v0__fillcap_4
XTAP_TAPCELL_ROW_20_532 VDD VSS gf180mcu_fd_sc_mcu7t5v0__filltie
X_5749_ _5753_/A1 _5754_/A2 _6582_/A3 VDD VDD VSS VSS gf180mcu_fd_sc_mcu7t5v0__nor2_1
XTAP_TAPCELL_ROW_20_543 VDD VSS gf180mcu_fd_sc_mcu7t5v0__filltie
XTAP_TAPCELL_ROW_79_1364 VDD VSS gf180mcu_fd_sc_mcu7t5v0__filltie
X_7419_ _7419_/D _7500_/CLK _7419_/Q VDD VDD VSS VSS gf180mcu_fd_sc_mcu7t5v0__dffq_1
XTAP_TAPCELL_ROW_92_1553 VDD VSS gf180mcu_fd_sc_mcu7t5v0__filltie
XTAP_TAPCELL_ROW_92_1542 VDD VSS gf180mcu_fd_sc_mcu7t5v0__filltie
XFILLER_104_664 VDD VDD VSS VSS gf180mcu_fd_sc_mcu7t5v0__fill_1
XTAP_TAPCELL_ROW_9_379 VDD VSS gf180mcu_fd_sc_mcu7t5v0__filltie
XFILLER_77_559 VDD VDD VSS VSS gf180mcu_fd_sc_mcu7t5v0__fill_1
XTAP_TAPCELL_ROW_28_654 VDD VSS gf180mcu_fd_sc_mcu7t5v0__filltie
XFILLER_46_979 VDD VDD VSS VSS gf180mcu_fd_sc_mcu7t5v0__fill_2
XTAP_TAPCELL_ROW_101_1671 VDD VSS gf180mcu_fd_sc_mcu7t5v0__filltie
XFILLER_108_981 VDD VDD VSS VSS gf180mcu_fd_sc_mcu7t5v0__fill_1
Xoutput109 _7878_/Z alert_tx_o[1] VDD VDD VSS VSS gf180mcu_fd_sc_mcu7t5v0__dlyd_1
XFILLER_68_537 VDD VDD VSS VSS gf180mcu_fd_sc_mcu7t5v0__fill_1
X_4080_ _4125_/A1 _4812_/A2 _4080_/B _6778_/D VDD VDD VSS VSS gf180mcu_fd_sc_mcu7t5v0__oai21_1
XFILLER_49_784 VDD VDD VSS VSS gf180mcu_fd_sc_mcu7t5v0__fill_2
XFILLER_76_581 VDD VDD VSS VSS gf180mcu_fd_sc_mcu7t5v0__fill_2
XFILLER_64_732 VDD VDD VSS VSS gf180mcu_fd_sc_mcu7t5v0__fill_2
X_7770_ _7770_/D _7822_/RN _7822_/CLK _7770_/Q VDD VDD VSS VSS gf180mcu_fd_sc_mcu7t5v0__dffrnq_1
XFILLER_51_437 VDD VDD VSS VSS gf180mcu_fd_sc_mcu7t5v0__fill_1
X_4982_ _4996_/A1 _4994_/A2 _4982_/B _7205_/D VDD VDD VSS VSS gf180mcu_fd_sc_mcu7t5v0__oai21_1
X_6721_ _7759_/Q _3777_/Z _7759_/D VDD VDD VSS VSS gf180mcu_fd_sc_mcu7t5v0__xor2_1
X_3933_ _7752_/Q _7753_/Q _3932_/Z _3933_/Z VDD VDD VSS VSS gf180mcu_fd_sc_mcu7t5v0__xor3_1
XTAP_TAPCELL_ROW_63_1143 VDD VSS gf180mcu_fd_sc_mcu7t5v0__filltie
X_6652_ _6652_/A1 _6652_/A2 _6652_/B _7733_/D VDD VDD VSS VSS gf180mcu_fd_sc_mcu7t5v0__oai21_1
X_3864_ _6679_/I0 _3932_/A2 _3865_/B VDD VDD VSS VSS gf180mcu_fd_sc_mcu7t5v0__nand2_1
X_5603_ _6829_/Q _5603_/A2 _6634_/B _5605_/A1 VDD VDD VSS VSS gf180mcu_fd_sc_mcu7t5v0__oai21_1
X_3795_ _5632_/A2 _3795_/A2 _7771_/D VDD VDD VSS VSS gf180mcu_fd_sc_mcu7t5v0__nor2_1
X_6583_ _6122_/C _6600_/A2 _6602_/A2 VDD VDD VSS VSS gf180mcu_fd_sc_mcu7t5v0__nor2_1
X_5534_ _7322_/Q _5562_/A2 _5609_/B _5539_/A1 VDD VDD VSS VSS gf180mcu_fd_sc_mcu7t5v0__oai21_1
X_5465_ _6728_/B _5465_/A2 _5465_/B _7509_/D VDD VDD VSS VSS gf180mcu_fd_sc_mcu7t5v0__aoi21_1
X_4416_ wire240/Z _4420_/A2 _4416_/B _6922_/D VDD VDD VSS VSS gf180mcu_fd_sc_mcu7t5v0__oai21_1
X_7204_ _7204_/D _7216_/CLK _7204_/Q VDD VDD VSS VSS gf180mcu_fd_sc_mcu7t5v0__dffq_1
Xfanout303 _6201_/B1 _6074_/B1 VDD VDD VSS VSS gf180mcu_fd_sc_mcu7t5v0__dlyd_1
X_5396_ _7408_/Q _5542_/A2 _5600_/A2 _7394_/Q _5397_/A3 VDD VDD VSS VSS gf180mcu_fd_sc_mcu7t5v0__oai22_1
X_7135_ _7135_/D _7233_/CLK _7135_/Q VDD VDD VSS VSS gf180mcu_fd_sc_mcu7t5v0__dffq_1
Xfanout314 _5754_/ZN _6215_/B1 VDD VDD VSS VSS gf180mcu_fd_sc_mcu7t5v0__dlyd_1
X_4347_ _6888_/Q _4350_/A2 _4348_/B VDD VDD VSS VSS gf180mcu_fd_sc_mcu7t5v0__nand2_1
XFILLER_86_301 VDD VDD VSS VSS gf180mcu_fd_sc_mcu7t5v0__fill_1
XTAP_TAPCELL_ROW_74_1294 VDD VSS gf180mcu_fd_sc_mcu7t5v0__filltie
XTAP_TAPCELL_ROW_6_349 VDD VSS gf180mcu_fd_sc_mcu7t5v0__filltie
XTAP_TAPCELL_ROW_6_338 VDD VSS gf180mcu_fd_sc_mcu7t5v0__filltie
Xfanout325 fanout328/Z _6008_/B1 VDD VDD VSS VSS gf180mcu_fd_sc_mcu7t5v0__dlyd_1
X_7066_ _7066_/D _7254_/CLK _7066_/Q VDD VDD VSS VSS gf180mcu_fd_sc_mcu7t5v0__dffq_1
X_4278_ _5132_/A1 _4280_/A2 _4278_/B _6853_/D VDD VDD VSS VSS gf180mcu_fd_sc_mcu7t5v0__oai21_1
Xfanout358 _6242_/B1 fanout358/Z VDD VDD VSS VSS gf180mcu_fd_sc_mcu7t5v0__dlyd_1
XFILLER_100_177 VDD VDD VSS VSS gf180mcu_fd_sc_mcu7t5v0__fill_2
X_6017_ _6859_/Q wire322/Z _6140_/B1 _6866_/Q _6019_/A1 VDD VDD VSS VSS gf180mcu_fd_sc_mcu7t5v0__oai22_1
XFILLER_28_979 VDD VDD VSS VSS gf180mcu_fd_sc_mcu7t5v0__fill_2
XTAP_TAPCELL_ROW_25_602 VDD VSS gf180mcu_fd_sc_mcu7t5v0__filltie
XTAP_TAPCELL_ROW_25_613 VDD VSS gf180mcu_fd_sc_mcu7t5v0__filltie
X_6919_ _6919_/D _6944_/CLK _6919_/Q VDD VDD VSS VSS gf180mcu_fd_sc_mcu7t5v0__dffq_1
XTAP_TAPCELL_ROW_53_999 VDD VSS gf180mcu_fd_sc_mcu7t5v0__filltie
XPHY_EDGE_ROW_30_Left_149 VDD VSS gf180mcu_fd_sc_mcu7t5v0__endcap
XFILLER_109_756 VDD VDD VSS VSS gf180mcu_fd_sc_mcu7t5v0__fill_2
XFILLER_10_389 VDD VDD VSS VSS gf180mcu_fd_sc_mcu7t5v0__fill_1
XFILLER_93_816 VDD VDD VSS VSS gf180mcu_fd_sc_mcu7t5v0__fill_2
XFILLER_37_209 VDD VDD VSS VSS gf180mcu_fd_sc_mcu7t5v0__fill_1
XFILLER_65_518 VDD VDD VSS VSS gf180mcu_fd_sc_mcu7t5v0__fill_1
XFILLER_61_702 VDD VDD VSS VSS gf180mcu_fd_sc_mcu7t5v0__fill_2
XTAP_TAPCELL_ROW_103_1700 VDD VSS gf180mcu_fd_sc_mcu7t5v0__filltie
XFILLER_18_489 VDD VDD VSS VSS gf180mcu_fd_sc_mcu7t5v0__fill_2
X_3580_ input34/Z input39/Z input63/Z _3580_/Z VDD VDD VSS VSS gf180mcu_fd_sc_mcu7t5v0__xor3_1
X_5250_ wire525/Z _7397_/Q _5253_/S _7397_/D VDD VDD VSS VSS gf180mcu_fd_sc_mcu7t5v0__mux2_2
XTAP_TAPCELL_ROW_114_1851 VDD VSS gf180mcu_fd_sc_mcu7t5v0__filltie
X_4201_ _4238_/I0 _6817_/Q _5246_/S _6817_/D VDD VDD VSS VSS gf180mcu_fd_sc_mcu7t5v0__mux2_2
X_5181_ wire521/Z _7328_/Q _5183_/S _7328_/D VDD VDD VSS VSS gf180mcu_fd_sc_mcu7t5v0__mux2_2
XFILLER_110_442 VDD VDD VSS VSS gf180mcu_fd_sc_mcu7t5v0__fill_2
X_4132_ _4132_/A1 _4135_/A2 _5050_/A2 VDD VDD VSS VSS gf180mcu_fd_sc_mcu7t5v0__nand2_1
XFILLER_111_976 VDD VDD VSS VSS gf180mcu_fd_sc_mcu7t5v0__fillcap_4
XFILLER_95_142 VDD VDD VSS VSS gf180mcu_fd_sc_mcu7t5v0__fill_2
XFILLER_84_827 VDD VDD VSS VSS gf180mcu_fd_sc_mcu7t5v0__fill_1
X_4063_ _4150_/A2 _4081_/A2 _4742_/A2 VDD VDD VSS VSS gf180mcu_fd_sc_mcu7t5v0__nand2_1
XFILLER_92_871 VDD VDD VSS VSS gf180mcu_fd_sc_mcu7t5v0__fillcap_4
XFILLER_52_702 VDD VDD VSS VSS gf180mcu_fd_sc_mcu7t5v0__fill_2
XFILLER_92_882 VDD VDD VSS VSS gf180mcu_fd_sc_mcu7t5v0__fill_2
X_7822_ _7822_/D _7822_/RN _7822_/CLK _7822_/Q VDD VDD VSS VSS gf180mcu_fd_sc_mcu7t5v0__dffrnq_1
X_4965_ _7197_/Q _4966_/A2 _4966_/B VDD VDD VSS VSS gf180mcu_fd_sc_mcu7t5v0__nand2_1
X_7753_ _7753_/D _7755_/RN _7755_/CLK _7753_/Q VDD VDD VSS VSS gf180mcu_fd_sc_mcu7t5v0__dffrnq_1
XFILLER_52_768 VDD VDD VSS VSS gf180mcu_fd_sc_mcu7t5v0__fillcap_4
X_3916_ _7601_/Q _7596_/Q _7600_/Q _3916_/Z VDD VDD VSS VSS gf180mcu_fd_sc_mcu7t5v0__xor3_1
X_6704_ _7750_/Q _6716_/A2 _6714_/B1 _7751_/Q _6705_/I VDD VDD VSS VSS gf180mcu_fd_sc_mcu7t5v0__aoi22_1
X_7684_ _7684_/D _7694_/RN _7692_/CLK _7684_/Q VDD VDD VSS VSS gf180mcu_fd_sc_mcu7t5v0__dffrnq_1
X_4896_ _4952_/A1 _4896_/A2 _4896_/B _7162_/D VDD VDD VSS VSS gf180mcu_fd_sc_mcu7t5v0__oai21_1
XTAP_TAPCELL_ROW_50_958 VDD VSS gf180mcu_fd_sc_mcu7t5v0__filltie
X_3847_ _3843_/Z _3846_/Z _3847_/Z VDD VDD VSS VSS gf180mcu_fd_sc_mcu7t5v0__xor2_1
X_6635_ _5577_/B _5368_/Z _6635_/A3 _6635_/Z VDD VDD VSS VSS gf180mcu_fd_sc_mcu7t5v0__and3_1
XTAP_TAPCELL_ROW_30_682 VDD VSS gf180mcu_fd_sc_mcu7t5v0__filltie
X_3778_ _7759_/Q _7760_/Q _3777_/Z _7785_/D VDD VDD VSS VSS gf180mcu_fd_sc_mcu7t5v0__and3_1
X_6566_ _7701_/Q _7700_/Q _6566_/S _7701_/D VDD VDD VSS VSS gf180mcu_fd_sc_mcu7t5v0__mux2_2
XTAP_TAPCELL_ROW_76_1323 VDD VSS gf180mcu_fd_sc_mcu7t5v0__filltie
X_5517_ _5514_/C _5517_/A2 _5517_/A3 _5521_/B VDD VDD VSS VSS gf180mcu_fd_sc_mcu7t5v0__or3_1
XFILLER_106_737 VDD VDD VSS VSS gf180mcu_fd_sc_mcu7t5v0__fill_2
XFILLER_105_203 VDD VDD VSS VSS gf180mcu_fd_sc_mcu7t5v0__fill_1
X_6497_ _6538_/A1 _6495_/Z _6497_/A3 _7674_/D VDD VDD VSS VSS gf180mcu_fd_sc_mcu7t5v0__nor3_1
X_5448_ _7410_/Q _5542_/A2 _5600_/A2 _7396_/Q _5449_/A3 VDD VDD VSS VSS gf180mcu_fd_sc_mcu7t5v0__oai22_1
X_5379_ _7478_/Q _5412_/B1 _5531_/B _5381_/A1 VDD VDD VSS VSS gf180mcu_fd_sc_mcu7t5v0__oai21_1
XFILLER_102_943 VDD VDD VSS VSS gf180mcu_fd_sc_mcu7t5v0__fill_2
XFILLER_87_632 VDD VDD VSS VSS gf180mcu_fd_sc_mcu7t5v0__fill_1
X_7118_ _7118_/D _7118_/CLK _7118_/Q VDD VDD VSS VSS gf180mcu_fd_sc_mcu7t5v0__dffq_1
X_7049_ _7049_/D _7064_/CLK _7049_/Q VDD VDD VSS VSS gf180mcu_fd_sc_mcu7t5v0__dffq_1
XPHY_EDGE_ROW_29_Right_29 VDD VSS gf180mcu_fd_sc_mcu7t5v0__endcap
XFILLER_68_890 VDD VDD VSS VSS gf180mcu_fd_sc_mcu7t5v0__fill_2
XFILLER_55_562 VDD VDD VSS VSS gf180mcu_fd_sc_mcu7t5v0__fill_2
XTAP_TAPCELL_ROW_87_1474 VDD VSS gf180mcu_fd_sc_mcu7t5v0__filltie
XTAP_TAPCELL_ROW_38_793 VDD VSS gf180mcu_fd_sc_mcu7t5v0__filltie
XFILLER_11_632 VDD VDD VSS VSS gf180mcu_fd_sc_mcu7t5v0__fillcap_64
XPHY_EDGE_ROW_38_Right_38 VDD VSS gf180mcu_fd_sc_mcu7t5v0__endcap
XFILLER_3_842 VDD VDD VSS VSS gf180mcu_fd_sc_mcu7t5v0__fillcap_64
XFILLER_78_621 VDD VDD VSS VSS gf180mcu_fd_sc_mcu7t5v0__fill_1
XFILLER_78_610 VDD VDD VSS VSS gf180mcu_fd_sc_mcu7t5v0__fillcap_4
Xload_slew528 _5347_/I0 _5228_/I0 VDD VDD VSS VSS gf180mcu_fd_sc_mcu7t5v0__buf_2
Xload_slew539 fanout538/Z _6353_/I0 VDD VDD VSS VSS gf180mcu_fd_sc_mcu7t5v0__buf_4
XPHY_EDGE_ROW_47_Right_47 VDD VSS gf180mcu_fd_sc_mcu7t5v0__endcap
XFILLER_33_223 VDD VDD VSS VSS gf180mcu_fd_sc_mcu7t5v0__fill_2
XFILLER_61_543 VDD VDD VSS VSS gf180mcu_fd_sc_mcu7t5v0__fillcap_4
X_4750_ _4988_/A1 _4756_/A2 _4750_/B _7089_/D VDD VDD VSS VSS gf180mcu_fd_sc_mcu7t5v0__oai21_1
XTAP_TAPCELL_ROW_16_487 VDD VSS gf180mcu_fd_sc_mcu7t5v0__filltie
XTAP_TAPCELL_ROW_16_476 VDD VSS gf180mcu_fd_sc_mcu7t5v0__filltie
XFILLER_30_941 VDD VDD VSS VSS gf180mcu_fd_sc_mcu7t5v0__fillcap_4
XPHY_EDGE_ROW_56_Right_56 VDD VSS gf180mcu_fd_sc_mcu7t5v0__endcap
XTAP_TAPCELL_ROW_60_1102 VDD VSS gf180mcu_fd_sc_mcu7t5v0__filltie
X_4681_ _7055_/Q _4686_/A2 _4682_/B VDD VDD VSS VSS gf180mcu_fd_sc_mcu7t5v0__nand2_1
X_3701_ _5690_/A1 _6315_/A2 _5630_/B _3701_/B _3702_/A3 VDD VDD VSS VSS gf180mcu_fd_sc_mcu7t5v0__oai31_1
X_6420_ _6418_/I _6419_/Z _6422_/A1 VDD VDD VSS VSS gf180mcu_fd_sc_mcu7t5v0__nand2_1
X_3632_ _3629_/Z _3630_/Z _3631_/Z _3632_/Z VDD VDD VSS VSS gf180mcu_fd_sc_mcu7t5v0__xor3_1
X_6351_ _6351_/A1 _6352_/S _6351_/B _7637_/D VDD VDD VSS VSS gf180mcu_fd_sc_mcu7t5v0__oai21_1
X_3563_ _3563_/A1 _3563_/A2 _3563_/Z VDD VDD VSS VSS gf180mcu_fd_sc_mcu7t5v0__xor2_1
X_5302_ _5309_/I0 _7449_/Q _5302_/S _7449_/D VDD VDD VSS VSS gf180mcu_fd_sc_mcu7t5v0__mux2_2
X_6282_ _6282_/A1 _6284_/A2 _6284_/B1 _6282_/B2 _7593_/D VDD VDD VSS VSS gf180mcu_fd_sc_mcu7t5v0__aoi22_1
XTAP_TAPCELL_ROW_58_1064 VDD VSS gf180mcu_fd_sc_mcu7t5v0__filltie
XTAP_TAPCELL_ROW_58_1075 VDD VSS gf180mcu_fd_sc_mcu7t5v0__filltie
X_3494_ _3494_/A1 _3488_/Z _3494_/B _3500_/A2 VDD VDD VSS VSS gf180mcu_fd_sc_mcu7t5v0__oai21_1
X_5233_ _5352_/I0 _7380_/Q _5239_/S _7380_/D VDD VDD VSS VSS gf180mcu_fd_sc_mcu7t5v0__mux2_2
XPHY_EDGE_ROW_65_Right_65 VDD VSS gf180mcu_fd_sc_mcu7t5v0__endcap
X_5164_ _5339_/I0 _7311_/Q _5169_/S _7311_/D VDD VDD VSS VSS gf180mcu_fd_sc_mcu7t5v0__mux2_2
XTAP_TAPCELL_ROW_71_1253 VDD VSS gf180mcu_fd_sc_mcu7t5v0__filltie
XFILLER_96_473 VDD VDD VSS VSS gf180mcu_fd_sc_mcu7t5v0__fill_1
X_4115_ _6789_/Q _4966_/A2 _4116_/B VDD VDD VSS VSS gf180mcu_fd_sc_mcu7t5v0__nand2_1
X_5095_ _7262_/Q _5106_/A2 _5096_/B VDD VDD VSS VSS gf180mcu_fd_sc_mcu7t5v0__nand2_1
XFILLER_57_838 VDD VDD VSS VSS gf180mcu_fd_sc_mcu7t5v0__fill_2
X_4046_ _4143_/A1 _4658_/A2 _4046_/B _6767_/D VDD VDD VSS VSS gf180mcu_fd_sc_mcu7t5v0__oai21_1
XFILLER_25_702 VDD VDD VSS VSS gf180mcu_fd_sc_mcu7t5v0__fillcap_64
XFILLER_37_562 VDD VDD VSS VSS gf180mcu_fd_sc_mcu7t5v0__fillcap_64
X_7805_ _7805_/D _7811_/RN clkload9/I _7805_/Q VDD VDD VSS VSS gf180mcu_fd_sc_mcu7t5v0__dffrnq_1
XPHY_EDGE_ROW_74_Right_74 VDD VSS gf180mcu_fd_sc_mcu7t5v0__endcap
XTAP_TAPCELL_ROW_35_752 VDD VSS gf180mcu_fd_sc_mcu7t5v0__filltie
X_5997_ _5997_/A1 _5997_/A2 _5997_/B1 _5997_/B2 _5997_/C _5999_/B VDD VDD VSS VSS
+ gf180mcu_fd_sc_mcu7t5v0__oai221_1
X_7736_ _7736_/D _7736_/RN _7736_/CLK _7736_/Q VDD VDD VSS VSS gf180mcu_fd_sc_mcu7t5v0__dffrnq_1
X_4948_ _4948_/A1 _4952_/A2 _4948_/B _7188_/D VDD VDD VSS VSS gf180mcu_fd_sc_mcu7t5v0__oai21_1
X_7667_ _7667_/D _7671_/RN _7667_/CLK _7667_/Q VDD VDD VSS VSS gf180mcu_fd_sc_mcu7t5v0__dffrnq_1
X_4879_ _7154_/Q _4882_/A2 _4880_/B VDD VDD VSS VSS gf180mcu_fd_sc_mcu7t5v0__nand2_1
XPHY_EDGE_ROW_104_Left_223 VDD VSS gf180mcu_fd_sc_mcu7t5v0__endcap
X_6618_ _7723_/Q _6617_/C _6621_/A2 VDD VDD VSS VSS gf180mcu_fd_sc_mcu7t5v0__nand2_1
X_7598_ _7598_/D _7599_/RN _7669_/CLK _7598_/Q VDD VDD VSS VSS gf180mcu_fd_sc_mcu7t5v0__dffrnq_1
X_6549_ _7692_/Q _6546_/Z _6549_/Z VDD VDD VSS VSS gf180mcu_fd_sc_mcu7t5v0__and2_1
XPHY_EDGE_ROW_83_Right_83 VDD VSS gf180mcu_fd_sc_mcu7t5v0__endcap
XFILLER_102_751 VDD VDD VSS VSS gf180mcu_fd_sc_mcu7t5v0__fill_2
XTAP_TAPCELL_ROW_89_1503 VDD VSS gf180mcu_fd_sc_mcu7t5v0__filltie
XPHY_EDGE_ROW_113_Left_232 VDD VSS gf180mcu_fd_sc_mcu7t5v0__endcap
XFILLER_75_668 VDD VDD VSS VSS gf180mcu_fd_sc_mcu7t5v0__fillcap_4
XFILLER_56_871 VDD VDD VSS VSS gf180mcu_fd_sc_mcu7t5v0__fillcap_4
XPHY_EDGE_ROW_92_Right_92 VDD VSS gf180mcu_fd_sc_mcu7t5v0__endcap
XFILLER_15_212 VDD VDD VSS VSS gf180mcu_fd_sc_mcu7t5v0__fill_2
XFILLER_12_941 VDD VDD VSS VSS gf180mcu_fd_sc_mcu7t5v0__fillcap_4
XFILLER_70_384 VDD VDD VSS VSS gf180mcu_fd_sc_mcu7t5v0__fill_1
XTAP_TAPCELL_ROW_13_446 VDD VSS gf180mcu_fd_sc_mcu7t5v0__filltie
XTAP_TAPCELL_ROW_13_435 VDD VSS gf180mcu_fd_sc_mcu7t5v0__filltie
Xwire353 wire353/I wire353/Z VDD VDD VSS VSS gf180mcu_fd_sc_mcu7t5v0__clkbuf_4
XTAP_TAPCELL_ROW_111_1810 VDD VSS gf180mcu_fd_sc_mcu7t5v0__filltie
Xload_slew347 _6076_/A2 _6141_/A2 VDD VDD VSS VSS gf180mcu_fd_sc_mcu7t5v0__buf_4
Xload_slew336 _6227_/A2 _6175_/A2 VDD VDD VSS VSS gf180mcu_fd_sc_mcu7t5v0__buf_4
XFILLER_79_974 VDD VDD VSS VSS gf180mcu_fd_sc_mcu7t5v0__fillcap_4
Xload_slew369 _5603_/A2 _5594_/B1 VDD VDD VSS VSS gf180mcu_fd_sc_mcu7t5v0__buf_4
XFILLER_19_551 VDD VDD VSS VSS gf180mcu_fd_sc_mcu7t5v0__fillcap_8
X_5920_ _5920_/A1 _5920_/A2 _6224_/B _5936_/B2 VDD VDD VSS VSS gf180mcu_fd_sc_mcu7t5v0__oai21_1
XFILLER_19_562 VDD VDD VSS VSS gf180mcu_fd_sc_mcu7t5v0__fillcap_64
XFILLER_47_871 VDD VDD VSS VSS gf180mcu_fd_sc_mcu7t5v0__fillcap_32
XTAP_TAPCELL_ROW_109_1783 VDD VSS gf180mcu_fd_sc_mcu7t5v0__filltie
XFILLER_34_532 VDD VDD VSS VSS gf180mcu_fd_sc_mcu7t5v0__fillcap_32
X_5851_ _7073_/Q _6215_/A2 _6191_/B _5853_/A1 VDD VDD VSS VSS gf180mcu_fd_sc_mcu7t5v0__oai21_1
XFILLER_62_874 VDD VDD VSS VSS gf180mcu_fd_sc_mcu7t5v0__fill_1
XPHY_EDGE_ROW_100_Right_100 VDD VSS gf180mcu_fd_sc_mcu7t5v0__endcap
X_4802_ wire268/Z _4812_/A2 _4802_/B _7115_/D VDD VDD VSS VSS gf180mcu_fd_sc_mcu7t5v0__oai21_1
XTAP_TAPCELL_ROW_32_700 VDD VSS gf180mcu_fd_sc_mcu7t5v0__filltie
XTAP_TAPCELL_ROW_32_711 VDD VSS gf180mcu_fd_sc_mcu7t5v0__filltie
X_5782_ _7198_/Q _6232_/A2 _6174_/B _5784_/A1 VDD VDD VSS VSS gf180mcu_fd_sc_mcu7t5v0__oai21_1
X_4733_ _7081_/Q _4742_/A2 _4734_/B VDD VDD VSS VSS gf180mcu_fd_sc_mcu7t5v0__nand2_1
X_7521_ _7521_/D _7708_/RN _7693_/CLK _7521_/Q VDD VDD VSS VSS gf180mcu_fd_sc_mcu7t5v0__dffrnq_1
X_7452_ _7452_/D _7754_/CLK _7452_/Q VDD VDD VSS VSS gf180mcu_fd_sc_mcu7t5v0__dffq_1
X_6403_ _6451_/A2 _6403_/A2 _6403_/B _7659_/D VDD VDD VSS VSS gf180mcu_fd_sc_mcu7t5v0__oai21_1
X_4664_ _4748_/A1 _4672_/A2 _4664_/B _7046_/D VDD VDD VSS VSS gf180mcu_fd_sc_mcu7t5v0__oai21_1
X_4595_ _7012_/Q _4602_/A2 _4596_/B VDD VDD VSS VSS gf180mcu_fd_sc_mcu7t5v0__nand2_1
X_3615_ input93/Z input94/Z _3615_/Z VDD VDD VSS VSS gf180mcu_fd_sc_mcu7t5v0__xor2_1
X_7383_ _7383_/D _7472_/CLK _7383_/Q VDD VDD VSS VSS gf180mcu_fd_sc_mcu7t5v0__dffq_1
X_6334_ _7626_/Q input42/Z _6338_/S _7626_/D VDD VDD VSS VSS gf180mcu_fd_sc_mcu7t5v0__mux2_2
X_3546_ input25/Z _3383_/I input26/Z _3546_/Z VDD VDD VSS VSS gf180mcu_fd_sc_mcu7t5v0__xor3_1
X_6265_ _6265_/A1 _6300_/A2 _6302_/B1 _6265_/B2 _7585_/D VDD VDD VSS VSS gf180mcu_fd_sc_mcu7t5v0__aoi22_1
X_5216_ _5342_/I0 _7363_/Q _5218_/S _7363_/D VDD VDD VSS VSS gf180mcu_fd_sc_mcu7t5v0__mux2_2
X_3477_ _7720_/Q _5754_/A2 _3488_/A1 VDD VDD VSS VSS gf180mcu_fd_sc_mcu7t5v0__nand2_1
X_6196_ _6196_/A1 _6196_/A2 _6196_/B _6203_/A2 VDD VDD VSS VSS gf180mcu_fd_sc_mcu7t5v0__oai21_1
X_5147_ wire517/Z _7294_/Q _5148_/S _7294_/D VDD VDD VSS VSS gf180mcu_fd_sc_mcu7t5v0__mux2_2
XFILLER_57_646 VDD VDD VSS VSS gf180mcu_fd_sc_mcu7t5v0__fill_1
XFILLER_85_977 VDD VDD VSS VSS gf180mcu_fd_sc_mcu7t5v0__fill_2
XFILLER_84_432 VDD VDD VSS VSS gf180mcu_fd_sc_mcu7t5v0__fill_1
XFILLER_29_348 VDD VDD VSS VSS gf180mcu_fd_sc_mcu7t5v0__fill_2
X_5078_ _5078_/A1 _5078_/A2 _5078_/B _7253_/D VDD VDD VSS VSS gf180mcu_fd_sc_mcu7t5v0__aoi21_1
X_4029_ _4029_/A1 _4588_/A2 _4029_/B _6762_/D VDD VDD VSS VSS gf180mcu_fd_sc_mcu7t5v0__oai21_1
XFILLER_38_871 VDD VDD VSS VSS gf180mcu_fd_sc_mcu7t5v0__fillcap_4
XTAP_TAPCELL_ROW_84_1433 VDD VSS gf180mcu_fd_sc_mcu7t5v0__filltie
XFILLER_12_226 VDD VDD VSS VSS gf180mcu_fd_sc_mcu7t5v0__fill_1
XFILLER_40_524 VDD VDD VSS VSS gf180mcu_fd_sc_mcu7t5v0__fill_1
X_7719_ _7719_/D wire593/Z _7719_/CLK _7719_/Q VDD VDD VSS VSS gf180mcu_fd_sc_mcu7t5v0__dffrnq_1
XTAP_TAPCELL_ROW_10_405 VDD VSS gf180mcu_fd_sc_mcu7t5v0__filltie
XFILLER_20_292 VDD VDD VSS VSS gf180mcu_fd_sc_mcu7t5v0__fill_1
XTAP_TAPCELL_ROW_95_1595 VDD VSS gf180mcu_fd_sc_mcu7t5v0__filltie
XTAP_TAPCELL_ROW_95_1584 VDD VSS gf180mcu_fd_sc_mcu7t5v0__filltie
XFILLER_76_944 VDD VDD VSS VSS gf180mcu_fd_sc_mcu7t5v0__fill_1
XTAP_TAPCELL_ROW_18_516 VDD VSS gf180mcu_fd_sc_mcu7t5v0__filltie
XTAP_TAPCELL_ROW_18_505 VDD VSS gf180mcu_fd_sc_mcu7t5v0__filltie
XFILLER_31_502 VDD VDD VSS VSS gf180mcu_fd_sc_mcu7t5v0__fill_2
XFILLER_44_874 VDD VDD VSS VSS gf180mcu_fd_sc_mcu7t5v0__fill_1
XFILLER_8_731 VDD VDD VSS VSS gf180mcu_fd_sc_mcu7t5v0__fillcap_4
X_4380_ _4506_/A1 _4392_/A2 _4380_/B _6904_/D VDD VDD VSS VSS gf180mcu_fd_sc_mcu7t5v0__oai21_1
X_3400_ _7621_/Q _6327_/A1 VDD VDD VSS VSS gf180mcu_fd_sc_mcu7t5v0__clkinv_1
XFILLER_4_981 VDD VDD VSS VSS gf180mcu_fd_sc_mcu7t5v0__fill_1
XTAP_TAPCELL_ROW_55_1023 VDD VSS gf180mcu_fd_sc_mcu7t5v0__filltie
XTAP_TAPCELL_ROW_55_1034 VDD VSS gf180mcu_fd_sc_mcu7t5v0__filltie
X_6050_ _7251_/Q _6235_/A2 _6171_/B _6052_/B1 VDD VDD VSS VSS gf180mcu_fd_sc_mcu7t5v0__oai21_1
XFILLER_22_2 VDD VDD VSS VSS gf180mcu_fd_sc_mcu7t5v0__fill_1
X_5001_ _7215_/Q _5008_/A2 _5002_/B VDD VDD VSS VSS gf180mcu_fd_sc_mcu7t5v0__nand2_1
Xload_slew188 _4138_/ZN _5078_/A2 VDD VDD VSS VSS gf180mcu_fd_sc_mcu7t5v0__buf_2
Xload_slew199 _6274_/B1 _6300_/B1 VDD VDD VSS VSS gf180mcu_fd_sc_mcu7t5v0__buf_4
XFILLER_67_977 VDD VDD VSS VSS gf180mcu_fd_sc_mcu7t5v0__fill_2
XFILLER_82_947 VDD VDD VSS VSS gf180mcu_fd_sc_mcu7t5v0__fillcap_32
X_6952_ _6952_/D _7002_/CLK _6952_/Q VDD VDD VSS VSS gf180mcu_fd_sc_mcu7t5v0__dffq_1
X_6883_ _6883_/D _7008_/CLK _6883_/Q VDD VDD VSS VSS gf180mcu_fd_sc_mcu7t5v0__dffq_1
X_5903_ _7158_/Q _6132_/A2 wire341/Z _7151_/Q _5905_/A1 VDD VDD VSS VSS gf180mcu_fd_sc_mcu7t5v0__oai22_1
X_5834_ _5834_/A1 _5834_/A2 _5834_/B1 _5834_/B2 _5848_/A2 VDD VDD VSS VSS gf180mcu_fd_sc_mcu7t5v0__oai22_1
XTAP_TAPCELL_ROW_45_891 VDD VSS gf180mcu_fd_sc_mcu7t5v0__filltie
XTAP_TAPCELL_ROW_66_1185 VDD VSS gf180mcu_fd_sc_mcu7t5v0__filltie
XFILLER_50_877 VDD VDD VSS VSS gf180mcu_fd_sc_mcu7t5v0__fillcap_64
X_5765_ _6217_/B _5765_/A2 _5765_/A3 _5779_/A2 VDD VDD VSS VSS gf180mcu_fd_sc_mcu7t5v0__nand3_1
X_4716_ _4786_/A1 _4728_/A2 _4716_/B _7072_/D VDD VDD VSS VSS gf180mcu_fd_sc_mcu7t5v0__oai21_1
X_7504_ _7504_/D _7504_/CLK _7504_/Q VDD VDD VSS VSS gf180mcu_fd_sc_mcu7t5v0__dffq_1
X_5696_ _5696_/A1 _5696_/A2 _5697_/B VDD VDD VSS VSS gf180mcu_fd_sc_mcu7t5v0__nor2_1
X_4647_ _7038_/Q _4658_/A2 _4648_/B VDD VDD VSS VSS gf180mcu_fd_sc_mcu7t5v0__nand2_1
X_7435_ _7435_/D _7456_/CLK _7435_/Q VDD VDD VSS VSS gf180mcu_fd_sc_mcu7t5v0__dffq_1
X_7366_ _7366_/D _7736_/CLK _7366_/Q VDD VDD VSS VSS gf180mcu_fd_sc_mcu7t5v0__dffq_1
XFILLER_116_662 VDD VDD VSS VSS gf180mcu_fd_sc_mcu7t5v0__fill_2
X_4578_ _5124_/A1 _4588_/A2 _4578_/B _7003_/D VDD VDD VSS VSS gf180mcu_fd_sc_mcu7t5v0__oai21_1
X_6317_ _7615_/Q input29/Z _6325_/S _7615_/D VDD VDD VSS VSS gf180mcu_fd_sc_mcu7t5v0__mux2_2
X_3529_ _5744_/A1 _3378_/I _5883_/C VDD VDD VSS VSS gf180mcu_fd_sc_mcu7t5v0__nand2_1
XFILLER_89_546 VDD VDD VSS VSS gf180mcu_fd_sc_mcu7t5v0__fill_2
X_7297_ _7297_/D _7500_/CLK _7297_/Q VDD VDD VSS VSS gf180mcu_fd_sc_mcu7t5v0__dffq_1
X_6248_ _7539_/Q _6256_/A2 _5691_/I _7565_/Q _6250_/A3 VDD VDD VSS VSS gf180mcu_fd_sc_mcu7t5v0__aoi22_1
X_6179_ _7176_/Q _6241_/B1 _6179_/B _6242_/C _6182_/B VDD VDD VSS VSS gf180mcu_fd_sc_mcu7t5v0__oai211_1
XFILLER_58_944 VDD VDD VSS VSS gf180mcu_fd_sc_mcu7t5v0__fill_1
XFILLER_73_914 VDD VDD VSS VSS gf180mcu_fd_sc_mcu7t5v0__fill_1
XTAP_TAPCELL_ROW_23_574 VDD VSS gf180mcu_fd_sc_mcu7t5v0__filltie
XTAP_TAPCELL_ROW_97_1613 VDD VSS gf180mcu_fd_sc_mcu7t5v0__filltie
XTAP_TAPCELL_ROW_23_585 VDD VSS gf180mcu_fd_sc_mcu7t5v0__filltie
XFILLER_29_91 VDD VDD VSS VSS gf180mcu_fd_sc_mcu7t5v0__fill_1
XFILLER_64_947 VDD VDD VSS VSS gf180mcu_fd_sc_mcu7t5v0__fillcap_32
XTAP_TAPCELL_ROW_106_1742 VDD VSS gf180mcu_fd_sc_mcu7t5v0__filltie
XFILLER_16_351 VDD VDD VSS VSS gf180mcu_fd_sc_mcu7t5v0__fill_2
XFILLER_16_384 VDD VDD VSS VSS gf180mcu_fd_sc_mcu7t5v0__fill_1
XFILLER_50_129 VDD VDD VSS VSS gf180mcu_fd_sc_mcu7t5v0__fill_2
XFILLER_31_343 VDD VDD VSS VSS gf180mcu_fd_sc_mcu7t5v0__fill_1
XFILLER_32_877 VDD VDD VSS VSS gf180mcu_fd_sc_mcu7t5v0__fillcap_64
X_3880_ _7792_/Q _3877_/Z _7784_/Q _6362_/B VDD VDD VSS VSS gf180mcu_fd_sc_mcu7t5v0__aoi21_1
XTAP_TAPCELL_ROW_42_850 VDD VSS gf180mcu_fd_sc_mcu7t5v0__filltie
XFILLER_12_590 VDD VDD VSS VSS gf180mcu_fd_sc_mcu7t5v0__fillcap_4
X_5550_ _7350_/Q _5593_/A2 wire420/Z _7336_/Q _5552_/A2 VDD VDD VSS VSS gf180mcu_fd_sc_mcu7t5v0__oai22_1
X_4501_ _6965_/Q _4504_/A2 _4502_/B VDD VDD VSS VSS gf180mcu_fd_sc_mcu7t5v0__nand2_1
X_5481_ _7495_/Q _5515_/A2 _5516_/C2 _7502_/Q _7292_/Q _5562_/A2 _5482_/A3 VDD VDD
+ VSS VSS gf180mcu_fd_sc_mcu7t5v0__oai222_1
X_4432_ _4460_/A1 _4434_/A2 _4432_/B _6930_/D VDD VDD VSS VSS gf180mcu_fd_sc_mcu7t5v0__oai21_1
X_7220_ _7220_/D _7266_/CLK _7220_/Q VDD VDD VSS VSS gf180mcu_fd_sc_mcu7t5v0__dffq_1
XTAP_TAPCELL_ROW_117_1893 VDD VSS gf180mcu_fd_sc_mcu7t5v0__filltie
X_4363_ _6896_/Q _4364_/A2 _4364_/B VDD VDD VSS VSS gf180mcu_fd_sc_mcu7t5v0__nand2_1
X_7151_ _7151_/D _7189_/CLK _7151_/Q VDD VDD VSS VSS gf180mcu_fd_sc_mcu7t5v0__dffq_1
X_7082_ _7082_/D _7118_/CLK _7082_/Q VDD VDD VSS VSS gf180mcu_fd_sc_mcu7t5v0__dffq_1
X_4294_ _4336_/A1 _4294_/A2 _4294_/B _6861_/D VDD VDD VSS VSS gf180mcu_fd_sc_mcu7t5v0__oai21_1
Xfanout518 wire521/I _5244_/I0 VDD VDD VSS VSS gf180mcu_fd_sc_mcu7t5v0__dlyd_1
Xfanout529 _7641_/Q _5235_/I0 VDD VDD VSS VSS gf180mcu_fd_sc_mcu7t5v0__dlyd_1
X_6102_ _6102_/A1 _6102_/A2 _6237_/B _6109_/A2 VDD VDD VSS VSS gf180mcu_fd_sc_mcu7t5v0__oai21_1
XFILLER_113_698 VDD VDD VSS VSS gf180mcu_fd_sc_mcu7t5v0__fill_2
XFILLER_101_838 VDD VDD VSS VSS gf180mcu_fd_sc_mcu7t5v0__fill_2
X_6033_ _6176_/B _6033_/A2 _6033_/B1 _6033_/B2 _6217_/B _6034_/A2 VDD VDD VSS VSS
+ gf180mcu_fd_sc_mcu7t5v0__oai221_1
XFILLER_67_741 VDD VDD VSS VSS gf180mcu_fd_sc_mcu7t5v0__fill_2
XTAP_TAPCELL_ROW_68_1214 VDD VSS gf180mcu_fd_sc_mcu7t5v0__filltie
X_6935_ _6935_/D _7259_/CLK _6935_/Q VDD VDD VSS VSS gf180mcu_fd_sc_mcu7t5v0__dffq_1
XTAP_TAPCELL_ROW_1_269 VDD VSS gf180mcu_fd_sc_mcu7t5v0__filltie
X_6866_ _6866_/D _7267_/CLK _6866_/Q VDD VDD VSS VSS gf180mcu_fd_sc_mcu7t5v0__dffq_1
X_6797_ _6797_/D _7253_/CLK _6797_/Q VDD VDD VSS VSS gf180mcu_fd_sc_mcu7t5v0__dffq_1
X_5817_ _5943_/A1 _5817_/A2 _5817_/A3 _5818_/C VDD VDD VSS VSS gf180mcu_fd_sc_mcu7t5v0__nand3_1
XTAP_TAPCELL_ROW_20_533 VDD VSS gf180mcu_fd_sc_mcu7t5v0__filltie
XFILLER_22_387 VDD VDD VSS VSS gf180mcu_fd_sc_mcu7t5v0__fill_1
X_5748_ _5808_/A1 _5748_/A2 _6488_/B _5748_/Z VDD VDD VSS VSS gf180mcu_fd_sc_mcu7t5v0__or3_1
XTAP_TAPCELL_ROW_20_544 VDD VSS gf180mcu_fd_sc_mcu7t5v0__filltie
XTAP_TAPCELL_ROW_79_1365 VDD VSS gf180mcu_fd_sc_mcu7t5v0__filltie
X_5679_ _7553_/Q input35/Z _5686_/S _7553_/D VDD VDD VSS VSS gf180mcu_fd_sc_mcu7t5v0__mux2_2
X_7418_ _7418_/D _7418_/CLK _7418_/Q VDD VDD VSS VSS gf180mcu_fd_sc_mcu7t5v0__dffq_1
XTAP_TAPCELL_ROW_92_1543 VDD VSS gf180mcu_fd_sc_mcu7t5v0__filltie
XFILLER_2_737 VDD VDD VSS VSS gf180mcu_fd_sc_mcu7t5v0__fillcap_64
X_7349_ _7349_/D clkload9/I _7349_/Q VDD VDD VSS VSS gf180mcu_fd_sc_mcu7t5v0__dffq_1
XFILLER_77_505 VDD VDD VSS VSS gf180mcu_fd_sc_mcu7t5v0__fill_2
XFILLER_100_882 VDD VDD VSS VSS gf180mcu_fd_sc_mcu7t5v0__fillcap_4
XFILLER_46_947 VDD VDD VSS VSS gf180mcu_fd_sc_mcu7t5v0__fillcap_32
XFILLER_72_210 VDD VDD VSS VSS gf180mcu_fd_sc_mcu7t5v0__fill_1
XTAP_TAPCELL_ROW_28_644 VDD VSS gf180mcu_fd_sc_mcu7t5v0__filltie
XTAP_TAPCELL_ROW_28_655 VDD VSS gf180mcu_fd_sc_mcu7t5v0__filltie
XFILLER_32_107 VDD VDD VSS VSS gf180mcu_fd_sc_mcu7t5v0__fill_1
XFILLER_13_343 VDD VDD VSS VSS gf180mcu_fd_sc_mcu7t5v0__fill_1
XFILLER_14_877 VDD VDD VSS VSS gf180mcu_fd_sc_mcu7t5v0__fillcap_64
XTAP_TAPCELL_ROW_101_1672 VDD VSS gf180mcu_fd_sc_mcu7t5v0__filltie
XFILLER_41_696 VDD VDD VSS VSS gf180mcu_fd_sc_mcu7t5v0__fillcap_4
XFILLER_76_560 VDD VDD VSS VSS gf180mcu_fd_sc_mcu7t5v0__fill_2
XTAP_TAPCELL_ROW_47_920 VDD VSS gf180mcu_fd_sc_mcu7t5v0__filltie
X_4981_ _7205_/Q _4994_/A2 _4982_/B VDD VDD VSS VSS gf180mcu_fd_sc_mcu7t5v0__nand2_1
X_6720_ _3777_/Z _6720_/A2 _7758_/D VDD VDD VSS VSS gf180mcu_fd_sc_mcu7t5v0__nor2_1
X_3932_ _3932_/A1 _3932_/A2 _3931_/Z _3932_/Z VDD VDD VSS VSS gf180mcu_fd_sc_mcu7t5v0__xor3_1
XTAP_TAPCELL_ROW_63_1144 VDD VSS gf180mcu_fd_sc_mcu7t5v0__filltie
X_6651_ _6651_/A1 _6651_/A2 _6652_/A2 VDD VDD VSS VSS gf180mcu_fd_sc_mcu7t5v0__nor2_1
X_3863_ _6679_/I0 _7755_/Q _3863_/B _3863_/ZN VDD VDD VSS VSS gf180mcu_fd_sc_mcu7t5v0__oai21_1
X_5602_ _5397_/B _5602_/A2 _5602_/A3 _5602_/B1 _5602_/B2 _5616_/I1 VDD VDD VSS VSS
+ gf180mcu_fd_sc_mcu7t5v0__oai32_1
X_6582_ _6201_/C _5926_/B _6582_/A3 _6600_/A2 VDD VDD VSS VSS gf180mcu_fd_sc_mcu7t5v0__nand3_1
XFILLER_118_713 VDD VDD VSS VSS gf180mcu_fd_sc_mcu7t5v0__fill_1
X_3794_ _7769_/Q _5632_/A1 _3795_/A2 VDD VDD VSS VSS gf180mcu_fd_sc_mcu7t5v0__nor2_1
X_5533_ _5533_/A1 _5533_/A2 _5540_/A3 VDD VDD VSS VSS gf180mcu_fd_sc_mcu7t5v0__nor2_1
XFILLER_118_746 VDD VDD VSS VSS gf180mcu_fd_sc_mcu7t5v0__fill_2
XFILLER_117_245 VDD VDD VSS VSS gf180mcu_fd_sc_mcu7t5v0__fill_1
X_5464_ _7509_/Q _6728_/B _5465_/B VDD VDD VSS VSS gf180mcu_fd_sc_mcu7t5v0__nor2_1
X_4415_ _6922_/Q _4420_/A2 _4416_/B VDD VDD VSS VSS gf180mcu_fd_sc_mcu7t5v0__nand2_1
X_5395_ _7415_/Q _5597_/A2 _5597_/B1 _7401_/Q _5397_/A2 VDD VDD VSS VSS gf180mcu_fd_sc_mcu7t5v0__oai22_1
X_7203_ _7203_/D _7217_/CLK _7203_/Q VDD VDD VSS VSS gf180mcu_fd_sc_mcu7t5v0__dffq_1
XFILLER_114_941 VDD VDD VSS VSS gf180mcu_fd_sc_mcu7t5v0__fillcap_4
X_4346_ _5102_/A1 _4350_/A2 _4346_/B _6887_/D VDD VDD VSS VSS gf180mcu_fd_sc_mcu7t5v0__oai21_1
X_7134_ _7134_/D _7233_/CLK _7134_/Q VDD VDD VSS VSS gf180mcu_fd_sc_mcu7t5v0__dffq_1
Xclkbuf_3_7__f_clk_i clkbuf_0_clk_i/Z clkload6/I VDD VDD VSS VSS gf180mcu_fd_sc_mcu7t5v0__clkbuf_16
XTAP_TAPCELL_ROW_74_1295 VDD VSS gf180mcu_fd_sc_mcu7t5v0__filltie
XTAP_TAPCELL_ROW_6_339 VDD VSS gf180mcu_fd_sc_mcu7t5v0__filltie
Xfanout337 _5753_/ZN _6590_/A2 VDD VDD VSS VSS gf180mcu_fd_sc_mcu7t5v0__dlyd_1
XFILLER_59_505 VDD VDD VSS VSS gf180mcu_fd_sc_mcu7t5v0__fill_1
X_4277_ _6853_/Q _4280_/A2 _4278_/B VDD VDD VSS VSS gf180mcu_fd_sc_mcu7t5v0__nand2_1
X_7065_ _7065_/D _7070_/CLK _7065_/Q VDD VDD VSS VSS gf180mcu_fd_sc_mcu7t5v0__dffq_1
X_6016_ _6016_/A1 _6016_/A2 _6020_/B1 VDD VDD VSS VSS gf180mcu_fd_sc_mcu7t5v0__nor2_1
XFILLER_28_947 VDD VDD VSS VSS gf180mcu_fd_sc_mcu7t5v0__fillcap_32
XFILLER_43_906 VDD VDD VSS VSS gf180mcu_fd_sc_mcu7t5v0__fillcap_4
XTAP_TAPCELL_ROW_25_603 VDD VSS gf180mcu_fd_sc_mcu7t5v0__filltie
XTAP_TAPCELL_ROW_25_614 VDD VSS gf180mcu_fd_sc_mcu7t5v0__filltie
X_6918_ _6918_/D _6939_/CLK _6918_/Q VDD VDD VSS VSS gf180mcu_fd_sc_mcu7t5v0__dffq_1
X_6849_ _6849_/D _7276_/CLK _6849_/Q VDD VDD VSS VSS gf180mcu_fd_sc_mcu7t5v0__dffq_1
XFILLER_11_836 VDD VDD VSS VSS gf180mcu_fd_sc_mcu7t5v0__fillcap_4
XFILLER_23_696 VDD VDD VSS VSS gf180mcu_fd_sc_mcu7t5v0__fillcap_4
XFILLER_109_768 VDD VDD VSS VSS gf180mcu_fd_sc_mcu7t5v0__fill_2
XFILLER_93_828 VDD VDD VSS VSS gf180mcu_fd_sc_mcu7t5v0__fill_2
XTAP_TAPCELL_ROW_103_1701 VDD VSS gf180mcu_fd_sc_mcu7t5v0__filltie
XFILLER_61_736 VDD VDD VSS VSS gf180mcu_fd_sc_mcu7t5v0__fill_1
XFILLER_13_173 VDD VDD VSS VSS gf180mcu_fd_sc_mcu7t5v0__fill_1
Xclkbuf_leaf_31_clk_i clkload5/I _7279_/CLK VDD VDD VSS VSS gf180mcu_fd_sc_mcu7t5v0__clkbuf_8
XTAP_TAPCELL_ROW_114_1852 VDD VSS gf180mcu_fd_sc_mcu7t5v0__filltie
X_4200_ _6653_/A2 _4200_/A2 _5246_/S VDD VDD VSS VSS gf180mcu_fd_sc_mcu7t5v0__nand2_1
Xclkbuf_leaf_46_clk_i clkload6/I _7259_/CLK VDD VDD VSS VSS gf180mcu_fd_sc_mcu7t5v0__clkbuf_8
X_5180_ wire525/Z _7327_/Q _5183_/S _7327_/D VDD VDD VSS VSS gf180mcu_fd_sc_mcu7t5v0__mux2_2
X_4131_ _4140_/A1 _5036_/A2 _4131_/B _6794_/D VDD VDD VSS VSS gf180mcu_fd_sc_mcu7t5v0__oai21_1
XFILLER_69_858 VDD VDD VSS VSS gf180mcu_fd_sc_mcu7t5v0__fill_1
XFILLER_96_677 VDD VDD VSS VSS gf180mcu_fd_sc_mcu7t5v0__fill_1
X_4062_ _4071_/A1 _4728_/A2 _4062_/B _6772_/D VDD VDD VSS VSS gf180mcu_fd_sc_mcu7t5v0__oai21_1
XFILLER_25_906 VDD VDD VSS VSS gf180mcu_fd_sc_mcu7t5v0__fillcap_4
XFILLER_37_766 VDD VDD VSS VSS gf180mcu_fd_sc_mcu7t5v0__fillcap_4
X_7821_ _7821_/D _7822_/RN clkload7/I _7821_/Q VDD VDD VSS VSS gf180mcu_fd_sc_mcu7t5v0__dffsnq_1
X_7752_ _7752_/D _7755_/RN _7792_/CLK _7752_/Q VDD VDD VSS VSS gf180mcu_fd_sc_mcu7t5v0__dffrnq_1
X_4964_ _4964_/A1 _4966_/A2 _4964_/B _7196_/D VDD VDD VSS VSS gf180mcu_fd_sc_mcu7t5v0__oai21_1
X_3915_ _7589_/Q _7588_/Q _7593_/Q _3915_/Z VDD VDD VSS VSS gf180mcu_fd_sc_mcu7t5v0__xor3_1
X_6703_ _6703_/I _7749_/D VDD VDD VSS VSS gf180mcu_fd_sc_mcu7t5v0__clkinv_1
X_7683_ _7683_/D _7799_/RN _7683_/CLK _7683_/Q VDD VDD VSS VSS gf180mcu_fd_sc_mcu7t5v0__dffrnq_1
XFILLER_32_493 VDD VDD VSS VSS gf180mcu_fd_sc_mcu7t5v0__fill_1
X_4895_ _7162_/Q _4896_/A2 _4896_/B VDD VDD VSS VSS gf180mcu_fd_sc_mcu7t5v0__nand2_1
XTAP_TAPCELL_ROW_50_959 VDD VSS gf180mcu_fd_sc_mcu7t5v0__filltie
X_3846_ _3829_/Z _3844_/Z _3845_/Z _3846_/Z VDD VDD VSS VSS gf180mcu_fd_sc_mcu7t5v0__xor3_1
X_6634_ _5368_/Z _6635_/A3 _6634_/B _6636_/A2 VDD VDD VSS VSS gf180mcu_fd_sc_mcu7t5v0__aoi21_1
XTAP_TAPCELL_ROW_30_672 VDD VSS gf180mcu_fd_sc_mcu7t5v0__filltie
XTAP_TAPCELL_ROW_30_683 VDD VSS gf180mcu_fd_sc_mcu7t5v0__filltie
X_3777_ _7757_/Q _7758_/Q _6571_/S _3777_/Z VDD VDD VSS VSS gf180mcu_fd_sc_mcu7t5v0__and3_1
X_6565_ _7700_/Q _7699_/Q _6566_/S _7700_/D VDD VDD VSS VSS gf180mcu_fd_sc_mcu7t5v0__mux2_2
XTAP_TAPCELL_ROW_76_1324 VDD VSS gf180mcu_fd_sc_mcu7t5v0__filltie
X_5516_ _7300_/Q _5535_/C2 _5562_/A2 _7293_/Q _7503_/Q _5516_/C2 _5517_/A3 VDD VDD
+ VSS VSS gf180mcu_fd_sc_mcu7t5v0__oai222_1
X_6496_ _7674_/Q _6492_/Z _6497_/A3 VDD VDD VSS VSS gf180mcu_fd_sc_mcu7t5v0__nor2_1
X_5447_ _7417_/Q _5597_/A2 _5597_/B1 _7403_/Q _5449_/A2 VDD VDD VSS VSS gf180mcu_fd_sc_mcu7t5v0__oai22_1
XFILLER_87_600 VDD VDD VSS VSS gf180mcu_fd_sc_mcu7t5v0__fill_1
X_5378_ _5514_/C _5378_/A2 _5378_/A3 _5397_/B _5385_/B2 VDD VDD VSS VSS gf180mcu_fd_sc_mcu7t5v0__oai31_1
XFILLER_101_410 VDD VDD VSS VSS gf180mcu_fd_sc_mcu7t5v0__fill_2
X_4329_ _6879_/Q _4336_/A2 _4330_/B VDD VDD VSS VSS gf180mcu_fd_sc_mcu7t5v0__nand2_1
X_7117_ _7117_/D _7252_/CLK _7117_/Q VDD VDD VSS VSS gf180mcu_fd_sc_mcu7t5v0__dffq_1
X_7048_ _7048_/D _7055_/CLK _7048_/Q VDD VDD VSS VSS gf180mcu_fd_sc_mcu7t5v0__dffq_1
XFILLER_101_454 VDD VDD VSS VSS gf180mcu_fd_sc_mcu7t5v0__fill_2
XPHY_EDGE_ROW_114_Right_114 VDD VSS gf180mcu_fd_sc_mcu7t5v0__endcap
XFILLER_101_498 VDD VDD VSS VSS gf180mcu_fd_sc_mcu7t5v0__fill_1
XFILLER_75_839 VDD VDD VSS VSS gf180mcu_fd_sc_mcu7t5v0__fill_1
XTAP_TAPCELL_ROW_87_1475 VDD VSS gf180mcu_fd_sc_mcu7t5v0__filltie
XTAP_TAPCELL_ROW_38_794 VDD VSS gf180mcu_fd_sc_mcu7t5v0__filltie
XFILLER_43_769 VDD VDD VSS VSS gf180mcu_fd_sc_mcu7t5v0__fill_1
Xwire513 wire513/I wire513/Z VDD VDD VSS VSS gf180mcu_fd_sc_mcu7t5v0__buf_4
XFILLER_7_626 VDD VDD VSS VSS gf180mcu_fd_sc_mcu7t5v0__fillcap_4
XFILLER_78_644 VDD VDD VSS VSS gf180mcu_fd_sc_mcu7t5v0__fillcap_4
XFILLER_93_614 VDD VDD VSS VSS gf180mcu_fd_sc_mcu7t5v0__fill_1
XFILLER_77_165 VDD VDD VSS VSS gf180mcu_fd_sc_mcu7t5v0__fill_2
XFILLER_93_669 VDD VDD VSS VSS gf180mcu_fd_sc_mcu7t5v0__fill_2
XFILLER_19_766 VDD VDD VSS VSS gf180mcu_fd_sc_mcu7t5v0__fillcap_4
XFILLER_61_566 VDD VDD VSS VSS gf180mcu_fd_sc_mcu7t5v0__fill_1
X_3700_ _3700_/A1 _3700_/A2 _3700_/A3 _3700_/A4 _3702_/A2 VDD VDD VSS VSS gf180mcu_fd_sc_mcu7t5v0__nand4_1
XTAP_TAPCELL_ROW_16_488 VDD VSS gf180mcu_fd_sc_mcu7t5v0__filltie
XTAP_TAPCELL_ROW_16_477 VDD VSS gf180mcu_fd_sc_mcu7t5v0__filltie
XTAP_TAPCELL_ROW_60_1103 VDD VSS gf180mcu_fd_sc_mcu7t5v0__filltie
X_4680_ _4708_/A1 _4686_/A2 _4680_/B _7054_/D VDD VDD VSS VSS gf180mcu_fd_sc_mcu7t5v0__oai21_1
X_3631_ _3383_/I _3631_/A2 _3631_/Z VDD VDD VSS VSS gf180mcu_fd_sc_mcu7t5v0__xor2_1
X_3562_ _7882_/I input77/Z _3561_/Z _3562_/Z VDD VDD VSS VSS gf180mcu_fd_sc_mcu7t5v0__xor3_1
X_6350_ input54/Z _6352_/S _6351_/B VDD VDD VSS VSS gf180mcu_fd_sc_mcu7t5v0__nand2_1
X_5301_ wire517/I _7448_/Q _5302_/S _7448_/D VDD VDD VSS VSS gf180mcu_fd_sc_mcu7t5v0__mux2_2
XFILLER_89_909 VDD VDD VSS VSS gf180mcu_fd_sc_mcu7t5v0__fill_1
X_6281_ _7636_/Q _6283_/A2 _6283_/B1 _7801_/D _6283_/C1 _7526_/Q _6282_/B2 VDD VDD
+ VSS VSS gf180mcu_fd_sc_mcu7t5v0__aoi222_1
X_3493_ _3493_/A1 _3500_/B _3925_/A2 VDD VDD VSS VSS gf180mcu_fd_sc_mcu7t5v0__nor2_1
XTAP_TAPCELL_ROW_58_1065 VDD VSS gf180mcu_fd_sc_mcu7t5v0__filltie
XTAP_TAPCELL_ROW_58_1076 VDD VSS gf180mcu_fd_sc_mcu7t5v0__filltie
XFILLER_103_719 VDD VDD VSS VSS gf180mcu_fd_sc_mcu7t5v0__fill_2
X_5232_ _5239_/I0 _7379_/Q _5232_/S _7379_/D VDD VDD VSS VSS gf180mcu_fd_sc_mcu7t5v0__mux2_2
X_5163_ _5345_/I0 _7310_/Q _5169_/S _7310_/D VDD VDD VSS VSS gf180mcu_fd_sc_mcu7t5v0__mux2_2
XTAP_TAPCELL_ROW_71_1254 VDD VSS gf180mcu_fd_sc_mcu7t5v0__filltie
XFILLER_111_752 VDD VDD VSS VSS gf180mcu_fd_sc_mcu7t5v0__fillcap_16
X_4114_ _4114_/A1 _4135_/A2 _4966_/A2 VDD VDD VSS VSS gf180mcu_fd_sc_mcu7t5v0__nand2_1
X_5094_ _5094_/A1 _5106_/A2 _5094_/B _7261_/D VDD VDD VSS VSS gf180mcu_fd_sc_mcu7t5v0__oai21_1
X_4045_ _6767_/Q _4658_/A2 _4046_/B VDD VDD VSS VSS gf180mcu_fd_sc_mcu7t5v0__nand2_1
XFILLER_80_831 VDD VDD VSS VSS gf180mcu_fd_sc_mcu7t5v0__fill_1
X_7804_ _7804_/D _7810_/RN _7804_/CLK _7804_/Q VDD VDD VSS VSS gf180mcu_fd_sc_mcu7t5v0__dffrnq_1
XTAP_TAPCELL_ROW_35_742 VDD VSS gf180mcu_fd_sc_mcu7t5v0__filltie
XTAP_TAPCELL_ROW_35_753 VDD VSS gf180mcu_fd_sc_mcu7t5v0__filltie
X_5996_ _5997_/C _5996_/A2 _5996_/B _6136_/B _6000_/B VDD VDD VSS VSS gf180mcu_fd_sc_mcu7t5v0__oai211_1
X_7735_ _7735_/D _7736_/RN _7735_/CLK _7735_/Q VDD VDD VSS VSS gf180mcu_fd_sc_mcu7t5v0__dffrnq_1
X_4947_ _7188_/Q _4952_/A2 _4948_/B VDD VDD VSS VSS gf180mcu_fd_sc_mcu7t5v0__nand2_1
X_7666_ _7666_/D _7671_/RN _7669_/CLK _7666_/Q VDD VDD VSS VSS gf180mcu_fd_sc_mcu7t5v0__dffrnq_1
X_4878_ _5060_/A1 _4882_/A2 _4878_/B _7153_/D VDD VDD VSS VSS gf180mcu_fd_sc_mcu7t5v0__oai21_1
X_3829_ _7573_/Q _7579_/Q _3829_/Z VDD VDD VSS VSS gf180mcu_fd_sc_mcu7t5v0__xor2_1
X_6617_ _6617_/A1 _6617_/A2 _6621_/B _6617_/C _7722_/D VDD VDD VSS VSS gf180mcu_fd_sc_mcu7t5v0__aoi211_1
X_7597_ _7597_/D _7668_/RN _7670_/CLK _7597_/Q VDD VDD VSS VSS gf180mcu_fd_sc_mcu7t5v0__dffrnq_1
XFILLER_106_524 VDD VDD VSS VSS gf180mcu_fd_sc_mcu7t5v0__fill_1
X_6548_ _7692_/Q _6546_/Z _6550_/A2 VDD VDD VSS VSS gf180mcu_fd_sc_mcu7t5v0__nor2_1
X_6479_ _6576_/S _6479_/I1 _6479_/S _7671_/D VDD VDD VSS VSS gf180mcu_fd_sc_mcu7t5v0__mux2_2
XFILLER_87_430 VDD VDD VSS VSS gf180mcu_fd_sc_mcu7t5v0__fill_1
XTAP_TAPCELL_ROW_89_1504 VDD VSS gf180mcu_fd_sc_mcu7t5v0__filltie
XFILLER_102_796 VDD VDD VSS VSS gf180mcu_fd_sc_mcu7t5v0__fill_1
XFILLER_102_785 VDD VDD VSS VSS gf180mcu_fd_sc_mcu7t5v0__fill_1
XFILLER_28_574 VDD VDD VSS VSS gf180mcu_fd_sc_mcu7t5v0__fillcap_16
XFILLER_62_319 VDD VDD VSS VSS gf180mcu_fd_sc_mcu7t5v0__fill_1
XFILLER_71_842 VDD VDD VSS VSS gf180mcu_fd_sc_mcu7t5v0__fillcap_8
XFILLER_43_555 VDD VDD VSS VSS gf180mcu_fd_sc_mcu7t5v0__fillcap_4
XFILLER_43_566 VDD VDD VSS VSS gf180mcu_fd_sc_mcu7t5v0__fill_2
XFILLER_71_897 VDD VDD VSS VSS gf180mcu_fd_sc_mcu7t5v0__fillcap_4
XTAP_TAPCELL_ROW_13_447 VDD VSS gf180mcu_fd_sc_mcu7t5v0__filltie
XTAP_TAPCELL_ROW_13_436 VDD VSS gf180mcu_fd_sc_mcu7t5v0__filltie
XFILLER_8_979 VDD VDD VSS VSS gf180mcu_fd_sc_mcu7t5v0__fill_2
XFILLER_7_434 VDD VDD VSS VSS gf180mcu_fd_sc_mcu7t5v0__fill_1
XFILLER_7_489 VDD VDD VSS VSS gf180mcu_fd_sc_mcu7t5v0__fill_1
XTAP_TAPCELL_ROW_111_1811 VDD VSS gf180mcu_fd_sc_mcu7t5v0__filltie
Xload_slew304 _6074_/B1 _6228_/B1 VDD VDD VSS VSS gf180mcu_fd_sc_mcu7t5v0__buf_4
Xload_slew315 _6215_/B1 _6211_/B1 VDD VDD VSS VSS gf180mcu_fd_sc_mcu7t5v0__buf_4
Xload_slew326 _6104_/B1 _6236_/A2 VDD VDD VSS VSS gf180mcu_fd_sc_mcu7t5v0__buf_4
Xload_slew348 fanout346/Z _6076_/A2 VDD VDD VSS VSS gf180mcu_fd_sc_mcu7t5v0__buf_4
Xload_slew359 _6225_/B1 _6174_/A2 VDD VDD VSS VSS gf180mcu_fd_sc_mcu7t5v0__buf_4
XFILLER_93_422 VDD VDD VSS VSS gf180mcu_fd_sc_mcu7t5v0__fill_1
XFILLER_81_628 VDD VDD VSS VSS gf180mcu_fd_sc_mcu7t5v0__fill_2
XTAP_TAPCELL_ROW_109_1784 VDD VSS gf180mcu_fd_sc_mcu7t5v0__filltie
XFILLER_46_382 VDD VDD VSS VSS gf180mcu_fd_sc_mcu7t5v0__fill_2
X_5850_ _7122_/Q _6097_/A2 _6215_/A2 _7101_/Q _6214_/B _5854_/A2 VDD VDD VSS VSS gf180mcu_fd_sc_mcu7t5v0__oai221_1
XTAP_TAPCELL_ROW_32_701 VDD VSS gf180mcu_fd_sc_mcu7t5v0__filltie
XTAP_TAPCELL_ROW_32_712 VDD VSS gf180mcu_fd_sc_mcu7t5v0__filltie
XFILLER_34_588 VDD VDD VSS VSS gf180mcu_fd_sc_mcu7t5v0__fillcap_4
X_5781_ _7240_/Q _6235_/B1 _6236_/B1 _7233_/Q _6236_/C _5785_/A2 VDD VDD VSS VSS gf180mcu_fd_sc_mcu7t5v0__oai221_1
X_4801_ _7115_/Q _4812_/A2 _4802_/B VDD VDD VSS VSS gf180mcu_fd_sc_mcu7t5v0__nand2_1
X_4732_ wire268/Z _4742_/A2 _4732_/B _7080_/D VDD VDD VSS VSS gf180mcu_fd_sc_mcu7t5v0__oai21_1
X_7520_ _7520_/D _7760_/RN _7765_/CLK _7520_/Q VDD VDD VSS VSS gf180mcu_fd_sc_mcu7t5v0__dffrnq_1
X_4663_ _7046_/Q _4672_/A2 _4664_/B VDD VDD VSS VSS gf180mcu_fd_sc_mcu7t5v0__nand2_1
X_7451_ _7451_/D _7451_/CLK _7451_/Q VDD VDD VSS VSS gf180mcu_fd_sc_mcu7t5v0__dffq_1
X_6402_ _7659_/Q _6451_/A2 _6403_/B VDD VDD VSS VSS gf180mcu_fd_sc_mcu7t5v0__nand2_1
X_3614_ _3682_/C input78/Z _3614_/Z VDD VDD VSS VSS gf180mcu_fd_sc_mcu7t5v0__xor2_1
X_4594_ _4748_/A1 _4602_/A2 _4594_/B _7011_/D VDD VDD VSS VSS gf180mcu_fd_sc_mcu7t5v0__oai21_1
X_7382_ _7382_/D _7735_/CLK _7382_/Q VDD VDD VSS VSS gf180mcu_fd_sc_mcu7t5v0__dffq_1
X_3545_ _3383_/I input26/Z _3640_/A1 VDD VDD VSS VSS gf180mcu_fd_sc_mcu7t5v0__xnor2_1
X_6333_ _6333_/A1 _6338_/S _6333_/B _7625_/D VDD VDD VSS VSS gf180mcu_fd_sc_mcu7t5v0__oai21_1
XFILLER_116_877 VDD VDD VSS VSS gf180mcu_fd_sc_mcu7t5v0__fillcap_64
X_6264_ _7628_/Q _6285_/A2 _6268_/B1 _7709_/Q _6265_/B2 VDD VDD VSS VSS gf180mcu_fd_sc_mcu7t5v0__aoi22_1
X_3476_ _3476_/I _7796_/D VDD VDD VSS VSS gf180mcu_fd_sc_mcu7t5v0__clkinv_1
X_5215_ _5341_/I0 _7362_/Q _5218_/S _7362_/D VDD VDD VSS VSS gf180mcu_fd_sc_mcu7t5v0__mux2_2
X_6195_ _6799_/Q _6225_/A2 _6212_/B1 _6782_/Q _6195_/C _6196_/A2 VDD VDD VSS VSS gf180mcu_fd_sc_mcu7t5v0__oai221_1
XFILLER_57_603 VDD VDD VSS VSS gf180mcu_fd_sc_mcu7t5v0__fill_1
X_5146_ wire521/Z _7293_/Q _5148_/S _7293_/D VDD VDD VSS VSS gf180mcu_fd_sc_mcu7t5v0__mux2_2
XFILLER_29_316 VDD VDD VSS VSS gf180mcu_fd_sc_mcu7t5v0__fill_2
X_5077_ _7253_/Q _5078_/A2 _5078_/B VDD VDD VSS VSS gf180mcu_fd_sc_mcu7t5v0__nor2_1
X_4028_ _6762_/Q _4588_/A2 _4029_/B VDD VDD VSS VSS gf180mcu_fd_sc_mcu7t5v0__nand2_1
XFILLER_37_360 VDD VDD VSS VSS gf180mcu_fd_sc_mcu7t5v0__fill_1
XFILLER_72_617 VDD VDD VSS VSS gf180mcu_fd_sc_mcu7t5v0__fill_2
XTAP_TAPCELL_ROW_84_1434 VDD VSS gf180mcu_fd_sc_mcu7t5v0__filltie
XFILLER_53_842 VDD VDD VSS VSS gf180mcu_fd_sc_mcu7t5v0__fill_1
X_5979_ _7012_/Q _6212_/B1 _6084_/C _5981_/A1 VDD VDD VSS VSS gf180mcu_fd_sc_mcu7t5v0__oai21_1
XFILLER_100_32 VDD VDD VSS VSS gf180mcu_fd_sc_mcu7t5v0__fill_2
X_7718_ _7718_/D _7800_/RN _7796_/CLK _7718_/Q VDD VDD VSS VSS gf180mcu_fd_sc_mcu7t5v0__dffrnq_1
XFILLER_21_772 VDD VDD VSS VSS gf180mcu_fd_sc_mcu7t5v0__fillcap_64
X_7649_ _7649_/D _7800_/RN _7796_/CLK _7649_/Q VDD VDD VSS VSS gf180mcu_fd_sc_mcu7t5v0__dffrnq_1
XTAP_TAPCELL_ROW_95_1585 VDD VSS gf180mcu_fd_sc_mcu7t5v0__filltie
XFILLER_4_459 VDD VDD VSS VSS gf180mcu_fd_sc_mcu7t5v0__fill_1
XFILLER_75_422 VDD VDD VSS VSS gf180mcu_fd_sc_mcu7t5v0__fill_1
XTAP_TAPCELL_ROW_18_506 VDD VSS gf180mcu_fd_sc_mcu7t5v0__filltie
XTAP_TAPCELL_ROW_18_517 VDD VSS gf180mcu_fd_sc_mcu7t5v0__filltie
XFILLER_44_864 VDD VDD VSS VSS gf180mcu_fd_sc_mcu7t5v0__fillcap_8
XFILLER_11_282 VDD VDD VSS VSS gf180mcu_fd_sc_mcu7t5v0__fill_2
XTAP_TAPCELL_ROW_55_1024 VDD VSS gf180mcu_fd_sc_mcu7t5v0__filltie
XFILLER_113_836 VDD VDD VSS VSS gf180mcu_fd_sc_mcu7t5v0__fillcap_4
XTAP_TAPCELL_ROW_55_1035 VDD VSS gf180mcu_fd_sc_mcu7t5v0__filltie
X_5000_ _5070_/A1 _5008_/A2 _5000_/B _7214_/D VDD VDD VSS VSS gf180mcu_fd_sc_mcu7t5v0__oai21_1
Xload_slew189 _4126_/A1 _4144_/A1 VDD VDD VSS VSS gf180mcu_fd_sc_mcu7t5v0__buf_2
XFILLER_15_2 VDD VDD VSS VSS gf180mcu_fd_sc_mcu7t5v0__fill_1
XFILLER_82_937 VDD VDD VSS VSS gf180mcu_fd_sc_mcu7t5v0__fillcap_8
X_6951_ _6951_/D _7003_/CLK _6951_/Q VDD VDD VSS VSS gf180mcu_fd_sc_mcu7t5v0__dffq_1
XFILLER_19_371 VDD VDD VSS VSS gf180mcu_fd_sc_mcu7t5v0__fill_1
XFILLER_35_842 VDD VDD VSS VSS gf180mcu_fd_sc_mcu7t5v0__fillcap_64
X_6882_ _6882_/D _6882_/CLK _6882_/Q VDD VDD VSS VSS gf180mcu_fd_sc_mcu7t5v0__dffq_1
XFILLER_50_801 VDD VDD VSS VSS gf180mcu_fd_sc_mcu7t5v0__fillcap_4
X_5902_ _5902_/A1 _5902_/A2 _6237_/B _5902_/C _5937_/C VDD VDD VSS VSS gf180mcu_fd_sc_mcu7t5v0__oai211_1
XFILLER_90_981 VDD VDD VSS VSS gf180mcu_fd_sc_mcu7t5v0__fill_1
X_5833_ _5833_/A1 _5833_/A2 _6136_/B _5834_/B2 VDD VDD VSS VSS gf180mcu_fd_sc_mcu7t5v0__oai21_1
XFILLER_50_812 VDD VDD VSS VSS gf180mcu_fd_sc_mcu7t5v0__fillcap_8
XTAP_TAPCELL_ROW_66_1186 VDD VSS gf180mcu_fd_sc_mcu7t5v0__filltie
XTAP_TAPCELL_ROW_45_892 VDD VSS gf180mcu_fd_sc_mcu7t5v0__filltie
X_5764_ _5764_/A1 _5764_/A2 _6196_/B _5764_/C _5765_/A3 VDD VDD VSS VSS gf180mcu_fd_sc_mcu7t5v0__oai211_1
X_7503_ _7503_/D _7505_/CLK _7503_/Q VDD VDD VSS VSS gf180mcu_fd_sc_mcu7t5v0__dffq_1
X_4715_ _7072_/Q _4728_/A2 _4716_/B VDD VDD VSS VSS gf180mcu_fd_sc_mcu7t5v0__nand2_1
X_5695_ input34/Z _5738_/A2 _5695_/B _7563_/D VDD VDD VSS VSS gf180mcu_fd_sc_mcu7t5v0__aoi21_1
X_4646_ _5094_/A1 _4658_/A2 _4646_/B _7037_/D VDD VDD VSS VSS gf180mcu_fd_sc_mcu7t5v0__oai21_1
X_7434_ _7434_/D _7754_/CLK _7434_/Q VDD VDD VSS VSS gf180mcu_fd_sc_mcu7t5v0__dffq_1
X_4577_ _7003_/Q _4588_/A2 _4578_/B VDD VDD VSS VSS gf180mcu_fd_sc_mcu7t5v0__nand2_1
X_7365_ _7365_/D _7822_/CLK _7365_/Q VDD VDD VSS VSS gf180mcu_fd_sc_mcu7t5v0__dffq_1
X_6316_ _7614_/Q input64/Z _6344_/S _7614_/D VDD VDD VSS VSS gf180mcu_fd_sc_mcu7t5v0__mux2_2
XFILLER_104_858 VDD VDD VSS VSS gf180mcu_fd_sc_mcu7t5v0__fillcap_16
X_3528_ _7886_/I _3666_/B _6303_/S VDD VDD VSS VSS gf180mcu_fd_sc_mcu7t5v0__nor2_2
X_7296_ _7296_/D _7418_/CLK _7296_/Q VDD VDD VSS VSS gf180mcu_fd_sc_mcu7t5v0__dffq_1
X_3459_ _7595_/Q _6286_/A1 VDD VDD VSS VSS gf180mcu_fd_sc_mcu7t5v0__clkinv_1
XFILLER_103_357 VDD VDD VSS VSS gf180mcu_fd_sc_mcu7t5v0__fill_1
X_6247_ _7551_/Q _6247_/A2 _5677_/I _7556_/Q _6250_/A2 VDD VDD VSS VSS gf180mcu_fd_sc_mcu7t5v0__aoi22_1
X_6178_ _6178_/I _6179_/B VDD VDD VSS VSS gf180mcu_fd_sc_mcu7t5v0__clkinv_1
X_5129_ _7279_/Q _5134_/A2 _5130_/B VDD VDD VSS VSS gf180mcu_fd_sc_mcu7t5v0__nand2_1
XFILLER_57_422 VDD VDD VSS VSS gf180mcu_fd_sc_mcu7t5v0__fill_2
XFILLER_73_904 VDD VDD VSS VSS gf180mcu_fd_sc_mcu7t5v0__fillcap_4
XFILLER_13_525 VDD VDD VSS VSS gf180mcu_fd_sc_mcu7t5v0__fill_2
XFILLER_13_558 VDD VDD VSS VSS gf180mcu_fd_sc_mcu7t5v0__fill_2
XTAP_TAPCELL_ROW_97_1614 VDD VSS gf180mcu_fd_sc_mcu7t5v0__filltie
XTAP_TAPCELL_ROW_23_575 VDD VSS gf180mcu_fd_sc_mcu7t5v0__filltie
XTAP_TAPCELL_ROW_23_586 VDD VSS gf180mcu_fd_sc_mcu7t5v0__filltie
XFILLER_5_702 VDD VDD VSS VSS gf180mcu_fd_sc_mcu7t5v0__fillcap_64
XFILLER_4_223 VDD VDD VSS VSS gf180mcu_fd_sc_mcu7t5v0__fill_2
XFILLER_107_663 VDD VDD VSS VSS gf180mcu_fd_sc_mcu7t5v0__fill_2
XFILLER_49_912 VDD VDD VSS VSS gf180mcu_fd_sc_mcu7t5v0__fillcap_64
XFILLER_76_742 VDD VDD VSS VSS gf180mcu_fd_sc_mcu7t5v0__fillcap_4
XFILLER_35_138 VDD VDD VSS VSS gf180mcu_fd_sc_mcu7t5v0__fill_2
XFILLER_48_499 VDD VDD VSS VSS gf180mcu_fd_sc_mcu7t5v0__fill_2
XTAP_TAPCELL_ROW_106_1743 VDD VSS gf180mcu_fd_sc_mcu7t5v0__filltie
XFILLER_17_842 VDD VDD VSS VSS gf180mcu_fd_sc_mcu7t5v0__fillcap_64
XFILLER_32_801 VDD VDD VSS VSS gf180mcu_fd_sc_mcu7t5v0__fillcap_4
XFILLER_72_981 VDD VDD VSS VSS gf180mcu_fd_sc_mcu7t5v0__fill_1
XTAP_TAPCELL_ROW_42_840 VDD VSS gf180mcu_fd_sc_mcu7t5v0__filltie
XTAP_TAPCELL_ROW_42_851 VDD VSS gf180mcu_fd_sc_mcu7t5v0__filltie
X_4500_ _4584_/A1 _4504_/A2 _4500_/B _6964_/D VDD VDD VSS VSS gf180mcu_fd_sc_mcu7t5v0__oai21_1
X_5480_ _7299_/Q _5535_/C2 _5482_/A2 VDD VDD VSS VSS gf180mcu_fd_sc_mcu7t5v0__nor2_1
XANTENNA_1 _6947_/D VDD VDD VSS VSS gf180mcu_fd_sc_mcu7t5v0__antenna
X_4431_ _6930_/Q _4434_/A2 _4432_/B VDD VDD VSS VSS gf180mcu_fd_sc_mcu7t5v0__nand2_1
X_4362_ _5132_/A1 _4364_/A2 _4362_/B _6895_/D VDD VDD VSS VSS gf180mcu_fd_sc_mcu7t5v0__oai21_1
XTAP_TAPCELL_ROW_117_1894 VDD VSS gf180mcu_fd_sc_mcu7t5v0__filltie
X_7150_ _7150_/D _7233_/CLK _7150_/Q VDD VDD VSS VSS gf180mcu_fd_sc_mcu7t5v0__dffq_1
X_7081_ _7081_/D _7101_/CLK _7081_/Q VDD VDD VSS VSS gf180mcu_fd_sc_mcu7t5v0__dffq_1
X_4293_ _6861_/Q _4294_/A2 _4294_/B VDD VDD VSS VSS gf180mcu_fd_sc_mcu7t5v0__nand2_1
X_6101_ _7231_/Q _6104_/B1 _6171_/A2 _7238_/Q _7252_/Q _6192_/A2 _6102_/A2 VDD VDD
+ VSS VSS gf180mcu_fd_sc_mcu7t5v0__oai222_1
XFILLER_86_539 VDD VDD VSS VSS gf180mcu_fd_sc_mcu7t5v0__fill_2
X_6032_ _6032_/A1 _6032_/A2 _6216_/B _6033_/B2 VDD VDD VSS VSS gf180mcu_fd_sc_mcu7t5v0__oai21_1
XFILLER_39_422 VDD VDD VSS VSS gf180mcu_fd_sc_mcu7t5v0__fill_1
XFILLER_66_263 VDD VDD VSS VSS gf180mcu_fd_sc_mcu7t5v0__fill_1
XTAP_TAPCELL_ROW_68_1204 VDD VSS gf180mcu_fd_sc_mcu7t5v0__filltie
XFILLER_94_594 VDD VDD VSS VSS gf180mcu_fd_sc_mcu7t5v0__fill_1
XFILLER_94_583 VDD VDD VSS VSS gf180mcu_fd_sc_mcu7t5v0__fill_2
XFILLER_82_734 VDD VDD VSS VSS gf180mcu_fd_sc_mcu7t5v0__fill_1
XFILLER_82_723 VDD VDD VSS VSS gf180mcu_fd_sc_mcu7t5v0__fill_1
XTAP_TAPCELL_ROW_68_1215 VDD VSS gf180mcu_fd_sc_mcu7t5v0__filltie
X_6934_ _6934_/D _7259_/CLK _6934_/Q VDD VDD VSS VSS gf180mcu_fd_sc_mcu7t5v0__dffq_1
X_6865_ _6865_/D _7724_/CLK _6865_/Q VDD VDD VSS VSS gf180mcu_fd_sc_mcu7t5v0__dffq_1
XFILLER_22_322 VDD VDD VSS VSS gf180mcu_fd_sc_mcu7t5v0__fill_2
XFILLER_10_517 VDD VDD VSS VSS gf180mcu_fd_sc_mcu7t5v0__fill_1
X_6796_ _6796_/D _7253_/CLK _6796_/Q VDD VDD VSS VSS gf180mcu_fd_sc_mcu7t5v0__dffq_1
XFILLER_50_664 VDD VDD VSS VSS gf180mcu_fd_sc_mcu7t5v0__fill_1
X_5816_ _7779_/Q _5691_/I _5878_/A2 _7568_/Q _5817_/A3 VDD VDD VSS VSS gf180mcu_fd_sc_mcu7t5v0__aoi22_1
X_5747_ _5808_/A1 _5748_/A2 _6488_/B wire190/I VDD VDD VSS VSS gf180mcu_fd_sc_mcu7t5v0__nor3_2
XTAP_TAPCELL_ROW_20_534 VDD VSS gf180mcu_fd_sc_mcu7t5v0__filltie
XTAP_TAPCELL_ROW_20_545 VDD VSS gf180mcu_fd_sc_mcu7t5v0__filltie
XTAP_TAPCELL_ROW_79_1366 VDD VSS gf180mcu_fd_sc_mcu7t5v0__filltie
X_7417_ _7417_/D _7499_/CLK _7417_/Q VDD VDD VSS VSS gf180mcu_fd_sc_mcu7t5v0__dffq_1
X_5678_ _3703_/Z _5678_/A2 _5686_/S VDD VDD VSS VSS gf180mcu_fd_sc_mcu7t5v0__nor2_2
X_4629_ _7029_/Q _4630_/A2 _4630_/B VDD VDD VSS VSS gf180mcu_fd_sc_mcu7t5v0__nand2_1
XFILLER_116_471 VDD VDD VSS VSS gf180mcu_fd_sc_mcu7t5v0__fill_1
XTAP_TAPCELL_ROW_92_1544 VDD VSS gf180mcu_fd_sc_mcu7t5v0__filltie
X_7348_ _7348_/D clkload9/I _7348_/Q VDD VDD VSS VSS gf180mcu_fd_sc_mcu7t5v0__dffq_1
X_7279_ _7279_/D _7279_/CLK _7279_/Q VDD VDD VSS VSS gf180mcu_fd_sc_mcu7t5v0__dffq_1
XTAP_TAPCELL_ROW_28_645 VDD VSS gf180mcu_fd_sc_mcu7t5v0__filltie
XTAP_TAPCELL_ROW_28_656 VDD VSS gf180mcu_fd_sc_mcu7t5v0__filltie
XFILLER_14_801 VDD VDD VSS VSS gf180mcu_fd_sc_mcu7t5v0__fillcap_4
XFILLER_26_661 VDD VDD VSS VSS gf180mcu_fd_sc_mcu7t5v0__fillcap_4
XFILLER_54_981 VDD VDD VSS VSS gf180mcu_fd_sc_mcu7t5v0__fill_1
XTAP_TAPCELL_ROW_101_1673 VDD VSS gf180mcu_fd_sc_mcu7t5v0__filltie
XFILLER_96_837 VDD VDD VSS VSS gf180mcu_fd_sc_mcu7t5v0__fillcap_8
XTAP_TAPCELL_ROW_8_370 VDD VSS gf180mcu_fd_sc_mcu7t5v0__filltie
XFILLER_110_647 VDD VDD VSS VSS gf180mcu_fd_sc_mcu7t5v0__fill_2
XFILLER_96_859 VDD VDD VSS VSS gf180mcu_fd_sc_mcu7t5v0__fill_1
XFILLER_49_720 VDD VDD VSS VSS gf180mcu_fd_sc_mcu7t5v0__fillcap_4
XFILLER_49_753 VDD VDD VSS VSS gf180mcu_fd_sc_mcu7t5v0__fillcap_8
XFILLER_76_583 VDD VDD VSS VSS gf180mcu_fd_sc_mcu7t5v0__fill_1
XTAP_TAPCELL_ROW_47_910 VDD VSS gf180mcu_fd_sc_mcu7t5v0__filltie
XTAP_TAPCELL_ROW_47_921 VDD VSS gf180mcu_fd_sc_mcu7t5v0__filltie
XFILLER_64_712 VDD VDD VSS VSS gf180mcu_fd_sc_mcu7t5v0__fill_1
XFILLER_64_734 VDD VDD VSS VSS gf180mcu_fd_sc_mcu7t5v0__fill_1
X_4980_ _5008_/A1 _4980_/A2 _4980_/B _7204_/D VDD VDD VSS VSS gf180mcu_fd_sc_mcu7t5v0__oai21_1
X_3931_ _7749_/Q _7539_/Q _3930_/Z _3931_/Z VDD VDD VSS VSS gf180mcu_fd_sc_mcu7t5v0__xor3_1
XTAP_TAPCELL_ROW_63_1134 VDD VSS gf180mcu_fd_sc_mcu7t5v0__filltie
X_6650_ _7733_/Q _6650_/A2 _6652_/B VDD VDD VSS VSS gf180mcu_fd_sc_mcu7t5v0__nand2_1
X_3862_ _6679_/I0 _3862_/A2 _3863_/B VDD VDD VSS VSS gf180mcu_fd_sc_mcu7t5v0__nand2_1
XTAP_TAPCELL_ROW_63_1145 VDD VSS gf180mcu_fd_sc_mcu7t5v0__filltie
X_5601_ _5601_/A1 _5601_/A2 _5614_/B _5602_/B2 VDD VDD VSS VSS gf180mcu_fd_sc_mcu7t5v0__oai21_1
X_6581_ _6201_/C _6582_/A3 _6597_/A2 VDD VDD VSS VSS gf180mcu_fd_sc_mcu7t5v0__nand2_1
X_3793_ _7771_/Q _7769_/Q _3793_/B _5632_/A2 VDD VDD VSS VSS gf180mcu_fd_sc_mcu7t5v0__oai21_1
X_5532_ _7490_/Q wire428/I _5607_/A2 _7483_/Q _7469_/Q wire420/I _5533_/A2 VDD VDD
+ VSS VSS gf180mcu_fd_sc_mcu7t5v0__oai222_1
X_5463_ _7510_/Q _6732_/A1 _5463_/B _5465_/A2 VDD VDD VSS VSS gf180mcu_fd_sc_mcu7t5v0__oai21_1
X_4414_ _5086_/A1 _4420_/A2 _4414_/B _6921_/D VDD VDD VSS VSS gf180mcu_fd_sc_mcu7t5v0__oai21_1
X_5394_ _5394_/A1 _5394_/A2 _5398_/B1 VDD VDD VSS VSS gf180mcu_fd_sc_mcu7t5v0__nor2_1
X_7202_ _7202_/D _7216_/CLK _7202_/Q VDD VDD VSS VSS gf180mcu_fd_sc_mcu7t5v0__dffq_1
X_4345_ _6887_/Q _4350_/A2 _4346_/B VDD VDD VSS VSS gf180mcu_fd_sc_mcu7t5v0__nand2_1
X_7133_ _7133_/D _7248_/CLK _7133_/Q VDD VDD VSS VSS gf180mcu_fd_sc_mcu7t5v0__dffq_1
Xfanout305 _6215_/B1 _6138_/B1 VDD VDD VSS VSS gf180mcu_fd_sc_mcu7t5v0__dlyd_1
XTAP_TAPCELL_ROW_74_1296 VDD VSS gf180mcu_fd_sc_mcu7t5v0__filltie
X_7064_ _7064_/D _7064_/CLK _7064_/Q VDD VDD VSS VSS gf180mcu_fd_sc_mcu7t5v0__dffq_1
X_4276_ _5130_/A1 _4280_/A2 _4276_/B _6852_/D VDD VDD VSS VSS gf180mcu_fd_sc_mcu7t5v0__oai21_1
Xfanout349 wire353/I _6104_/A2 VDD VDD VSS VSS gf180mcu_fd_sc_mcu7t5v0__dlyd_1
X_6015_ _7272_/Q _6198_/C2 _6089_/B1 _7279_/Q _6845_/Q _6091_/A2 _6016_/A2 VDD VDD
+ VSS VSS gf180mcu_fd_sc_mcu7t5v0__oai222_1
XFILLER_100_179 VDD VDD VSS VSS gf180mcu_fd_sc_mcu7t5v0__fill_1
XFILLER_36_49 VDD VDD VSS VSS gf180mcu_fd_sc_mcu7t5v0__fill_2
XFILLER_82_597 VDD VDD VSS VSS gf180mcu_fd_sc_mcu7t5v0__fillcap_4
XTAP_TAPCELL_ROW_25_604 VDD VSS gf180mcu_fd_sc_mcu7t5v0__filltie
XTAP_TAPCELL_ROW_25_615 VDD VSS gf180mcu_fd_sc_mcu7t5v0__filltie
XFILLER_36_981 VDD VDD VSS VSS gf180mcu_fd_sc_mcu7t5v0__fill_1
X_6917_ _6917_/D _7252_/CLK _6917_/Q VDD VDD VSS VSS gf180mcu_fd_sc_mcu7t5v0__dffq_1
X_6848_ _6848_/D _7683_/CLK _6848_/Q VDD VDD VSS VSS gf180mcu_fd_sc_mcu7t5v0__dffq_1
XFILLER_50_483 VDD VDD VSS VSS gf180mcu_fd_sc_mcu7t5v0__fill_1
X_6779_ _6779_/D _7250_/CLK _6779_/Q VDD VDD VSS VSS gf180mcu_fd_sc_mcu7t5v0__dffq_1
XFILLER_109_758 VDD VDD VSS VSS gf180mcu_fd_sc_mcu7t5v0__fill_1
XFILLER_78_804 VDD VDD VSS VSS gf180mcu_fd_sc_mcu7t5v0__fill_1
XFILLER_93_818 VDD VDD VSS VSS gf180mcu_fd_sc_mcu7t5v0__fill_1
XTAP_TAPCELL_ROW_103_1702 VDD VSS gf180mcu_fd_sc_mcu7t5v0__filltie
XFILLER_61_704 VDD VDD VSS VSS gf180mcu_fd_sc_mcu7t5v0__fill_1
XTAP_TAPCELL_ROW_52_990 VDD VSS gf180mcu_fd_sc_mcu7t5v0__filltie
XFILLER_108_780 VDD VDD VSS VSS gf180mcu_fd_sc_mcu7t5v0__fillcap_4
XTAP_TAPCELL_ROW_114_1853 VDD VSS gf180mcu_fd_sc_mcu7t5v0__filltie
XFILLER_111_912 VDD VDD VSS VSS gf180mcu_fd_sc_mcu7t5v0__fillcap_64
X_4130_ _6794_/Q _5036_/A2 _4131_/B VDD VDD VSS VSS gf180mcu_fd_sc_mcu7t5v0__nand2_1
XFILLER_110_444 VDD VDD VSS VSS gf180mcu_fd_sc_mcu7t5v0__fill_1
XFILLER_96_667 VDD VDD VSS VSS gf180mcu_fd_sc_mcu7t5v0__fillcap_4
XFILLER_95_144 VDD VDD VSS VSS gf180mcu_fd_sc_mcu7t5v0__fill_1
X_4061_ _6772_/Q _4728_/A2 _4062_/B VDD VDD VSS VSS gf180mcu_fd_sc_mcu7t5v0__nand2_1
XFILLER_49_572 VDD VDD VSS VSS gf180mcu_fd_sc_mcu7t5v0__fillcap_4
X_7820_ input1/Z _7823_/RN _7823_/CLK _7821_/D VDD VDD VSS VSS gf180mcu_fd_sc_mcu7t5v0__dffsnq_1
XFILLER_36_244 VDD VDD VSS VSS gf180mcu_fd_sc_mcu7t5v0__fill_1
XFILLER_18_981 VDD VDD VSS VSS gf180mcu_fd_sc_mcu7t5v0__fill_1
XFILLER_52_704 VDD VDD VSS VSS gf180mcu_fd_sc_mcu7t5v0__fill_1
XFILLER_52_737 VDD VDD VSS VSS gf180mcu_fd_sc_mcu7t5v0__fillcap_4
X_7751_ _7751_/D wire565/Z _7755_/CLK _7751_/Q VDD VDD VSS VSS gf180mcu_fd_sc_mcu7t5v0__dffrnq_1
X_4963_ _7196_/Q _4966_/A2 _4964_/B VDD VDD VSS VSS gf180mcu_fd_sc_mcu7t5v0__nand2_1
X_3914_ _3908_/Z _3911_/Z _3913_/Z _3914_/Z VDD VDD VSS VSS gf180mcu_fd_sc_mcu7t5v0__xor3_1
X_7682_ _7682_/D _7799_/RN _7692_/CLK _7682_/Q VDD VDD VSS VSS gf180mcu_fd_sc_mcu7t5v0__dffrnq_1
X_6702_ _7749_/Q _6716_/A2 _6714_/B1 _7750_/Q _6703_/I VDD VDD VSS VSS gf180mcu_fd_sc_mcu7t5v0__aoi22_1
X_6633_ _6633_/A1 _6633_/A2 _6633_/B _7727_/D VDD VDD VSS VSS gf180mcu_fd_sc_mcu7t5v0__oai21_1
X_4894_ _5076_/A1 _4896_/A2 _4894_/B _7161_/D VDD VDD VSS VSS gf180mcu_fd_sc_mcu7t5v0__oai21_1
X_3845_ _7574_/Q _7592_/Q _7594_/Q _3845_/Z VDD VDD VSS VSS gf180mcu_fd_sc_mcu7t5v0__xor3_1
XFILLER_20_667 VDD VDD VSS VSS gf180mcu_fd_sc_mcu7t5v0__fillcap_64
X_3776_ _7825_/Q _7519_/D _7825_/D VDD VDD VSS VSS gf180mcu_fd_sc_mcu7t5v0__or2_1
XTAP_TAPCELL_ROW_30_673 VDD VSS gf180mcu_fd_sc_mcu7t5v0__filltie
X_6564_ _7699_/Q _7698_/Q _6566_/S _7699_/D VDD VDD VSS VSS gf180mcu_fd_sc_mcu7t5v0__mux2_2
XTAP_TAPCELL_ROW_76_1325 VDD VSS gf180mcu_fd_sc_mcu7t5v0__filltie
X_6495_ _7672_/Q _7673_/Q _7674_/Q _7791_/Q _6495_/Z VDD VDD VSS VSS gf180mcu_fd_sc_mcu7t5v0__and4_1
X_5515_ _7496_/Q _5515_/A2 _5517_/A2 VDD VDD VSS VSS gf180mcu_fd_sc_mcu7t5v0__nor2_1
XTAP_TAPCELL_ROW_30_684 VDD VSS gf180mcu_fd_sc_mcu7t5v0__filltie
X_5446_ _5549_/C _5446_/A2 _5446_/A3 _5458_/A3 VDD VDD VSS VSS gf180mcu_fd_sc_mcu7t5v0__nor3_1
X_5377_ _7296_/Q _5612_/A2 _5610_/C2 _7499_/Q _5378_/A3 VDD VDD VSS VSS gf180mcu_fd_sc_mcu7t5v0__oai22_1
XFILLER_101_422 VDD VDD VSS VSS gf180mcu_fd_sc_mcu7t5v0__fill_2
X_4328_ _4832_/A1 _4336_/A2 _4328_/B _6878_/D VDD VDD VSS VSS gf180mcu_fd_sc_mcu7t5v0__oai21_1
X_7116_ _7116_/D _7196_/CLK _7116_/Q VDD VDD VSS VSS gf180mcu_fd_sc_mcu7t5v0__dffq_1
X_7047_ _7047_/D _7261_/CLK _7047_/Q VDD VDD VSS VSS gf180mcu_fd_sc_mcu7t5v0__dffq_1
X_4259_ _6844_/Q _4266_/A2 _4260_/B VDD VDD VSS VSS gf180mcu_fd_sc_mcu7t5v0__nand2_1
XTAP_TAPCELL_ROW_87_1476 VDD VSS gf180mcu_fd_sc_mcu7t5v0__filltie
XFILLER_82_372 VDD VDD VSS VSS gf180mcu_fd_sc_mcu7t5v0__fill_1
XFILLER_55_564 VDD VDD VSS VSS gf180mcu_fd_sc_mcu7t5v0__fill_1
XTAP_TAPCELL_ROW_38_784 VDD VSS gf180mcu_fd_sc_mcu7t5v0__filltie
XTAP_TAPCELL_ROW_38_795 VDD VSS gf180mcu_fd_sc_mcu7t5v0__filltie
XFILLER_51_781 VDD VDD VSS VSS gf180mcu_fd_sc_mcu7t5v0__fill_1
Xwire503 _6576_/S _6574_/S VDD VDD VSS VSS gf180mcu_fd_sc_mcu7t5v0__clkbuf_4
XFILLER_109_500 VDD VDD VSS VSS gf180mcu_fd_sc_mcu7t5v0__fill_2
XFILLER_109_511 VDD VDD VSS VSS gf180mcu_fd_sc_mcu7t5v0__fill_1
Xwire525 wire525/I wire525/Z VDD VDD VSS VSS gf180mcu_fd_sc_mcu7t5v0__clkbuf_4
Xload_slew519 _5244_/I0 _5342_/I0 VDD VDD VSS VSS gf180mcu_fd_sc_mcu7t5v0__buf_3
Xload_slew508 wire507/I _4223_/I0 VDD VDD VSS VSS gf180mcu_fd_sc_mcu7t5v0__buf_3
XFILLER_2_387 VDD VDD VSS VSS gf180mcu_fd_sc_mcu7t5v0__fill_2
XFILLER_78_656 VDD VDD VSS VSS gf180mcu_fd_sc_mcu7t5v0__fill_1
XFILLER_78_667 VDD VDD VSS VSS gf180mcu_fd_sc_mcu7t5v0__fill_2
XFILLER_66_807 VDD VDD VSS VSS gf180mcu_fd_sc_mcu7t5v0__fillcap_4
XFILLER_74_862 VDD VDD VSS VSS gf180mcu_fd_sc_mcu7t5v0__fillcap_8
XFILLER_61_512 VDD VDD VSS VSS gf180mcu_fd_sc_mcu7t5v0__fill_2
XFILLER_18_299 VDD VDD VSS VSS gf180mcu_fd_sc_mcu7t5v0__fill_1
XFILLER_34_737 VDD VDD VSS VSS gf180mcu_fd_sc_mcu7t5v0__fillcap_64
XTAP_TAPCELL_ROW_16_489 VDD VSS gf180mcu_fd_sc_mcu7t5v0__filltie
XTAP_TAPCELL_ROW_16_478 VDD VSS gf180mcu_fd_sc_mcu7t5v0__filltie
XTAP_TAPCELL_ROW_60_1104 VDD VSS gf180mcu_fd_sc_mcu7t5v0__filltie
X_3630_ input24/Z input25/Z _3630_/Z VDD VDD VSS VSS gf180mcu_fd_sc_mcu7t5v0__xor2_1
X_3561_ input92/Z input95/Z _3561_/Z VDD VDD VSS VSS gf180mcu_fd_sc_mcu7t5v0__xor2_1
X_5300_ wire521/I _7447_/Q _5302_/S _7447_/D VDD VDD VSS VSS gf180mcu_fd_sc_mcu7t5v0__mux2_2
X_6280_ _6280_/A1 _6284_/A2 _6284_/B1 _6280_/B2 _7592_/D VDD VDD VSS VSS gf180mcu_fd_sc_mcu7t5v0__aoi22_1
X_3492_ _5926_/B _6617_/A1 _3500_/B VDD VDD VSS VSS gf180mcu_fd_sc_mcu7t5v0__nor2_1
XTAP_TAPCELL_ROW_58_1066 VDD VSS gf180mcu_fd_sc_mcu7t5v0__filltie
XTAP_TAPCELL_ROW_58_1077 VDD VSS gf180mcu_fd_sc_mcu7t5v0__filltie
X_5231_ _5343_/I0 _7378_/Q _5232_/S _7378_/D VDD VDD VSS VSS gf180mcu_fd_sc_mcu7t5v0__mux2_2
XFILLER_45_2 VDD VDD VSS VSS gf180mcu_fd_sc_mcu7t5v0__fill_2
X_5162_ wire513/Z _7309_/Q _5162_/S _7309_/D VDD VDD VSS VSS gf180mcu_fd_sc_mcu7t5v0__mux2_2
XTAP_TAPCELL_ROW_71_1255 VDD VSS gf180mcu_fd_sc_mcu7t5v0__filltie
XFILLER_97_976 VDD VDD VSS VSS gf180mcu_fd_sc_mcu7t5v0__fillcap_4
X_5093_ _7261_/Q _5106_/A2 _5094_/B VDD VDD VSS VSS gf180mcu_fd_sc_mcu7t5v0__nand2_1
X_4113_ _4138_/A1 _4138_/A3 _4135_/A2 VDD VDD VSS VSS gf180mcu_fd_sc_mcu7t5v0__nor2_1
XFILLER_56_306 VDD VDD VSS VSS gf180mcu_fd_sc_mcu7t5v0__fill_1
X_4044_ _4129_/A1 _4053_/A2 _4658_/A2 VDD VDD VSS VSS gf180mcu_fd_sc_mcu7t5v0__nand2_1
XFILLER_37_553 VDD VDD VSS VSS gf180mcu_fd_sc_mcu7t5v0__fillcap_4
X_7803_ _7803_/D _7825_/RN clkload8/I _7803_/Q VDD VDD VSS VSS gf180mcu_fd_sc_mcu7t5v0__dffrnq_1
XFILLER_52_523 VDD VDD VSS VSS gf180mcu_fd_sc_mcu7t5v0__fill_2
XFILLER_24_247 VDD VDD VSS VSS gf180mcu_fd_sc_mcu7t5v0__fill_1
XTAP_TAPCELL_ROW_35_743 VDD VSS gf180mcu_fd_sc_mcu7t5v0__filltie
XTAP_TAPCELL_ROW_35_754 VDD VSS gf180mcu_fd_sc_mcu7t5v0__filltie
X_7734_ _7734_/D _7736_/RN _7734_/CLK _7734_/Q VDD VDD VSS VSS gf180mcu_fd_sc_mcu7t5v0__dffrnq_1
X_5995_ _5995_/A1 _5995_/A2 _5995_/B1 _6122_/C _6217_/B _5996_/B VDD VDD VSS VSS gf180mcu_fd_sc_mcu7t5v0__oai221_1
X_4946_ _4946_/A1 _4952_/A2 _4946_/B _7187_/D VDD VDD VSS VSS gf180mcu_fd_sc_mcu7t5v0__oai21_1
X_7665_ _7665_/D _7671_/RN _7669_/CLK _7665_/Q VDD VDD VSS VSS gf180mcu_fd_sc_mcu7t5v0__dffrnq_1
X_4877_ _7153_/Q _4882_/A2 _4878_/B VDD VDD VSS VSS gf180mcu_fd_sc_mcu7t5v0__nand2_1
X_7596_ _7596_/D _7599_/RN _7613_/CLK _7596_/Q VDD VDD VSS VSS gf180mcu_fd_sc_mcu7t5v0__dffrnq_1
X_3828_ _3825_/Z _3826_/Z _3827_/Z _3828_/Z VDD VDD VSS VSS gf180mcu_fd_sc_mcu7t5v0__xor3_1
XFILLER_21_976 VDD VDD VSS VSS gf180mcu_fd_sc_mcu7t5v0__fillcap_4
X_6616_ _7721_/Q _6616_/A2 _6616_/B _7721_/D VDD VDD VSS VSS gf180mcu_fd_sc_mcu7t5v0__aoi21_1
X_6547_ _6559_/A1 _6547_/A2 _6546_/Z _7691_/D VDD VDD VSS VSS gf180mcu_fd_sc_mcu7t5v0__nor3_1
X_3759_ _3728_/Z _3729_/Z _3760_/A3 _3759_/B _7795_/D VDD VDD VSS VSS gf180mcu_fd_sc_mcu7t5v0__oai31_1
X_6478_ _6478_/A1 _6478_/A2 _6478_/B _6479_/I1 VDD VDD VSS VSS gf180mcu_fd_sc_mcu7t5v0__aoi21_1
XPHY_EDGE_ROW_18_Left_137 VDD VSS gf180mcu_fd_sc_mcu7t5v0__endcap
XFILLER_79_409 VDD VDD VSS VSS gf180mcu_fd_sc_mcu7t5v0__fill_1
X_5429_ _5590_/B _5429_/A2 _5429_/A3 _5616_/S _5430_/B2 VDD VDD VSS VSS gf180mcu_fd_sc_mcu7t5v0__oai31_1
XFILLER_102_753 VDD VDD VSS VSS gf180mcu_fd_sc_mcu7t5v0__fill_1
XFILLER_102_742 VDD VDD VSS VSS gf180mcu_fd_sc_mcu7t5v0__fillcap_4
XTAP_TAPCELL_ROW_89_1505 VDD VSS gf180mcu_fd_sc_mcu7t5v0__filltie
XFILLER_48_807 VDD VDD VSS VSS gf180mcu_fd_sc_mcu7t5v0__fill_2
XFILLER_75_637 VDD VDD VSS VSS gf180mcu_fd_sc_mcu7t5v0__fill_2
XFILLER_28_542 VDD VDD VSS VSS gf180mcu_fd_sc_mcu7t5v0__fillcap_32
Xclkbuf_leaf_30_clk_i clkload5/I _7276_/CLK VDD VDD VSS VSS gf180mcu_fd_sc_mcu7t5v0__clkbuf_8
XPHY_EDGE_ROW_27_Left_146 VDD VSS gf180mcu_fd_sc_mcu7t5v0__endcap
XFILLER_16_737 VDD VDD VSS VSS gf180mcu_fd_sc_mcu7t5v0__fillcap_64
XFILLER_28_597 VDD VDD VSS VSS gf180mcu_fd_sc_mcu7t5v0__fillcap_64
XFILLER_71_854 VDD VDD VSS VSS gf180mcu_fd_sc_mcu7t5v0__fill_2
XFILLER_30_228 VDD VDD VSS VSS gf180mcu_fd_sc_mcu7t5v0__fill_2
Xclkbuf_leaf_45_clk_i clkload6/I _6944_/CLK VDD VDD VSS VSS gf180mcu_fd_sc_mcu7t5v0__clkbuf_8
XTAP_TAPCELL_ROW_13_437 VDD VSS gf180mcu_fd_sc_mcu7t5v0__filltie
Xwire322 wire322/I wire322/Z VDD VDD VSS VSS gf180mcu_fd_sc_mcu7t5v0__clkbuf_4
XFILLER_8_947 VDD VDD VSS VSS gf180mcu_fd_sc_mcu7t5v0__fillcap_32
Xwire355 wire355/I wire355/Z VDD VDD VSS VSS gf180mcu_fd_sc_mcu7t5v0__clkbuf_4
XPHY_EDGE_ROW_36_Left_155 VDD VSS gf180mcu_fd_sc_mcu7t5v0__endcap
XTAP_TAPCELL_ROW_111_1812 VDD VSS gf180mcu_fd_sc_mcu7t5v0__filltie
XFILLER_3_696 VDD VDD VSS VSS gf180mcu_fd_sc_mcu7t5v0__fillcap_4
Xload_slew338 _6590_/A2 _6201_/A2 VDD VDD VSS VSS gf180mcu_fd_sc_mcu7t5v0__buf_2
Xload_slew316 _5754_/ZN _6201_/B1 VDD VDD VSS VSS gf180mcu_fd_sc_mcu7t5v0__buf_2
Xload_slew327 _6008_/B1 _6104_/B1 VDD VDD VSS VSS gf180mcu_fd_sc_mcu7t5v0__clkbuf_4
XFILLER_94_979 VDD VDD VSS VSS gf180mcu_fd_sc_mcu7t5v0__fill_2
XPHY_EDGE_ROW_45_Left_164 VDD VSS gf180mcu_fd_sc_mcu7t5v0__endcap
XFILLER_93_489 VDD VDD VSS VSS gf180mcu_fd_sc_mcu7t5v0__fill_1
XTAP_TAPCELL_ROW_109_1785 VDD VSS gf180mcu_fd_sc_mcu7t5v0__filltie
X_4800_ _4996_/A1 _4812_/A2 _4800_/B _7114_/D VDD VDD VSS VSS gf180mcu_fd_sc_mcu7t5v0__oai21_1
XTAP_TAPCELL_ROW_32_702 VDD VSS gf180mcu_fd_sc_mcu7t5v0__filltie
XTAP_TAPCELL_ROW_32_713 VDD VSS gf180mcu_fd_sc_mcu7t5v0__filltie
X_5780_ _7247_/Q _6235_/A2 _6236_/A2 _7226_/Q _5785_/A1 VDD VDD VSS VSS gf180mcu_fd_sc_mcu7t5v0__oai22_1
X_4731_ _7080_/Q _4742_/A2 _4732_/B VDD VDD VSS VSS gf180mcu_fd_sc_mcu7t5v0__nand2_1
X_4662_ _4998_/A1 _4672_/A2 _4662_/B _7045_/D VDD VDD VSS VSS gf180mcu_fd_sc_mcu7t5v0__oai21_1
X_7450_ _7450_/D _7736_/CLK _7450_/Q VDD VDD VSS VSS gf180mcu_fd_sc_mcu7t5v0__dffq_1
X_6401_ _6399_/Z _6411_/B2 _6403_/A2 VDD VDD VSS VSS gf180mcu_fd_sc_mcu7t5v0__xnor2_1
X_3613_ _3677_/S _3688_/A2 _3687_/B1 VDD VDD VSS VSS gf180mcu_fd_sc_mcu7t5v0__nand2_1
XPHY_EDGE_ROW_54_Left_173 VDD VSS gf180mcu_fd_sc_mcu7t5v0__endcap
X_4593_ _7011_/Q _4602_/A2 _4594_/B VDD VDD VSS VSS gf180mcu_fd_sc_mcu7t5v0__nand2_1
X_7381_ _7381_/D _7472_/CLK _7381_/Q VDD VDD VSS VSS gf180mcu_fd_sc_mcu7t5v0__dffq_1
X_3544_ _3631_/A2 _3563_/A1 _3544_/Z VDD VDD VSS VSS gf180mcu_fd_sc_mcu7t5v0__xor2_1
XFILLER_6_490 VDD VDD VSS VSS gf180mcu_fd_sc_mcu7t5v0__fill_2
X_6332_ input40/Z _6341_/S _6333_/B VDD VDD VSS VSS gf180mcu_fd_sc_mcu7t5v0__nand2_1
X_6263_ _6263_/A1 _5744_/B _6274_/B1 _6263_/B2 _7584_/D VDD VDD VSS VSS gf180mcu_fd_sc_mcu7t5v0__aoi22_1
X_3475_ _6609_/A1 _7712_/Q _3476_/I VDD VDD VSS VSS gf180mcu_fd_sc_mcu7t5v0__xor2_1
X_5214_ _5347_/I0 _7361_/Q _5218_/S _7361_/D VDD VDD VSS VSS gf180mcu_fd_sc_mcu7t5v0__mux2_2
X_6194_ _6798_/Q wire355/I _6207_/B1 _6793_/Q _6196_/A1 VDD VDD VSS VSS gf180mcu_fd_sc_mcu7t5v0__oai22_1
XFILLER_97_784 VDD VDD VSS VSS gf180mcu_fd_sc_mcu7t5v0__fillcap_16
X_5145_ wire525/Z _7292_/Q _5148_/S _7292_/D VDD VDD VSS VSS gf180mcu_fd_sc_mcu7t5v0__mux2_2
XPHY_EDGE_ROW_63_Left_182 VDD VSS gf180mcu_fd_sc_mcu7t5v0__endcap
XFILLER_111_594 VDD VDD VSS VSS gf180mcu_fd_sc_mcu7t5v0__fill_2
XFILLER_85_979 VDD VDD VSS VSS gf180mcu_fd_sc_mcu7t5v0__fill_1
X_5076_ _5076_/A1 _5078_/A2 _5076_/B _7252_/D VDD VDD VSS VSS gf180mcu_fd_sc_mcu7t5v0__aoi21_1
X_4027_ _3967_/I _4027_/A2 _4588_/A2 VDD VDD VSS VSS gf180mcu_fd_sc_mcu7t5v0__nand2_1
XTAP_TAPCELL_ROW_84_1435 VDD VSS gf180mcu_fd_sc_mcu7t5v0__filltie
X_5978_ _7054_/Q _6154_/A2 _6151_/A2 _7040_/Q _6227_/C _5982_/A2 VDD VDD VSS VSS gf180mcu_fd_sc_mcu7t5v0__oai221_1
XFILLER_52_375 VDD VDD VSS VSS gf180mcu_fd_sc_mcu7t5v0__fill_1
X_7717_ _7717_/D wire593/Z _7755_/CLK _7717_/Q VDD VDD VSS VSS gf180mcu_fd_sc_mcu7t5v0__dffrnq_1
X_4929_ _7179_/Q _4938_/A2 _4930_/B VDD VDD VSS VSS gf180mcu_fd_sc_mcu7t5v0__nand2_1
X_7648_ _7648_/D _7799_/RN _7796_/CLK _7648_/Q VDD VDD VSS VSS gf180mcu_fd_sc_mcu7t5v0__dffrnq_1
XPHY_EDGE_ROW_72_Left_191 VDD VSS gf180mcu_fd_sc_mcu7t5v0__endcap
XFILLER_5_906 VDD VDD VSS VSS gf180mcu_fd_sc_mcu7t5v0__fillcap_4
X_7579_ _7579_/D _7595_/RN _7671_/CLK _7579_/Q VDD VDD VSS VSS gf180mcu_fd_sc_mcu7t5v0__dffrnq_1
XTAP_TAPCELL_ROW_95_1586 VDD VSS gf180mcu_fd_sc_mcu7t5v0__filltie
XFILLER_102_594 VDD VDD VSS VSS gf180mcu_fd_sc_mcu7t5v0__fill_1
XFILLER_87_294 VDD VDD VSS VSS gf180mcu_fd_sc_mcu7t5v0__fill_2
XFILLER_76_979 VDD VDD VSS VSS gf180mcu_fd_sc_mcu7t5v0__fill_2
XTAP_TAPCELL_ROW_18_507 VDD VSS gf180mcu_fd_sc_mcu7t5v0__filltie
XFILLER_31_559 VDD VDD VSS VSS gf180mcu_fd_sc_mcu7t5v0__fill_1
XTAP_TAPCELL_ROW_55_1025 VDD VSS gf180mcu_fd_sc_mcu7t5v0__filltie
XFILLER_94_721 VDD VDD VSS VSS gf180mcu_fd_sc_mcu7t5v0__fillcap_4
XFILLER_39_626 VDD VDD VSS VSS gf180mcu_fd_sc_mcu7t5v0__fillcap_4
X_6950_ _6950_/D _7667_/CLK _6950_/Q VDD VDD VSS VSS gf180mcu_fd_sc_mcu7t5v0__dffq_1
XFILLER_67_979 VDD VDD VSS VSS gf180mcu_fd_sc_mcu7t5v0__fill_1
X_5901_ _7249_/Q _6235_/A2 _6235_/B1 _7242_/Q _7228_/Q _6236_/A2 _5902_/A2 VDD VDD
+ VSS VSS gf180mcu_fd_sc_mcu7t5v0__oai222_1
X_6881_ _6881_/D _7683_/CLK _6881_/Q VDD VDD VSS VSS gf180mcu_fd_sc_mcu7t5v0__dffq_1
X_5832_ _6877_/Q _6198_/A2 wire322/I _6856_/Q _6221_/B _5833_/A2 VDD VDD VSS VSS gf180mcu_fd_sc_mcu7t5v0__oai221_1
XTAP_TAPCELL_ROW_45_882 VDD VSS gf180mcu_fd_sc_mcu7t5v0__filltie
XFILLER_62_662 VDD VDD VSS VSS gf180mcu_fd_sc_mcu7t5v0__fill_2
XTAP_TAPCELL_ROW_66_1176 VDD VSS gf180mcu_fd_sc_mcu7t5v0__filltie
XTAP_TAPCELL_ROW_66_1187 VDD VSS gf180mcu_fd_sc_mcu7t5v0__filltie
X_5763_ _7023_/Q _6154_/A2 wire313/I _7016_/Q _6208_/C _5764_/A2 VDD VDD VSS VSS gf180mcu_fd_sc_mcu7t5v0__oai221_1
XTAP_TAPCELL_ROW_45_893 VDD VSS gf180mcu_fd_sc_mcu7t5v0__filltie
XFILLER_50_868 VDD VDD VSS VSS gf180mcu_fd_sc_mcu7t5v0__fillcap_4
XFILLER_61_194 VDD VDD VSS VSS gf180mcu_fd_sc_mcu7t5v0__fill_2
X_4714_ _5078_/A1 _4714_/A2 _4714_/B _7071_/D VDD VDD VSS VSS gf180mcu_fd_sc_mcu7t5v0__oai21_1
X_7502_ _7502_/D _7505_/CLK _7502_/Q VDD VDD VSS VSS gf180mcu_fd_sc_mcu7t5v0__dffq_1
X_5694_ input34/Z _6373_/S _5694_/B _7563_/Q _5695_/B VDD VDD VSS VSS gf180mcu_fd_sc_mcu7t5v0__aoi211_1
X_4645_ _7037_/Q _4658_/A2 _4646_/B VDD VDD VSS VSS gf180mcu_fd_sc_mcu7t5v0__nand2_1
X_7433_ _7433_/D _7754_/CLK _7433_/Q VDD VDD VSS VSS gf180mcu_fd_sc_mcu7t5v0__dffq_1
X_4576_ _5122_/A1 _4588_/A2 _4576_/B _7002_/D VDD VDD VSS VSS gf180mcu_fd_sc_mcu7t5v0__oai21_1
X_7364_ _7364_/D _7483_/CLK _7364_/Q VDD VDD VSS VSS gf180mcu_fd_sc_mcu7t5v0__dffq_1
XFILLER_116_664 VDD VDD VSS VSS gf180mcu_fd_sc_mcu7t5v0__fill_1
XFILLER_104_804 VDD VDD VSS VSS gf180mcu_fd_sc_mcu7t5v0__fill_1
X_3527_ _7879_/I _7880_/I _5810_/A1 VDD VDD VSS VSS gf180mcu_fd_sc_mcu7t5v0__nand2_1
X_6315_ _6315_/A1 _6315_/A2 _3703_/Z wire197/I VDD VDD VSS VSS gf180mcu_fd_sc_mcu7t5v0__nor3_2
X_7295_ _7295_/D _7505_/CLK _7295_/Q VDD VDD VSS VSS gf180mcu_fd_sc_mcu7t5v0__dffq_1
X_3458_ _7594_/Q _6284_/A1 VDD VDD VSS VSS gf180mcu_fd_sc_mcu7t5v0__clkinv_1
X_6246_ _6184_/C _6246_/A2 _6246_/B _6246_/C _6250_/A1 VDD VDD VSS VSS gf180mcu_fd_sc_mcu7t5v0__oai211_1
X_3389_ _7733_/Q _4165_/A2 VDD VDD VSS VSS gf180mcu_fd_sc_mcu7t5v0__clkinv_1
X_6177_ _7190_/Q _6242_/A2 _6177_/B1 _7183_/Q _7169_/Q _6177_/C2 _6178_/I VDD VDD
+ VSS VSS gf180mcu_fd_sc_mcu7t5v0__oai222_1
X_5128_ _5128_/A1 _5134_/A2 _5128_/B _7278_/D VDD VDD VSS VSS gf180mcu_fd_sc_mcu7t5v0__oai21_1
XFILLER_69_294 VDD VDD VSS VSS gf180mcu_fd_sc_mcu7t5v0__fill_1
XFILLER_58_979 VDD VDD VSS VSS gf180mcu_fd_sc_mcu7t5v0__fill_2
XFILLER_45_629 VDD VDD VSS VSS gf180mcu_fd_sc_mcu7t5v0__fill_1
X_5059_ _7244_/Q _5064_/A2 _5060_/B VDD VDD VSS VSS gf180mcu_fd_sc_mcu7t5v0__nand2_1
XFILLER_53_640 VDD VDD VSS VSS gf180mcu_fd_sc_mcu7t5v0__fill_2
XPHY_EDGE_ROW_109_Right_109 VDD VSS gf180mcu_fd_sc_mcu7t5v0__endcap
XTAP_TAPCELL_ROW_97_1615 VDD VSS gf180mcu_fd_sc_mcu7t5v0__filltie
XTAP_TAPCELL_ROW_23_576 VDD VSS gf180mcu_fd_sc_mcu7t5v0__filltie
XTAP_TAPCELL_ROW_23_587 VDD VSS gf180mcu_fd_sc_mcu7t5v0__filltie
XFILLER_110_807 VDD VDD VSS VSS gf180mcu_fd_sc_mcu7t5v0__fillcap_64
XFILLER_75_264 VDD VDD VSS VSS gf180mcu_fd_sc_mcu7t5v0__fill_2
XFILLER_35_106 VDD VDD VSS VSS gf180mcu_fd_sc_mcu7t5v0__fill_2
XTAP_TAPCELL_ROW_106_1744 VDD VSS gf180mcu_fd_sc_mcu7t5v0__filltie
XTAP_TAPCELL_ROW_42_841 VDD VSS gf180mcu_fd_sc_mcu7t5v0__filltie
XTAP_TAPCELL_ROW_42_852 VDD VSS gf180mcu_fd_sc_mcu7t5v0__filltie
XANTENNA_2 _6961_/D VDD VDD VSS VSS gf180mcu_fd_sc_mcu7t5v0__antenna
X_4430_ wire240/Z _4434_/A2 _4430_/B _6929_/D VDD VDD VSS VSS gf180mcu_fd_sc_mcu7t5v0__oai21_1
XTAP_TAPCELL_ROW_117_1895 VDD VSS gf180mcu_fd_sc_mcu7t5v0__filltie
X_4361_ _6895_/Q _4364_/A2 _4362_/B VDD VDD VSS VSS gf180mcu_fd_sc_mcu7t5v0__nand2_1
XFILLER_98_312 VDD VDD VSS VSS gf180mcu_fd_sc_mcu7t5v0__fill_2
X_6100_ _7245_/Q wire353/I _6236_/C _6102_/A1 VDD VDD VSS VSS gf180mcu_fd_sc_mcu7t5v0__oai21_1
XFILLER_99_879 VDD VDD VSS VSS gf180mcu_fd_sc_mcu7t5v0__fill_2
X_4292_ _5132_/A1 _4294_/A2 _4292_/B _6860_/D VDD VDD VSS VSS gf180mcu_fd_sc_mcu7t5v0__oai21_1
X_7080_ _7080_/D _7101_/CLK _7080_/Q VDD VDD VSS VSS gf180mcu_fd_sc_mcu7t5v0__dffq_1
Xfanout509 wire513/I _5239_/I0 VDD VDD VSS VSS gf180mcu_fd_sc_mcu7t5v0__dlyd_1
XFILLER_79_570 VDD VDD VSS VSS gf180mcu_fd_sc_mcu7t5v0__fill_2
X_6031_ _7125_/Q _6214_/A2 wire353/Z _7118_/Q _7104_/Q _6215_/A2 _6032_/A2 VDD VDD
+ VSS VSS gf180mcu_fd_sc_mcu7t5v0__oai222_1
XFILLER_67_743 VDD VDD VSS VSS gf180mcu_fd_sc_mcu7t5v0__fill_1
XTAP_TAPCELL_ROW_68_1205 VDD VSS gf180mcu_fd_sc_mcu7t5v0__filltie
XTAP_TAPCELL_ROW_68_1216 VDD VSS gf180mcu_fd_sc_mcu7t5v0__filltie
X_6933_ _6933_/D _7259_/CLK _6933_/Q VDD VDD VSS VSS gf180mcu_fd_sc_mcu7t5v0__dffq_1
X_6864_ _6864_/D _6882_/CLK _6864_/Q VDD VDD VSS VSS gf180mcu_fd_sc_mcu7t5v0__dffq_1
X_5815_ _7544_/Q _6256_/A2 _5677_/I _7561_/Q _6283_/B1 _5815_/C2 _5817_/A2 VDD VDD
+ VSS VSS gf180mcu_fd_sc_mcu7t5v0__aoi222_1
X_6795_ _6795_/D _7253_/CLK _6795_/Q VDD VDD VSS VSS gf180mcu_fd_sc_mcu7t5v0__dffq_1
X_5746_ _7796_/D _5746_/A2 _7802_/D _5746_/A4 _6488_/B VDD VDD VSS VSS gf180mcu_fd_sc_mcu7t5v0__nor4_1
XTAP_TAPCELL_ROW_20_535 VDD VSS gf180mcu_fd_sc_mcu7t5v0__filltie
X_5677_ _5677_/I _5678_/A2 VDD VDD VSS VSS gf180mcu_fd_sc_mcu7t5v0__clkinv_1
X_4628_ _4964_/A1 _4630_/A2 _4628_/B _7028_/D VDD VDD VSS VSS gf180mcu_fd_sc_mcu7t5v0__oai21_1
XTAP_TAPCELL_ROW_79_1367 VDD VSS gf180mcu_fd_sc_mcu7t5v0__filltie
X_7416_ _7416_/D _7500_/CLK _7416_/Q VDD VDD VSS VSS gf180mcu_fd_sc_mcu7t5v0__dffq_1
XTAP_TAPCELL_ROW_92_1545 VDD VSS gf180mcu_fd_sc_mcu7t5v0__filltie
X_4559_ _6994_/Q _4560_/A2 _4560_/B VDD VDD VSS VSS gf180mcu_fd_sc_mcu7t5v0__nand2_1
X_7347_ _7347_/D _7472_/CLK _7347_/Q VDD VDD VSS VSS gf180mcu_fd_sc_mcu7t5v0__dffq_1
X_7278_ _7278_/D _7692_/CLK _7278_/Q VDD VDD VSS VSS gf180mcu_fd_sc_mcu7t5v0__dffq_1
X_6229_ _6748_/Q _6229_/A2 _6229_/B1 _6745_/Q _6229_/C _6230_/A2 VDD VDD VSS VSS gf180mcu_fd_sc_mcu7t5v0__oai221_1
XFILLER_98_890 VDD VDD VSS VSS gf180mcu_fd_sc_mcu7t5v0__fill_1
XFILLER_58_732 VDD VDD VSS VSS gf180mcu_fd_sc_mcu7t5v0__fill_2
XFILLER_58_721 VDD VDD VSS VSS gf180mcu_fd_sc_mcu7t5v0__fill_1
XFILLER_100_873 VDD VDD VSS VSS gf180mcu_fd_sc_mcu7t5v0__fill_2
XFILLER_100_862 VDD VDD VSS VSS gf180mcu_fd_sc_mcu7t5v0__fill_2
XFILLER_73_702 VDD VDD VSS VSS gf180mcu_fd_sc_mcu7t5v0__fillcap_4
XTAP_TAPCELL_ROW_28_646 VDD VSS gf180mcu_fd_sc_mcu7t5v0__filltie
XTAP_TAPCELL_ROW_28_657 VDD VSS gf180mcu_fd_sc_mcu7t5v0__filltie
XTAP_TAPCELL_ROW_0_260 VDD VSS gf180mcu_fd_sc_mcu7t5v0__filltie
XFILLER_41_632 VDD VDD VSS VSS gf180mcu_fd_sc_mcu7t5v0__fillcap_64
XFILLER_13_367 VDD VDD VSS VSS gf180mcu_fd_sc_mcu7t5v0__fill_2
XFILLER_40_131 VDD VDD VSS VSS gf180mcu_fd_sc_mcu7t5v0__fill_1
XTAP_TAPCELL_ROW_101_1674 VDD VSS gf180mcu_fd_sc_mcu7t5v0__filltie
XTAP_TAPCELL_ROW_8_371 VDD VSS gf180mcu_fd_sc_mcu7t5v0__filltie
XFILLER_1_772 VDD VDD VSS VSS gf180mcu_fd_sc_mcu7t5v0__fillcap_64
XFILLER_0_271 VDD VDD VSS VSS gf180mcu_fd_sc_mcu7t5v0__fill_1
XFILLER_76_562 VDD VDD VSS VSS gf180mcu_fd_sc_mcu7t5v0__fill_1
XTAP_TAPCELL_ROW_47_911 VDD VSS gf180mcu_fd_sc_mcu7t5v0__filltie
XTAP_TAPCELL_ROW_47_922 VDD VSS gf180mcu_fd_sc_mcu7t5v0__filltie
X_3930_ _3930_/A1 _3930_/A2 _3929_/Z _3930_/Z VDD VDD VSS VSS gf180mcu_fd_sc_mcu7t5v0__xor3_1
XFILLER_60_941 VDD VDD VSS VSS gf180mcu_fd_sc_mcu7t5v0__fillcap_4
XTAP_TAPCELL_ROW_63_1135 VDD VSS gf180mcu_fd_sc_mcu7t5v0__filltie
X_3861_ _4946_/A1 _5694_/B _3877_/A1 VDD VDD VSS VSS gf180mcu_fd_sc_mcu7t5v0__nand2_1
XTAP_TAPCELL_ROW_63_1146 VDD VSS gf180mcu_fd_sc_mcu7t5v0__filltie
X_3792_ _5634_/A2 _3792_/A2 _7768_/D VDD VDD VSS VSS gf180mcu_fd_sc_mcu7t5v0__nor2_1
X_5600_ _6822_/Q _5600_/A2 _5600_/B1 _6823_/Q _6825_/Q _5600_/C2 _5601_/A2 VDD VDD
+ VSS VSS gf180mcu_fd_sc_mcu7t5v0__oai222_1
X_6580_ _6622_/B _6605_/A1 _6601_/A1 VDD VDD VSS VSS gf180mcu_fd_sc_mcu7t5v0__nand2_1
X_5531_ _7476_/Q _5603_/A2 _5531_/B _5533_/A1 VDD VDD VSS VSS gf180mcu_fd_sc_mcu7t5v0__oai21_1
X_5462_ _5366_/Z _5461_/Z _5463_/B VDD VDD VSS VSS gf180mcu_fd_sc_mcu7t5v0__nand2_1
X_7201_ _7201_/D _7251_/CLK _7201_/Q VDD VDD VSS VSS gf180mcu_fd_sc_mcu7t5v0__dffq_1
X_4413_ _6921_/Q _4420_/A2 _4414_/B VDD VDD VSS VSS gf180mcu_fd_sc_mcu7t5v0__nand2_1
X_5393_ _7450_/Q _5597_/A2 _5542_/A2 _7443_/Q _7422_/Q _5600_/A2 _5394_/A2 VDD VDD
+ VSS VSS gf180mcu_fd_sc_mcu7t5v0__oai222_1
X_4344_ _5086_/A1 _4350_/A2 _4344_/B _6886_/D VDD VDD VSS VSS gf180mcu_fd_sc_mcu7t5v0__oai21_1
XFILLER_99_632 VDD VDD VSS VSS gf180mcu_fd_sc_mcu7t5v0__fill_1
X_7132_ _7132_/D _7233_/CLK _7132_/Q VDD VDD VSS VSS gf180mcu_fd_sc_mcu7t5v0__dffq_1
X_7063_ _7063_/D _7064_/CLK _7063_/Q VDD VDD VSS VSS gf180mcu_fd_sc_mcu7t5v0__dffq_1
XFILLER_87_838 VDD VDD VSS VSS gf180mcu_fd_sc_mcu7t5v0__fill_2
Xfanout339 _6228_/A2 wire341/I VDD VDD VSS VSS gf180mcu_fd_sc_mcu7t5v0__dlyd_1
XTAP_TAPCELL_ROW_74_1297 VDD VSS gf180mcu_fd_sc_mcu7t5v0__filltie
Xfanout328 _6175_/A2 fanout328/Z VDD VDD VSS VSS gf180mcu_fd_sc_mcu7t5v0__dlyd_1
Xfanout317 _6590_/A2 _6177_/C2 VDD VDD VSS VSS gf180mcu_fd_sc_mcu7t5v0__dlyd_1
X_4275_ _6852_/Q _4280_/A2 _4276_/B VDD VDD VSS VSS gf180mcu_fd_sc_mcu7t5v0__nand2_1
X_6014_ _6852_/Q _6073_/A2 _6197_/B _6016_/A1 VDD VDD VSS VSS gf180mcu_fd_sc_mcu7t5v0__oai21_1
XFILLER_67_562 VDD VDD VSS VSS gf180mcu_fd_sc_mcu7t5v0__fill_2
XFILLER_27_437 VDD VDD VSS VSS gf180mcu_fd_sc_mcu7t5v0__fill_2
XFILLER_55_768 VDD VDD VSS VSS gf180mcu_fd_sc_mcu7t5v0__fill_2
XFILLER_82_576 VDD VDD VSS VSS gf180mcu_fd_sc_mcu7t5v0__fill_2
XTAP_TAPCELL_ROW_25_605 VDD VSS gf180mcu_fd_sc_mcu7t5v0__filltie
X_6916_ _6916_/D _7266_/CLK _6916_/Q VDD VDD VSS VSS gf180mcu_fd_sc_mcu7t5v0__dffq_1
XFILLER_23_632 VDD VDD VSS VSS gf180mcu_fd_sc_mcu7t5v0__fillcap_64
X_6847_ _6847_/D _7724_/CLK _6847_/Q VDD VDD VSS VSS gf180mcu_fd_sc_mcu7t5v0__dffq_1
X_6778_ _6778_/D _7252_/CLK _6778_/Q VDD VDD VSS VSS gf180mcu_fd_sc_mcu7t5v0__dffq_1
X_5729_ _6333_/A1 _7682_/Q _7634_/Q _5730_/A2 _5730_/C VDD VDD VSS VSS gf180mcu_fd_sc_mcu7t5v0__aoi22_1
XFILLER_108_247 VDD VDD VSS VSS gf180mcu_fd_sc_mcu7t5v0__fill_1
XTAP_TAPCELL_ROW_5_330 VDD VSS gf180mcu_fd_sc_mcu7t5v0__filltie
XFILLER_86_882 VDD VDD VSS VSS gf180mcu_fd_sc_mcu7t5v0__fillcap_4
XFILLER_45_212 VDD VDD VSS VSS gf180mcu_fd_sc_mcu7t5v0__fill_2
XTAP_TAPCELL_ROW_103_1703 VDD VSS gf180mcu_fd_sc_mcu7t5v0__filltie
XFILLER_73_576 VDD VDD VSS VSS gf180mcu_fd_sc_mcu7t5v0__fill_2
XFILLER_42_941 VDD VDD VSS VSS gf180mcu_fd_sc_mcu7t5v0__fillcap_4
XFILLER_60_215 VDD VDD VSS VSS gf180mcu_fd_sc_mcu7t5v0__fill_1
XTAP_TAPCELL_ROW_52_980 VDD VSS gf180mcu_fd_sc_mcu7t5v0__filltie
XTAP_TAPCELL_ROW_52_991 VDD VSS gf180mcu_fd_sc_mcu7t5v0__filltie
XFILLER_10_871 VDD VDD VSS VSS gf180mcu_fd_sc_mcu7t5v0__fillcap_4
XFILLER_115_707 VDD VDD VSS VSS gf180mcu_fd_sc_mcu7t5v0__fill_1
XTAP_TAPCELL_ROW_114_1854 VDD VSS gf180mcu_fd_sc_mcu7t5v0__filltie
XFILLER_96_657 VDD VDD VSS VSS gf180mcu_fd_sc_mcu7t5v0__fill_1
X_4060_ _4114_/A1 _4081_/A2 _4728_/A2 VDD VDD VSS VSS gf180mcu_fd_sc_mcu7t5v0__nand2_1
XFILLER_37_702 VDD VDD VSS VSS gf180mcu_fd_sc_mcu7t5v0__fillcap_64
XFILLER_64_543 VDD VDD VSS VSS gf180mcu_fd_sc_mcu7t5v0__fill_1
X_4962_ _5060_/A1 _4966_/A2 _4962_/B _7195_/D VDD VDD VSS VSS gf180mcu_fd_sc_mcu7t5v0__oai21_1
X_7750_ _7750_/D wire565/Z _7755_/CLK _7750_/Q VDD VDD VSS VSS gf180mcu_fd_sc_mcu7t5v0__dffrnq_1
X_3913_ _7572_/Q _7579_/Q _3912_/Z _3913_/Z VDD VDD VSS VSS gf180mcu_fd_sc_mcu7t5v0__xor3_1
X_7681_ _7681_/D _7694_/RN _7802_/CLK _7681_/Q VDD VDD VSS VSS gf180mcu_fd_sc_mcu7t5v0__dffrnq_1
X_6701_ _6701_/I _7748_/D VDD VDD VSS VSS gf180mcu_fd_sc_mcu7t5v0__clkinv_1
X_4893_ _7161_/Q _4896_/A2 _4894_/B VDD VDD VSS VSS gf180mcu_fd_sc_mcu7t5v0__nand2_1
X_3844_ _7603_/Q _7600_/Q _7599_/Q _3844_/Z VDD VDD VSS VSS gf180mcu_fd_sc_mcu7t5v0__xor3_1
XFILLER_32_462 VDD VDD VSS VSS gf180mcu_fd_sc_mcu7t5v0__fill_1
X_6632_ _6632_/A1 wire420/Z _6633_/A2 VDD VDD VSS VSS gf180mcu_fd_sc_mcu7t5v0__nand2_1
X_3775_ _7519_/Q _3775_/A2 _7519_/D VDD VDD VSS VSS gf180mcu_fd_sc_mcu7t5v0__or2_1
XTAP_TAPCELL_ROW_30_674 VDD VSS gf180mcu_fd_sc_mcu7t5v0__filltie
X_6563_ _7698_/Q _7697_/Q _6566_/S _7698_/D VDD VDD VSS VSS gf180mcu_fd_sc_mcu7t5v0__mux2_2
X_5514_ _7328_/Q _5535_/C2 _5562_/A2 _7321_/Q _5514_/C _5521_/A2 VDD VDD VSS VSS gf180mcu_fd_sc_mcu7t5v0__oai221_1
XTAP_TAPCELL_ROW_30_685 VDD VSS gf180mcu_fd_sc_mcu7t5v0__filltie
X_6494_ _6538_/A1 _6492_/Z _6494_/A3 _7673_/D VDD VDD VSS VSS gf180mcu_fd_sc_mcu7t5v0__nor3_1
XTAP_TAPCELL_ROW_76_1326 VDD VSS gf180mcu_fd_sc_mcu7t5v0__filltie
X_5445_ _7354_/Q _6632_/A1 _5594_/B1 _7340_/Q _5446_/A3 VDD VDD VSS VSS gf180mcu_fd_sc_mcu7t5v0__oai22_1
X_5376_ _7289_/Q _5610_/B1 _5515_/A2 _7492_/Q _5378_/A2 VDD VDD VSS VSS gf180mcu_fd_sc_mcu7t5v0__oai22_1
X_7115_ _7115_/D _7196_/CLK _7115_/Q VDD VDD VSS VSS gf180mcu_fd_sc_mcu7t5v0__dffq_1
XFILLER_102_935 VDD VDD VSS VSS gf180mcu_fd_sc_mcu7t5v0__fillcap_8
XFILLER_101_401 VDD VDD VSS VSS gf180mcu_fd_sc_mcu7t5v0__fill_1
X_4327_ _6878_/Q _4336_/A2 _4328_/B VDD VDD VSS VSS gf180mcu_fd_sc_mcu7t5v0__nand2_1
XFILLER_102_979 VDD VDD VSS VSS gf180mcu_fd_sc_mcu7t5v0__fill_2
X_7046_ _7046_/D _7060_/CLK _7046_/Q VDD VDD VSS VSS gf180mcu_fd_sc_mcu7t5v0__dffq_1
X_4258_ _5112_/A1 _4266_/A2 _4258_/B _6843_/D VDD VDD VSS VSS gf180mcu_fd_sc_mcu7t5v0__oai21_1
XFILLER_68_860 VDD VDD VSS VSS gf180mcu_fd_sc_mcu7t5v0__fill_1
X_4189_ _6653_/A2 _4189_/A2 _5211_/S VDD VDD VSS VSS gf180mcu_fd_sc_mcu7t5v0__nand2_1
XTAP_TAPCELL_ROW_87_1477 VDD VSS gf180mcu_fd_sc_mcu7t5v0__filltie
XTAP_TAPCELL_ROW_38_785 VDD VSS gf180mcu_fd_sc_mcu7t5v0__filltie
XTAP_TAPCELL_ROW_38_796 VDD VSS gf180mcu_fd_sc_mcu7t5v0__filltie
XFILLER_24_941 VDD VDD VSS VSS gf180mcu_fd_sc_mcu7t5v0__fillcap_4
X_7879_ _7879_/I _7879_/Z VDD VDD VSS VSS gf180mcu_fd_sc_mcu7t5v0__buf_1
XFILLER_19_702 VDD VDD VSS VSS gf180mcu_fd_sc_mcu7t5v0__fillcap_64
XFILLER_74_874 VDD VDD VSS VSS gf180mcu_fd_sc_mcu7t5v0__fill_1
XPHY_EDGE_ROW_16_Right_16 VDD VSS gf180mcu_fd_sc_mcu7t5v0__endcap
XFILLER_46_554 VDD VDD VSS VSS gf180mcu_fd_sc_mcu7t5v0__fill_1
XTAP_TAPCELL_ROW_16_479 VDD VSS gf180mcu_fd_sc_mcu7t5v0__filltie
XTAP_TAPCELL_ROW_60_1105 VDD VSS gf180mcu_fd_sc_mcu7t5v0__filltie
X_3560_ input80/Z input88/Z input90/Z _3560_/Z VDD VDD VSS VSS gf180mcu_fd_sc_mcu7t5v0__xor3_1
XPHY_EDGE_ROW_25_Right_25 VDD VSS gf180mcu_fd_sc_mcu7t5v0__endcap
XFILLER_6_661 VDD VDD VSS VSS gf180mcu_fd_sc_mcu7t5v0__fillcap_4
X_3491_ _3491_/I _3493_/A1 VDD VDD VSS VSS gf180mcu_fd_sc_mcu7t5v0__clkinv_1
X_5230_ _5244_/I0 _7377_/Q _5232_/S _7377_/D VDD VDD VSS VSS gf180mcu_fd_sc_mcu7t5v0__mux2_2
XTAP_TAPCELL_ROW_58_1067 VDD VSS gf180mcu_fd_sc_mcu7t5v0__filltie
XFILLER_97_900 VDD VDD VSS VSS gf180mcu_fd_sc_mcu7t5v0__fillcap_8
X_5161_ wire517/Z _7308_/Q _5162_/S _7308_/D VDD VDD VSS VSS gf180mcu_fd_sc_mcu7t5v0__mux2_2
XFILLER_38_2 VDD VDD VSS VSS gf180mcu_fd_sc_mcu7t5v0__fill_1
XFILLER_110_220 VDD VDD VSS VSS gf180mcu_fd_sc_mcu7t5v0__fill_1
X_5092_ _5134_/A1 _5092_/A2 _5092_/B _7260_/D VDD VDD VSS VSS gf180mcu_fd_sc_mcu7t5v0__oai21_1
X_4112_ _4112_/A1 _4952_/A2 _4112_/B _6788_/D VDD VDD VSS VSS gf180mcu_fd_sc_mcu7t5v0__oai21_1
XTAP_TAPCELL_ROW_71_1256 VDD VSS gf180mcu_fd_sc_mcu7t5v0__filltie
X_4043_ _4071_/A1 _4644_/A2 _4043_/B _6766_/D VDD VDD VSS VSS gf180mcu_fd_sc_mcu7t5v0__oai21_1
XPHY_EDGE_ROW_34_Right_34 VDD VSS gf180mcu_fd_sc_mcu7t5v0__endcap
XFILLER_49_381 VDD VDD VSS VSS gf180mcu_fd_sc_mcu7t5v0__fill_2
X_5994_ _5994_/A1 _5994_/A2 _5994_/B1 _5994_/B2 _5996_/A2 VDD VDD VSS VSS gf180mcu_fd_sc_mcu7t5v0__oai22_1
X_7802_ _7802_/D _7802_/RN _7802_/CLK _7802_/Q VDD VDD VSS VSS gf180mcu_fd_sc_mcu7t5v0__dffrnq_1
XFILLER_52_535 VDD VDD VSS VSS gf180mcu_fd_sc_mcu7t5v0__fill_1
XTAP_TAPCELL_ROW_35_744 VDD VSS gf180mcu_fd_sc_mcu7t5v0__filltie
XTAP_TAPCELL_ROW_35_755 VDD VSS gf180mcu_fd_sc_mcu7t5v0__filltie
X_7733_ _7733_/D _7733_/RN _7734_/CLK _7733_/Q VDD VDD VSS VSS gf180mcu_fd_sc_mcu7t5v0__dffrnq_1
XFILLER_52_546 VDD VDD VSS VSS gf180mcu_fd_sc_mcu7t5v0__fillcap_4
X_4945_ _7187_/Q _4952_/A2 _4946_/B VDD VDD VSS VSS gf180mcu_fd_sc_mcu7t5v0__nand2_1
XFILLER_52_579 VDD VDD VSS VSS gf180mcu_fd_sc_mcu7t5v0__fill_2
X_7664_ _7664_/D _7664_/RN _7670_/CLK _7664_/Q VDD VDD VSS VSS gf180mcu_fd_sc_mcu7t5v0__dffrnq_1
X_4876_ _4918_/A1 _4882_/A2 _4876_/B _7152_/D VDD VDD VSS VSS gf180mcu_fd_sc_mcu7t5v0__oai21_1
X_3827_ _7601_/Q _3823_/Z _3827_/Z VDD VDD VSS VSS gf180mcu_fd_sc_mcu7t5v0__xor2_1
X_7595_ _7595_/D _7595_/RN _7710_/CLK _7595_/Q VDD VDD VSS VSS gf180mcu_fd_sc_mcu7t5v0__dffrnq_1
XFILLER_20_454 VDD VDD VSS VSS gf180mcu_fd_sc_mcu7t5v0__fill_1
XPHY_EDGE_ROW_43_Right_43 VDD VSS gf180mcu_fd_sc_mcu7t5v0__endcap
X_6615_ _7721_/Q _6616_/A2 _6622_/B _6616_/B VDD VDD VSS VSS gf180mcu_fd_sc_mcu7t5v0__oai21_1
X_6546_ _7691_/Q _6543_/Z _6546_/Z VDD VDD VSS VSS gf180mcu_fd_sc_mcu7t5v0__and2_1
X_3758_ _7802_/D _3754_/B _3758_/B1 _3758_/B2 _3759_/B VDD VDD VSS VSS gf180mcu_fd_sc_mcu7t5v0__aoi22_1
X_6477_ _6479_/S _6476_/Z _6477_/B _7670_/D VDD VDD VSS VSS gf180mcu_fd_sc_mcu7t5v0__aoi21_1
X_3689_ _3682_/C input68/Z input67/Z _3385_/I _3689_/B2 _3690_/B VDD VDD VSS VSS gf180mcu_fd_sc_mcu7t5v0__oai32_1
X_5428_ _7395_/Q _5578_/A2 _5501_/B1 _7402_/Q _7409_/Q _5542_/A2 _5429_/A3 VDD VDD
+ VSS VSS gf180mcu_fd_sc_mcu7t5v0__oai222_1
XFILLER_88_944 VDD VDD VSS VSS gf180mcu_fd_sc_mcu7t5v0__fill_1
X_5359_ _7785_/Q _3708_/Z _5359_/Z VDD VDD VSS VSS gf180mcu_fd_sc_mcu7t5v0__and2_1
XFILLER_58_26 VDD VDD VSS VSS gf180mcu_fd_sc_mcu7t5v0__fill_1
XFILLER_58_37 VDD VDD VSS VSS gf180mcu_fd_sc_mcu7t5v0__fill_2
X_7029_ _7029_/D _7060_/CLK _7029_/Q VDD VDD VSS VSS gf180mcu_fd_sc_mcu7t5v0__dffq_1
XTAP_TAPCELL_ROW_89_1506 VDD VSS gf180mcu_fd_sc_mcu7t5v0__filltie
XFILLER_87_465 VDD VDD VSS VSS gf180mcu_fd_sc_mcu7t5v0__fill_2
XFILLER_75_616 VDD VDD VSS VSS gf180mcu_fd_sc_mcu7t5v0__fillcap_4
XPHY_EDGE_ROW_52_Right_52 VDD VSS gf180mcu_fd_sc_mcu7t5v0__endcap
XTAP_TAPCELL_ROW_13_438 VDD VSS gf180mcu_fd_sc_mcu7t5v0__filltie
XPHY_EDGE_ROW_61_Right_61 VDD VSS gf180mcu_fd_sc_mcu7t5v0__endcap
XTAP_TAPCELL_ROW_111_1813 VDD VSS gf180mcu_fd_sc_mcu7t5v0__filltie
XFILLER_79_900 VDD VDD VSS VSS gf180mcu_fd_sc_mcu7t5v0__fill_2
Xload_slew306 _6171_/A2 _6236_/B1 VDD VDD VSS VSS gf180mcu_fd_sc_mcu7t5v0__buf_2
XPHY_EDGE_ROW_70_Right_70 VDD VSS gf180mcu_fd_sc_mcu7t5v0__endcap
XFILLER_79_966 VDD VDD VSS VSS gf180mcu_fd_sc_mcu7t5v0__fillcap_8
XFILLER_94_925 VDD VDD VSS VSS gf180mcu_fd_sc_mcu7t5v0__fillcap_16
XFILLER_78_465 VDD VDD VSS VSS gf180mcu_fd_sc_mcu7t5v0__fill_1
XFILLER_94_947 VDD VDD VSS VSS gf180mcu_fd_sc_mcu7t5v0__fillcap_32
XFILLER_19_521 VDD VDD VSS VSS gf180mcu_fd_sc_mcu7t5v0__fill_1
XFILLER_47_830 VDD VDD VSS VSS gf180mcu_fd_sc_mcu7t5v0__fill_2
XTAP_TAPCELL_ROW_109_1786 VDD VSS gf180mcu_fd_sc_mcu7t5v0__filltie
XFILLER_46_384 VDD VDD VSS VSS gf180mcu_fd_sc_mcu7t5v0__fill_1
XFILLER_62_844 VDD VDD VSS VSS gf180mcu_fd_sc_mcu7t5v0__fill_1
XTAP_TAPCELL_ROW_32_703 VDD VSS gf180mcu_fd_sc_mcu7t5v0__filltie
X_4730_ _4786_/A1 _4742_/A2 _4730_/B _7079_/D VDD VDD VSS VSS gf180mcu_fd_sc_mcu7t5v0__oai21_1
X_4661_ _7045_/Q _4672_/A2 _4662_/B VDD VDD VSS VSS gf180mcu_fd_sc_mcu7t5v0__nand2_1
X_6400_ _6400_/A1 _6400_/A2 _6400_/B _6411_/B2 VDD VDD VSS VSS gf180mcu_fd_sc_mcu7t5v0__oai21_1
X_3612_ _3607_/Z _3609_/Z _3612_/A3 _3612_/Z VDD VDD VSS VSS gf180mcu_fd_sc_mcu7t5v0__xor3_1
X_7380_ _7380_/D _7735_/CLK _7380_/Q VDD VDD VSS VSS gf180mcu_fd_sc_mcu7t5v0__dffq_1
XFILLER_116_802 VDD VDD VSS VSS gf180mcu_fd_sc_mcu7t5v0__fill_2
X_4592_ wire268/Z _4602_/A2 _4592_/B _7010_/D VDD VDD VSS VSS gf180mcu_fd_sc_mcu7t5v0__oai21_1
X_6331_ _7624_/Q input39/Z _6331_/S _7624_/D VDD VDD VSS VSS gf180mcu_fd_sc_mcu7t5v0__mux2_2
X_3543_ input24/Z _3563_/A2 _3636_/A1 _3543_/Z VDD VDD VSS VSS gf180mcu_fd_sc_mcu7t5v0__xor3_1
X_6262_ _7627_/Q _6262_/A2 _6268_/B1 _7708_/Q _6263_/B2 VDD VDD VSS VSS gf180mcu_fd_sc_mcu7t5v0__aoi22_1
X_3474_ _7766_/D _3790_/B VDD VDD VSS VSS gf180mcu_fd_sc_mcu7t5v0__clkinv_1
X_6193_ _6193_/A1 _6193_/A2 _6203_/A1 VDD VDD VSS VSS gf180mcu_fd_sc_mcu7t5v0__nor2_1
X_5213_ _6354_/I0 _7360_/Q _5218_/S _7360_/D VDD VDD VSS VSS gf180mcu_fd_sc_mcu7t5v0__mux2_2
X_5144_ _5347_/I0 _7291_/Q _5148_/S _7291_/D VDD VDD VSS VSS gf180mcu_fd_sc_mcu7t5v0__mux2_2
X_5075_ _7252_/Q _5075_/A2 _5076_/B VDD VDD VSS VSS gf180mcu_fd_sc_mcu7t5v0__nor2_1
X_4026_ _4029_/A1 _4574_/A2 _4026_/B _6761_/D VDD VDD VSS VSS gf180mcu_fd_sc_mcu7t5v0__oai21_1
XFILLER_53_800 VDD VDD VSS VSS gf180mcu_fd_sc_mcu7t5v0__fill_1
XTAP_TAPCELL_ROW_84_1436 VDD VSS gf180mcu_fd_sc_mcu7t5v0__filltie
X_5977_ _7061_/Q _6207_/A2 _6085_/B1 _7047_/Q _5982_/A1 VDD VDD VSS VSS gf180mcu_fd_sc_mcu7t5v0__oai22_1
XFILLER_40_527 VDD VDD VSS VSS gf180mcu_fd_sc_mcu7t5v0__fillcap_64
XFILLER_53_888 VDD VDD VSS VSS gf180mcu_fd_sc_mcu7t5v0__fillcap_16
XFILLER_100_34 VDD VDD VSS VSS gf180mcu_fd_sc_mcu7t5v0__fill_1
X_4928_ _4942_/A1 _4938_/A2 _4928_/B _7178_/D VDD VDD VSS VSS gf180mcu_fd_sc_mcu7t5v0__oai21_1
X_7716_ _7716_/D wire593/Z _7755_/CLK _7716_/Q VDD VDD VSS VSS gf180mcu_fd_sc_mcu7t5v0__dffrnq_1
X_7647_ _7647_/D wire565/Z _7755_/CLK _7647_/Q VDD VDD VSS VSS gf180mcu_fd_sc_mcu7t5v0__dffrnq_1
X_4859_ _7144_/Q _4868_/A2 _4860_/B VDD VDD VSS VSS gf180mcu_fd_sc_mcu7t5v0__nand2_1
X_7578_ _7578_/D _7614_/RN _7710_/CLK _7578_/Q VDD VDD VSS VSS gf180mcu_fd_sc_mcu7t5v0__dffrnq_1
X_6529_ _6538_/A1 _6529_/A2 _7685_/D VDD VDD VSS VSS gf180mcu_fd_sc_mcu7t5v0__nor2_1
XTAP_TAPCELL_ROW_95_1587 VDD VSS gf180mcu_fd_sc_mcu7t5v0__filltie
XFILLER_76_936 VDD VDD VSS VSS gf180mcu_fd_sc_mcu7t5v0__fillcap_8
XFILLER_76_947 VDD VDD VSS VSS gf180mcu_fd_sc_mcu7t5v0__fillcap_32
XFILLER_18_51 VDD VDD VSS VSS gf180mcu_fd_sc_mcu7t5v0__fill_1
XTAP_TAPCELL_ROW_18_508 VDD VSS gf180mcu_fd_sc_mcu7t5v0__filltie
XFILLER_16_524 VDD VDD VSS VSS gf180mcu_fd_sc_mcu7t5v0__fill_1
XFILLER_44_877 VDD VDD VSS VSS gf180mcu_fd_sc_mcu7t5v0__fillcap_64
XFILLER_24_590 VDD VDD VSS VSS gf180mcu_fd_sc_mcu7t5v0__fillcap_4
XFILLER_34_94 VDD VDD VSS VSS gf180mcu_fd_sc_mcu7t5v0__fill_1
Xwire197 wire197/I _6352_/S VDD VDD VSS VSS gf180mcu_fd_sc_mcu7t5v0__buf_2
XFILLER_98_527 VDD VDD VSS VSS gf180mcu_fd_sc_mcu7t5v0__fill_2
XTAP_TAPCELL_ROW_55_1026 VDD VSS gf180mcu_fd_sc_mcu7t5v0__filltie
XPHY_EDGE_ROW_0_Left_119 VDD VSS gf180mcu_fd_sc_mcu7t5v0__endcap
XFILLER_66_457 VDD VDD VSS VSS gf180mcu_fd_sc_mcu7t5v0__fill_2
X_5900_ _7235_/Q _6171_/A2 _6171_/B _5902_/A1 VDD VDD VSS VSS gf180mcu_fd_sc_mcu7t5v0__oai21_1
X_6880_ _6880_/D _6915_/CLK _6880_/Q VDD VDD VSS VSS gf180mcu_fd_sc_mcu7t5v0__dffq_1
X_5831_ _6870_/Q _6141_/A2 _6197_/A2 _6863_/Q _5833_/A1 VDD VDD VSS VSS gf180mcu_fd_sc_mcu7t5v0__oai22_1
XFILLER_34_354 VDD VDD VSS VSS gf180mcu_fd_sc_mcu7t5v0__fill_2
XTAP_TAPCELL_ROW_66_1177 VDD VSS gf180mcu_fd_sc_mcu7t5v0__filltie
X_5762_ _7030_/Q _6151_/C2 _6151_/A2 _7009_/Q _5764_/A1 VDD VDD VSS VSS gf180mcu_fd_sc_mcu7t5v0__oai22_1
XTAP_TAPCELL_ROW_45_883 VDD VSS gf180mcu_fd_sc_mcu7t5v0__filltie
XTAP_TAPCELL_ROW_45_894 VDD VSS gf180mcu_fd_sc_mcu7t5v0__filltie
XTAP_TAPCELL_ROW_66_1188 VDD VSS gf180mcu_fd_sc_mcu7t5v0__filltie
X_4713_ _7071_/Q _4714_/A2 _4714_/B VDD VDD VSS VSS gf180mcu_fd_sc_mcu7t5v0__nand2_1
X_7501_ _7501_/D _7504_/CLK _7501_/Q VDD VDD VSS VSS gf180mcu_fd_sc_mcu7t5v0__dffq_1
X_5693_ input35/Z _5738_/A2 _5693_/B _7562_/D VDD VDD VSS VSS gf180mcu_fd_sc_mcu7t5v0__aoi21_1
X_4644_ wire291/Z _4644_/A2 _4644_/B _7036_/D VDD VDD VSS VSS gf180mcu_fd_sc_mcu7t5v0__oai21_1
X_7432_ _7432_/D _7451_/CLK _7432_/Q VDD VDD VSS VSS gf180mcu_fd_sc_mcu7t5v0__dffq_1
X_4575_ _7002_/Q _4588_/A2 _4576_/B VDD VDD VSS VSS gf180mcu_fd_sc_mcu7t5v0__nand2_1
X_7363_ _7363_/D clkload7/I _7363_/Q VDD VDD VSS VSS gf180mcu_fd_sc_mcu7t5v0__dffq_1
X_6314_ _6314_/A1 _5744_/B _6314_/B _7613_/D VDD VDD VSS VSS gf180mcu_fd_sc_mcu7t5v0__oai21_1
X_3526_ _7881_/I _3696_/A2 _5808_/A1 VDD VDD VSS VSS gf180mcu_fd_sc_mcu7t5v0__nand2_1
X_7294_ _7294_/D _7504_/CLK _7294_/Q VDD VDD VSS VSS gf180mcu_fd_sc_mcu7t5v0__dffq_1
X_6245_ _6184_/C _6245_/A2 _6245_/A3 _6246_/B VDD VDD VSS VSS gf180mcu_fd_sc_mcu7t5v0__nand3_1
X_3457_ _7581_/Q _6257_/A1 VDD VDD VSS VSS gf180mcu_fd_sc_mcu7t5v0__clkinv_1
XFILLER_112_871 VDD VDD VSS VSS gf180mcu_fd_sc_mcu7t5v0__fillcap_4
Xclkbuf_leaf_44_clk_i clkload5/I _6939_/CLK VDD VDD VSS VSS gf180mcu_fd_sc_mcu7t5v0__clkbuf_8
X_3388_ _7732_/Q _4173_/A1 VDD VDD VSS VSS gf180mcu_fd_sc_mcu7t5v0__clkinv_1
X_6176_ _6176_/A1 _6176_/A2 _6176_/B _6183_/A2 VDD VDD VSS VSS gf180mcu_fd_sc_mcu7t5v0__oai21_1
XFILLER_58_914 VDD VDD VSS VSS gf180mcu_fd_sc_mcu7t5v0__fillcap_16
X_5127_ _7278_/Q _5134_/A2 _5128_/B VDD VDD VSS VSS gf180mcu_fd_sc_mcu7t5v0__nand2_1
XFILLER_58_947 VDD VDD VSS VSS gf180mcu_fd_sc_mcu7t5v0__fillcap_32
XFILLER_85_766 VDD VDD VSS VSS gf180mcu_fd_sc_mcu7t5v0__fillcap_4
XPHY_EDGE_ROW_2_Right_2 VDD VSS gf180mcu_fd_sc_mcu7t5v0__endcap
XFILLER_29_148 VDD VDD VSS VSS gf180mcu_fd_sc_mcu7t5v0__fill_1
X_5058_ _5072_/A1 _5064_/A2 _5058_/B _7243_/D VDD VDD VSS VSS gf180mcu_fd_sc_mcu7t5v0__oai21_1
X_4009_ _4120_/A1 _4027_/A2 _4504_/A2 VDD VDD VSS VSS gf180mcu_fd_sc_mcu7t5v0__nand2_1
Xclkbuf_leaf_59_clk_i clkload6/I _7070_/CLK VDD VDD VSS VSS gf180mcu_fd_sc_mcu7t5v0__clkbuf_8
XFILLER_26_877 VDD VDD VSS VSS gf180mcu_fd_sc_mcu7t5v0__fillcap_64
XFILLER_41_836 VDD VDD VSS VSS gf180mcu_fd_sc_mcu7t5v0__fillcap_4
XTAP_TAPCELL_ROW_23_577 VDD VSS gf180mcu_fd_sc_mcu7t5v0__filltie
XTAP_TAPCELL_ROW_97_1616 VDD VSS gf180mcu_fd_sc_mcu7t5v0__filltie
XFILLER_4_225 VDD VDD VSS VSS gf180mcu_fd_sc_mcu7t5v0__fill_1
XFILLER_1_976 VDD VDD VSS VSS gf180mcu_fd_sc_mcu7t5v0__fillcap_4
XFILLER_64_928 VDD VDD VSS VSS gf180mcu_fd_sc_mcu7t5v0__fillcap_16
XFILLER_63_405 VDD VDD VSS VSS gf180mcu_fd_sc_mcu7t5v0__fill_1
XTAP_TAPCELL_ROW_106_1745 VDD VSS gf180mcu_fd_sc_mcu7t5v0__filltie
XFILLER_44_641 VDD VDD VSS VSS gf180mcu_fd_sc_mcu7t5v0__fillcap_8
XTAP_TAPCELL_ROW_42_842 VDD VSS gf180mcu_fd_sc_mcu7t5v0__filltie
XTAP_TAPCELL_ROW_42_853 VDD VSS gf180mcu_fd_sc_mcu7t5v0__filltie
XANTENNA_3 _7007_/D VDD VDD VSS VSS gf180mcu_fd_sc_mcu7t5v0__antenna
XFILLER_8_597 VDD VDD VSS VSS gf180mcu_fd_sc_mcu7t5v0__fillcap_64
X_4360_ _5102_/A1 _4364_/A2 _4360_/B _6894_/D VDD VDD VSS VSS gf180mcu_fd_sc_mcu7t5v0__oai21_1
XTAP_TAPCELL_ROW_117_1896 VDD VSS gf180mcu_fd_sc_mcu7t5v0__filltie
X_4291_ _6860_/Q _4294_/A2 _4292_/B VDD VDD VSS VSS gf180mcu_fd_sc_mcu7t5v0__nand2_1
X_6030_ _7111_/Q _6232_/A2 _6214_/B _6032_/A1 VDD VDD VSS VSS gf180mcu_fd_sc_mcu7t5v0__oai21_1
XFILLER_79_593 VDD VDD VSS VSS gf180mcu_fd_sc_mcu7t5v0__fill_1
XFILLER_20_2 VDD VDD VSS VSS gf180mcu_fd_sc_mcu7t5v0__fill_1
XFILLER_67_777 VDD VDD VSS VSS gf180mcu_fd_sc_mcu7t5v0__fillcap_4
XFILLER_94_585 VDD VDD VSS VSS gf180mcu_fd_sc_mcu7t5v0__fill_1
XTAP_TAPCELL_ROW_68_1206 VDD VSS gf180mcu_fd_sc_mcu7t5v0__filltie
XTAP_TAPCELL_ROW_68_1217 VDD VSS gf180mcu_fd_sc_mcu7t5v0__filltie
X_6932_ _6932_/D _6939_/CLK _6932_/Q VDD VDD VSS VSS gf180mcu_fd_sc_mcu7t5v0__dffq_1
X_6863_ _6863_/D _6915_/CLK _6863_/Q VDD VDD VSS VSS gf180mcu_fd_sc_mcu7t5v0__dffq_1
XFILLER_22_324 VDD VDD VSS VSS gf180mcu_fd_sc_mcu7t5v0__fill_1
XFILLER_23_836 VDD VDD VSS VSS gf180mcu_fd_sc_mcu7t5v0__fillcap_4
XFILLER_35_696 VDD VDD VSS VSS gf180mcu_fd_sc_mcu7t5v0__fillcap_4
X_5814_ _6315_/A1 _6283_/A2 _5883_/C _5943_/A1 VDD VDD VSS VSS gf180mcu_fd_sc_mcu7t5v0__aoi21_1
X_6794_ _6794_/D _7247_/CLK _6794_/Q VDD VDD VSS VSS gf180mcu_fd_sc_mcu7t5v0__dffq_1
X_5745_ _3676_/B _3702_/Z _5883_/B VDD VDD VSS VSS gf180mcu_fd_sc_mcu7t5v0__or2_1
XFILLER_109_908 VDD VDD VSS VSS gf180mcu_fd_sc_mcu7t5v0__fill_2
XTAP_TAPCELL_ROW_20_536 VDD VSS gf180mcu_fd_sc_mcu7t5v0__filltie
X_5676_ _7881_/I _7882_/I _5813_/A1 _6252_/A2 VDD VDD VSS VSS gf180mcu_fd_sc_mcu7t5v0__nor3_2
X_4627_ _7028_/Q _4630_/A2 _4628_/B VDD VDD VSS VSS gf180mcu_fd_sc_mcu7t5v0__nand2_1
XTAP_TAPCELL_ROW_79_1368 VDD VSS gf180mcu_fd_sc_mcu7t5v0__filltie
X_7415_ _7415_/D _7456_/CLK _7415_/Q VDD VDD VSS VSS gf180mcu_fd_sc_mcu7t5v0__dffq_1
XTAP_TAPCELL_ROW_92_1546 VDD VSS gf180mcu_fd_sc_mcu7t5v0__filltie
X_4558_ _5076_/A1 _4560_/A2 _4558_/B _6993_/D VDD VDD VSS VSS gf180mcu_fd_sc_mcu7t5v0__oai21_1
X_7346_ _7346_/D _7378_/CLK _7346_/Q VDD VDD VSS VSS gf180mcu_fd_sc_mcu7t5v0__dffq_1
X_4489_ _6959_/Q _4490_/A2 _4490_/B VDD VDD VSS VSS gf180mcu_fd_sc_mcu7t5v0__nand2_1
X_7277_ _7277_/D _7683_/CLK _7277_/Q VDD VDD VSS VSS gf180mcu_fd_sc_mcu7t5v0__dffq_1
X_3509_ _7718_/Q _7725_/Q _3926_/A3 VDD VDD VSS VSS gf180mcu_fd_sc_mcu7t5v0__xnor2_1
X_6228_ _6747_/Q _6228_/A2 _6228_/B1 _6746_/Q _6230_/A1 VDD VDD VSS VSS gf180mcu_fd_sc_mcu7t5v0__oai22_1
X_6159_ _6980_/Q _6229_/B1 _6228_/B1 _6987_/Q _7001_/Q _6222_/B1 _6160_/A2 VDD VDD
+ VSS VSS gf180mcu_fd_sc_mcu7t5v0__oai222_1
XTAP_TAPCELL_ROW_28_647 VDD VSS gf180mcu_fd_sc_mcu7t5v0__filltie
XTAP_TAPCELL_ROW_0_250 VDD VSS gf180mcu_fd_sc_mcu7t5v0__filltie
XTAP_TAPCELL_ROW_0_261 VDD VSS gf180mcu_fd_sc_mcu7t5v0__filltie
XFILLER_53_460 VDD VDD VSS VSS gf180mcu_fd_sc_mcu7t5v0__fill_1
XFILLER_81_780 VDD VDD VSS VSS gf180mcu_fd_sc_mcu7t5v0__fill_1
XTAP_TAPCELL_ROW_101_1675 VDD VSS gf180mcu_fd_sc_mcu7t5v0__filltie
XFILLER_96_817 VDD VDD VSS VSS gf180mcu_fd_sc_mcu7t5v0__fill_2
XTAP_TAPCELL_ROW_8_372 VDD VSS gf180mcu_fd_sc_mcu7t5v0__filltie
XFILLER_89_891 VDD VDD VSS VSS gf180mcu_fd_sc_mcu7t5v0__fillcap_16
XFILLER_37_906 VDD VDD VSS VSS gf180mcu_fd_sc_mcu7t5v0__fillcap_4
XPHY_EDGE_ROW_90_Left_209 VDD VSS gf180mcu_fd_sc_mcu7t5v0__endcap
XTAP_TAPCELL_ROW_47_912 VDD VSS gf180mcu_fd_sc_mcu7t5v0__filltie
XTAP_TAPCELL_ROW_47_923 VDD VSS gf180mcu_fd_sc_mcu7t5v0__filltie
XFILLER_17_696 VDD VDD VSS VSS gf180mcu_fd_sc_mcu7t5v0__fillcap_4
X_3860_ _3860_/A1 _7756_/Q _5694_/B VDD VDD VSS VSS gf180mcu_fd_sc_mcu7t5v0__nor2_1
XTAP_TAPCELL_ROW_63_1136 VDD VSS gf180mcu_fd_sc_mcu7t5v0__filltie
XTAP_TAPCELL_ROW_63_1147 VDD VSS gf180mcu_fd_sc_mcu7t5v0__filltie
X_3791_ _5634_/A1 _7766_/Q _3792_/A2 VDD VDD VSS VSS gf180mcu_fd_sc_mcu7t5v0__nor2_1
X_5530_ _5508_/C _5530_/A2 _5530_/A3 _5540_/A2 VDD VDD VSS VSS gf180mcu_fd_sc_mcu7t5v0__nor3_1
X_5461_ _5461_/I0 _5461_/I1 _7730_/Q _5461_/Z VDD VDD VSS VSS gf180mcu_fd_sc_mcu7t5v0__mux2_2
X_4412_ _5056_/A1 _4420_/A2 _4412_/B _6920_/D VDD VDD VSS VSS gf180mcu_fd_sc_mcu7t5v0__oai21_1
X_7200_ _7200_/D _7216_/CLK _7200_/Q VDD VDD VSS VSS gf180mcu_fd_sc_mcu7t5v0__dffq_1
X_5392_ _7429_/Q _5600_/B1 _5590_/B _5394_/A1 VDD VDD VSS VSS gf180mcu_fd_sc_mcu7t5v0__oai21_1
X_4343_ _6886_/Q _4350_/A2 _4344_/B VDD VDD VSS VSS gf180mcu_fd_sc_mcu7t5v0__nand2_1
XPHY_EDGE_ROW_99_Right_99 VDD VSS gf180mcu_fd_sc_mcu7t5v0__endcap
X_7131_ _7131_/D _7248_/CLK _7131_/Q VDD VDD VSS VSS gf180mcu_fd_sc_mcu7t5v0__dffq_1
XFILLER_99_688 VDD VDD VSS VSS gf180mcu_fd_sc_mcu7t5v0__fillcap_4
X_7062_ _7062_/D _7062_/CLK _7062_/Q VDD VDD VSS VSS gf180mcu_fd_sc_mcu7t5v0__dffq_1
XFILLER_87_806 VDD VDD VSS VSS gf180mcu_fd_sc_mcu7t5v0__fill_2
XTAP_TAPCELL_ROW_74_1298 VDD VSS gf180mcu_fd_sc_mcu7t5v0__filltie
X_4274_ _4540_/A1 _4280_/A2 _4274_/B _6851_/D VDD VDD VSS VSS gf180mcu_fd_sc_mcu7t5v0__oai21_1
XFILLER_113_498 VDD VDD VSS VSS gf180mcu_fd_sc_mcu7t5v0__fill_1
X_6013_ _6013_/A1 _6013_/A2 _6196_/B _6020_/A2 VDD VDD VSS VSS gf180mcu_fd_sc_mcu7t5v0__oai21_1
XFILLER_95_872 VDD VDD VSS VSS gf180mcu_fd_sc_mcu7t5v0__fillcap_4
XFILLER_82_588 VDD VDD VSS VSS gf180mcu_fd_sc_mcu7t5v0__fill_2
X_6915_ _6915_/D _6915_/CLK _6915_/Q VDD VDD VSS VSS gf180mcu_fd_sc_mcu7t5v0__dffq_1
XTAP_TAPCELL_ROW_25_606 VDD VSS gf180mcu_fd_sc_mcu7t5v0__filltie
XFILLER_63_780 VDD VDD VSS VSS gf180mcu_fd_sc_mcu7t5v0__fill_1
X_6846_ _6846_/D _7279_/CLK _6846_/Q VDD VDD VSS VSS gf180mcu_fd_sc_mcu7t5v0__dffq_1
X_6777_ _6777_/D _7252_/CLK _6777_/Q VDD VDD VSS VSS gf180mcu_fd_sc_mcu7t5v0__dffq_1
X_5728_ _6337_/A1 _7685_/Q _7633_/Q _5728_/B2 _5728_/C _5730_/B VDD VDD VSS VSS gf180mcu_fd_sc_mcu7t5v0__aoi221_1
X_3989_ _4088_/A1 _4406_/A2 _3989_/B _6749_/D VDD VDD VSS VSS gf180mcu_fd_sc_mcu7t5v0__oai21_1
XFILLER_109_738 VDD VDD VSS VSS gf180mcu_fd_sc_mcu7t5v0__fillcap_4
X_5659_ _6677_/A1 _5661_/S _5659_/B _7540_/D VDD VDD VSS VSS gf180mcu_fd_sc_mcu7t5v0__oai21_1
X_7329_ _7329_/D _7492_/CLK _7329_/Q VDD VDD VSS VSS gf180mcu_fd_sc_mcu7t5v0__dffq_1
XTAP_TAPCELL_ROW_5_331 VDD VSS gf180mcu_fd_sc_mcu7t5v0__filltie
XFILLER_19_906 VDD VDD VSS VSS gf180mcu_fd_sc_mcu7t5v0__fillcap_4
XFILLER_58_541 VDD VDD VSS VSS gf180mcu_fd_sc_mcu7t5v0__fillcap_4
XFILLER_73_522 VDD VDD VSS VSS gf180mcu_fd_sc_mcu7t5v0__fill_2
XTAP_TAPCELL_ROW_103_1704 VDD VSS gf180mcu_fd_sc_mcu7t5v0__filltie
XFILLER_60_227 VDD VDD VSS VSS gf180mcu_fd_sc_mcu7t5v0__fill_2
XFILLER_41_430 VDD VDD VSS VSS gf180mcu_fd_sc_mcu7t5v0__fill_1
XFILLER_53_290 VDD VDD VSS VSS gf180mcu_fd_sc_mcu7t5v0__fill_1
XTAP_TAPCELL_ROW_52_981 VDD VSS gf180mcu_fd_sc_mcu7t5v0__filltie
XTAP_TAPCELL_ROW_52_992 VDD VSS gf180mcu_fd_sc_mcu7t5v0__filltie
XFILLER_5_364 VDD VDD VSS VSS gf180mcu_fd_sc_mcu7t5v0__fill_1
XTAP_TAPCELL_ROW_114_1855 VDD VSS gf180mcu_fd_sc_mcu7t5v0__filltie
X_4961_ _7195_/Q _4966_/A2 _4962_/B VDD VDD VSS VSS gf180mcu_fd_sc_mcu7t5v0__nand2_1
X_3912_ _7582_/Q _7583_/Q _3912_/Z VDD VDD VSS VSS gf180mcu_fd_sc_mcu7t5v0__xor2_1
X_7680_ _7680_/D _7802_/RN _7683_/CLK _7680_/Q VDD VDD VSS VSS gf180mcu_fd_sc_mcu7t5v0__dffrnq_1
X_6700_ _7748_/Q _6716_/A2 _6714_/B1 _7749_/Q _6701_/I VDD VDD VSS VSS gf180mcu_fd_sc_mcu7t5v0__aoi22_1
X_4892_ _5060_/A1 _4896_/A2 _4892_/B _7160_/D VDD VDD VSS VSS gf180mcu_fd_sc_mcu7t5v0__oai21_1
X_3843_ _6263_/A1 _6267_/A1 _3820_/Z _3843_/Z VDD VDD VSS VSS gf180mcu_fd_sc_mcu7t5v0__xor3_1
X_6631_ _7727_/Q _6631_/A2 _6633_/B VDD VDD VSS VSS gf180mcu_fd_sc_mcu7t5v0__nand2_1
X_3774_ _7565_/Q _7556_/Q _7811_/D VDD VDD VSS VSS gf180mcu_fd_sc_mcu7t5v0__and2_1
X_6562_ _7697_/Q _7696_/Q _6566_/S _7697_/D VDD VDD VSS VSS gf180mcu_fd_sc_mcu7t5v0__mux2_2
XTAP_TAPCELL_ROW_76_1316 VDD VSS gf180mcu_fd_sc_mcu7t5v0__filltie
X_5513_ _7307_/Q _5515_/A2 _5516_/C2 _7314_/Q _5521_/A1 VDD VDD VSS VSS gf180mcu_fd_sc_mcu7t5v0__oai22_1
XTAP_TAPCELL_ROW_30_675 VDD VSS gf180mcu_fd_sc_mcu7t5v0__filltie
X_6493_ _7672_/Q _7791_/Q _7673_/Q _6494_/A3 VDD VDD VSS VSS gf180mcu_fd_sc_mcu7t5v0__aoi21_1
XTAP_TAPCELL_ROW_76_1327 VDD VSS gf180mcu_fd_sc_mcu7t5v0__filltie
X_5444_ _7347_/Q _5572_/C2 wire420/Z _7333_/Q _5446_/A2 VDD VDD VSS VSS gf180mcu_fd_sc_mcu7t5v0__oai22_1
X_5375_ _5375_/A1 _5375_/A2 _5385_/B1 VDD VDD VSS VSS gf180mcu_fd_sc_mcu7t5v0__nor2_1
X_7114_ _7114_/D _7217_/CLK _7114_/Q VDD VDD VSS VSS gf180mcu_fd_sc_mcu7t5v0__dffq_1
XFILLER_102_947 VDD VDD VSS VSS gf180mcu_fd_sc_mcu7t5v0__fillcap_32
XFILLER_101_424 VDD VDD VSS VSS gf180mcu_fd_sc_mcu7t5v0__fill_1
X_4326_ _4396_/A1 _4336_/A2 _4326_/B _6877_/D VDD VDD VSS VSS gf180mcu_fd_sc_mcu7t5v0__oai21_1
X_7045_ _7045_/D _7062_/CLK _7045_/Q VDD VDD VSS VSS gf180mcu_fd_sc_mcu7t5v0__dffq_1
X_4257_ _6843_/Q _4266_/A2 _4258_/B VDD VDD VSS VSS gf180mcu_fd_sc_mcu7t5v0__nand2_1
X_4188_ wire507/Z _6811_/Q _5204_/S _6811_/D VDD VDD VSS VSS gf180mcu_fd_sc_mcu7t5v0__mux2_2
XTAP_TAPCELL_ROW_87_1478 VDD VSS gf180mcu_fd_sc_mcu7t5v0__filltie
XFILLER_83_864 VDD VDD VSS VSS gf180mcu_fd_sc_mcu7t5v0__fill_2
XTAP_TAPCELL_ROW_38_786 VDD VSS gf180mcu_fd_sc_mcu7t5v0__filltie
XTAP_TAPCELL_ROW_38_797 VDD VSS gf180mcu_fd_sc_mcu7t5v0__filltie
XFILLER_43_739 VDD VDD VSS VSS gf180mcu_fd_sc_mcu7t5v0__fillcap_16
X_7878_ _7878_/I _7878_/Z VDD VDD VSS VSS gf180mcu_fd_sc_mcu7t5v0__buf_1
X_6829_ _6829_/D _7490_/CLK _6829_/Q VDD VDD VSS VSS gf180mcu_fd_sc_mcu7t5v0__dffq_1
XFILLER_109_502 VDD VDD VSS VSS gf180mcu_fd_sc_mcu7t5v0__fill_1
XFILLER_109_546 VDD VDD VSS VSS gf180mcu_fd_sc_mcu7t5v0__fill_1
XFILLER_2_389 VDD VDD VSS VSS gf180mcu_fd_sc_mcu7t5v0__fill_1
XFILLER_78_669 VDD VDD VSS VSS gf180mcu_fd_sc_mcu7t5v0__fill_1
XFILLER_59_872 VDD VDD VSS VSS gf180mcu_fd_sc_mcu7t5v0__fillcap_32
XFILLER_74_831 VDD VDD VSS VSS gf180mcu_fd_sc_mcu7t5v0__fill_2
XFILLER_46_522 VDD VDD VSS VSS gf180mcu_fd_sc_mcu7t5v0__fill_2
XFILLER_74_853 VDD VDD VSS VSS gf180mcu_fd_sc_mcu7t5v0__fillcap_4
X_3490_ _5926_/B _6617_/A1 _3491_/I VDD VDD VSS VSS gf180mcu_fd_sc_mcu7t5v0__nand2_1
XFILLER_115_549 VDD VDD VSS VSS gf180mcu_fd_sc_mcu7t5v0__fill_1
XTAP_TAPCELL_ROW_58_1068 VDD VSS gf180mcu_fd_sc_mcu7t5v0__filltie
XFILLER_97_912 VDD VDD VSS VSS gf180mcu_fd_sc_mcu7t5v0__fillcap_64
X_5160_ wire521/Z _7307_/Q _5162_/S _7307_/D VDD VDD VSS VSS gf180mcu_fd_sc_mcu7t5v0__mux2_2
XTAP_TAPCELL_ROW_71_1246 VDD VSS gf180mcu_fd_sc_mcu7t5v0__filltie
X_5091_ _7260_/Q _5092_/A2 _5092_/B VDD VDD VSS VSS gf180mcu_fd_sc_mcu7t5v0__nand2_1
X_4111_ _6788_/Q _4952_/A2 _4112_/B VDD VDD VSS VSS gf180mcu_fd_sc_mcu7t5v0__nand2_1
XTAP_TAPCELL_ROW_71_1257 VDD VSS gf180mcu_fd_sc_mcu7t5v0__filltie
X_4042_ _6766_/Q _4644_/A2 _4043_/B VDD VDD VSS VSS gf180mcu_fd_sc_mcu7t5v0__nand2_1
X_5993_ _5993_/A1 _5993_/A2 _5993_/B1 _5993_/B2 _5995_/B1 VDD VDD VSS VSS gf180mcu_fd_sc_mcu7t5v0__oai22_1
X_7801_ _7801_/D _7802_/RN _7802_/CLK _7801_/Q VDD VDD VSS VSS gf180mcu_fd_sc_mcu7t5v0__dffrnq_1
XTAP_TAPCELL_ROW_35_745 VDD VSS gf180mcu_fd_sc_mcu7t5v0__filltie
X_7732_ _7732_/D _7736_/RN _7782_/CLK _7732_/Q VDD VDD VSS VSS gf180mcu_fd_sc_mcu7t5v0__dffrnq_1
X_4944_ _5112_/A1 _4952_/A2 _4944_/B _7186_/D VDD VDD VSS VSS gf180mcu_fd_sc_mcu7t5v0__oai21_1
XFILLER_21_912 VDD VDD VSS VSS gf180mcu_fd_sc_mcu7t5v0__fillcap_64
XFILLER_33_772 VDD VDD VSS VSS gf180mcu_fd_sc_mcu7t5v0__fillcap_64
X_7663_ _7663_/D _7664_/RN _7669_/CLK _7663_/Q VDD VDD VSS VSS gf180mcu_fd_sc_mcu7t5v0__dffrnq_1
X_4875_ _7152_/Q _4882_/A2 _4876_/B VDD VDD VSS VSS gf180mcu_fd_sc_mcu7t5v0__nand2_1
X_7594_ _7594_/D _7660_/RN _7671_/CLK _7594_/Q VDD VDD VSS VSS gf180mcu_fd_sc_mcu7t5v0__dffrnq_1
X_3826_ _7574_/Q _3821_/Z _3822_/Z _3826_/Z VDD VDD VSS VSS gf180mcu_fd_sc_mcu7t5v0__xor3_1
X_6614_ _7721_/Q _6616_/A2 _6617_/A2 VDD VDD VSS VSS gf180mcu_fd_sc_mcu7t5v0__nand2_1
X_6545_ _7691_/Q _6543_/Z _6547_/A2 VDD VDD VSS VSS gf180mcu_fd_sc_mcu7t5v0__nor2_1
X_3757_ _3757_/I _3758_/B2 VDD VDD VSS VSS gf180mcu_fd_sc_mcu7t5v0__clkinv_1
X_6476_ _7670_/Q _7536_/Q _6478_/A1 _6476_/Z VDD VDD VSS VSS gf180mcu_fd_sc_mcu7t5v0__xor3_1
X_3688_ _3682_/C _3688_/A2 _3689_/B2 VDD VDD VSS VSS gf180mcu_fd_sc_mcu7t5v0__nand2_1
X_5427_ _7416_/Q _5535_/C2 _5429_/A2 VDD VDD VSS VSS gf180mcu_fd_sc_mcu7t5v0__nor2_1
X_5358_ _7645_/Q _7505_/Q _5358_/S _7505_/D VDD VDD VSS VSS gf180mcu_fd_sc_mcu7t5v0__mux2_2
X_4309_ _6869_/Q _4322_/A2 _4310_/B VDD VDD VSS VSS gf180mcu_fd_sc_mcu7t5v0__nand2_1
X_7028_ _7028_/D _7060_/CLK _7028_/Q VDD VDD VSS VSS gf180mcu_fd_sc_mcu7t5v0__dffq_1
XTAP_TAPCELL_ROW_89_1507 VDD VSS gf180mcu_fd_sc_mcu7t5v0__filltie
XFILLER_75_628 VDD VDD VSS VSS gf180mcu_fd_sc_mcu7t5v0__fill_2
X_5289_ _6353_/I0 _7436_/Q _5295_/S _7436_/D VDD VDD VSS VSS gf180mcu_fd_sc_mcu7t5v0__mux2_2
XFILLER_56_864 VDD VDD VSS VSS gf180mcu_fd_sc_mcu7t5v0__fill_2
XFILLER_70_333 VDD VDD VSS VSS gf180mcu_fd_sc_mcu7t5v0__fill_1
Xclkbuf_3_0__f_clk_i clkbuf_0_clk_i/Z clkload0/I VDD VDD VSS VSS gf180mcu_fd_sc_mcu7t5v0__clkbuf_16
XTAP_TAPCELL_ROW_13_439 VDD VSS gf180mcu_fd_sc_mcu7t5v0__filltie
XFILLER_51_591 VDD VDD VSS VSS gf180mcu_fd_sc_mcu7t5v0__fill_1
Xwire313 wire313/I wire313/Z VDD VDD VSS VSS gf180mcu_fd_sc_mcu7t5v0__clkbuf_4
XFILLER_3_632 VDD VDD VSS VSS gf180mcu_fd_sc_mcu7t5v0__fillcap_64
XTAP_TAPCELL_ROW_111_1814 VDD VSS gf180mcu_fd_sc_mcu7t5v0__filltie
XFILLER_97_208 VDD VDD VSS VSS gf180mcu_fd_sc_mcu7t5v0__fill_2
XFILLER_79_934 VDD VDD VSS VSS gf180mcu_fd_sc_mcu7t5v0__fillcap_32
XFILLER_79_912 VDD VDD VSS VSS gf180mcu_fd_sc_mcu7t5v0__fill_1
Xload_slew318 _6177_/C2 _6241_/A2 VDD VDD VSS VSS gf180mcu_fd_sc_mcu7t5v0__buf_4
Xload_slew307 _6138_/B1 _6171_/A2 VDD VDD VSS VSS gf180mcu_fd_sc_mcu7t5v0__buf_4
Xload_slew329 _6215_/A2 _6098_/A2 VDD VDD VSS VSS gf180mcu_fd_sc_mcu7t5v0__buf_4
XFILLER_79_978 VDD VDD VSS VSS gf180mcu_fd_sc_mcu7t5v0__fill_2
Xfanout490 _6204_/B _6090_/C VDD VDD VSS VSS gf180mcu_fd_sc_mcu7t5v0__dlyd_1
XFILLER_74_661 VDD VDD VSS VSS gf180mcu_fd_sc_mcu7t5v0__fillcap_4
XTAP_TAPCELL_ROW_109_1787 VDD VSS gf180mcu_fd_sc_mcu7t5v0__filltie
XFILLER_64_81 VDD VDD VSS VSS gf180mcu_fd_sc_mcu7t5v0__fill_1
XFILLER_15_772 VDD VDD VSS VSS gf180mcu_fd_sc_mcu7t5v0__fillcap_64
XFILLER_21_208 VDD VDD VSS VSS gf180mcu_fd_sc_mcu7t5v0__fill_2
XTAP_TAPCELL_ROW_32_704 VDD VSS gf180mcu_fd_sc_mcu7t5v0__filltie
XFILLER_30_731 VDD VDD VSS VSS gf180mcu_fd_sc_mcu7t5v0__fillcap_4
XFILLER_42_591 VDD VDD VSS VSS gf180mcu_fd_sc_mcu7t5v0__fillcap_4
X_4660_ _5094_/A1 _4672_/A2 _4660_/B _7044_/D VDD VDD VSS VSS gf180mcu_fd_sc_mcu7t5v0__oai21_1
X_3611_ _3611_/A1 _3610_/Z _3612_/A3 VDD VDD VSS VSS gf180mcu_fd_sc_mcu7t5v0__xnor2_1
X_4591_ _7010_/Q _4602_/A2 _4592_/B VDD VDD VSS VSS gf180mcu_fd_sc_mcu7t5v0__nand2_1
X_6330_ _6330_/A1 _6331_/S _6330_/B _7623_/D VDD VDD VSS VSS gf180mcu_fd_sc_mcu7t5v0__oai21_1
X_3542_ input18/Z _3695_/C _3677_/S _3542_/Z VDD VDD VSS VSS gf180mcu_fd_sc_mcu7t5v0__xor3_1
XFILLER_50_2 VDD VDD VSS VSS gf180mcu_fd_sc_mcu7t5v0__fill_2
X_6261_ _6261_/A1 _5744_/B _6300_/B1 _6261_/B2 _7583_/D VDD VDD VSS VSS gf180mcu_fd_sc_mcu7t5v0__aoi22_1
X_3473_ _7817_/D _7816_/D _7766_/D VDD VDD VSS VSS gf180mcu_fd_sc_mcu7t5v0__xor2_1
X_6192_ _6771_/Q _6192_/A2 wire353/I _6760_/Q _6738_/Q _6215_/A2 _6193_/A2 VDD VDD
+ VSS VSS gf180mcu_fd_sc_mcu7t5v0__oai222_1
X_5212_ _6353_/I0 _7359_/Q _5218_/S _7359_/D VDD VDD VSS VSS gf180mcu_fd_sc_mcu7t5v0__mux2_2
X_5143_ _5304_/I0 _7290_/Q _5148_/S _7290_/D VDD VDD VSS VSS gf180mcu_fd_sc_mcu7t5v0__mux2_2
X_5074_ wire241/Z _5074_/A2 _5074_/B _7251_/D VDD VDD VSS VSS gf180mcu_fd_sc_mcu7t5v0__aoi21_1
X_4025_ _6761_/Q _4574_/A2 _4026_/B VDD VDD VSS VSS gf180mcu_fd_sc_mcu7t5v0__nand2_1
XTAP_TAPCELL_ROW_84_1437 VDD VSS gf180mcu_fd_sc_mcu7t5v0__filltie
XFILLER_25_558 VDD VDD VSS VSS gf180mcu_fd_sc_mcu7t5v0__fill_2
XFILLER_53_856 VDD VDD VSS VSS gf180mcu_fd_sc_mcu7t5v0__fillcap_32
X_5976_ _5976_/A1 _5976_/A2 _6184_/C _5997_/A2 VDD VDD VSS VSS gf180mcu_fd_sc_mcu7t5v0__oai21_1
X_4927_ _7178_/Q _4938_/A2 _4928_/B VDD VDD VSS VSS gf180mcu_fd_sc_mcu7t5v0__nand2_1
X_7715_ _7715_/D wire593/Z _7755_/CLK _7715_/Q VDD VDD VSS VSS gf180mcu_fd_sc_mcu7t5v0__dffrnq_1
X_4858_ _5110_/A1 _4868_/A2 _4858_/B _7143_/D VDD VDD VSS VSS gf180mcu_fd_sc_mcu7t5v0__oai21_1
X_7646_ _7646_/D _7782_/RN _7782_/CLK _7646_/Q VDD VDD VSS VSS gf180mcu_fd_sc_mcu7t5v0__dffrnq_1
X_3809_ _3809_/I _7778_/D VDD VDD VSS VSS gf180mcu_fd_sc_mcu7t5v0__clkinv_1
X_7577_ _7577_/D _7595_/RN _7710_/CLK _7577_/Q VDD VDD VSS VSS gf180mcu_fd_sc_mcu7t5v0__dffrnq_1
X_4789_ _7109_/Q _4798_/A2 _4790_/B VDD VDD VSS VSS gf180mcu_fd_sc_mcu7t5v0__nand2_1
X_6528_ _7685_/Q _6526_/Z _6529_/A2 VDD VDD VSS VSS gf180mcu_fd_sc_mcu7t5v0__xnor2_1
X_6459_ _7668_/Q _7534_/Q _6459_/Z VDD VDD VSS VSS gf180mcu_fd_sc_mcu7t5v0__or2_1
XTAP_TAPCELL_ROW_95_1588 VDD VSS gf180mcu_fd_sc_mcu7t5v0__filltie
XFILLER_88_742 VDD VDD VSS VSS gf180mcu_fd_sc_mcu7t5v0__fillcap_8
XFILLER_87_296 VDD VDD VSS VSS gf180mcu_fd_sc_mcu7t5v0__fill_1
XFILLER_29_842 VDD VDD VSS VSS gf180mcu_fd_sc_mcu7t5v0__fillcap_64
XFILLER_84_981 VDD VDD VSS VSS gf180mcu_fd_sc_mcu7t5v0__fill_1
XTAP_TAPCELL_ROW_18_509 VDD VSS gf180mcu_fd_sc_mcu7t5v0__filltie
XFILLER_44_801 VDD VDD VSS VSS gf180mcu_fd_sc_mcu7t5v0__fillcap_4
XFILLER_12_731 VDD VDD VSS VSS gf180mcu_fd_sc_mcu7t5v0__fillcap_4
XFILLER_11_263 VDD VDD VSS VSS gf180mcu_fd_sc_mcu7t5v0__fill_1
XFILLER_4_941 VDD VDD VSS VSS gf180mcu_fd_sc_mcu7t5v0__fillcap_4
XTAP_TAPCELL_ROW_55_1027 VDD VSS gf180mcu_fd_sc_mcu7t5v0__filltie
XFILLER_81_417 VDD VDD VSS VSS gf180mcu_fd_sc_mcu7t5v0__fill_2
XFILLER_19_352 VDD VDD VSS VSS gf180mcu_fd_sc_mcu7t5v0__fill_2
X_5830_ _5830_/A1 _5830_/A2 _5834_/B1 VDD VDD VSS VSS gf180mcu_fd_sc_mcu7t5v0__nor2_1
XFILLER_62_664 VDD VDD VSS VSS gf180mcu_fd_sc_mcu7t5v0__fill_1
XTAP_TAPCELL_ROW_66_1178 VDD VSS gf180mcu_fd_sc_mcu7t5v0__filltie
X_5761_ _5761_/A1 _5761_/A2 _5764_/C VDD VDD VSS VSS gf180mcu_fd_sc_mcu7t5v0__or2_1
XTAP_TAPCELL_ROW_45_884 VDD VSS gf180mcu_fd_sc_mcu7t5v0__filltie
XTAP_TAPCELL_ROW_45_895 VDD VSS gf180mcu_fd_sc_mcu7t5v0__filltie
XTAP_TAPCELL_ROW_66_1189 VDD VSS gf180mcu_fd_sc_mcu7t5v0__filltie
X_4712_ _5076_/A1 _4714_/A2 _4712_/B _7070_/D VDD VDD VSS VSS gf180mcu_fd_sc_mcu7t5v0__oai21_1
X_7500_ _7500_/D _7500_/CLK _7500_/Q VDD VDD VSS VSS gf180mcu_fd_sc_mcu7t5v0__dffq_1
X_7431_ _7431_/D _7754_/CLK _7431_/Q VDD VDD VSS VSS gf180mcu_fd_sc_mcu7t5v0__dffq_1
X_5692_ _3703_/Z _5692_/A2 _5738_/A2 VDD VDD VSS VSS gf180mcu_fd_sc_mcu7t5v0__nor2_1
X_4643_ _7036_/Q _4644_/A2 _4644_/B VDD VDD VSS VSS gf180mcu_fd_sc_mcu7t5v0__nand2_1
X_4574_ _5134_/A1 _4574_/A2 _4574_/B _7001_/D VDD VDD VSS VSS gf180mcu_fd_sc_mcu7t5v0__oai21_1
X_7362_ _7362_/D _7822_/CLK _7362_/Q VDD VDD VSS VSS gf180mcu_fd_sc_mcu7t5v0__dffq_1
X_6313_ _7885_/I _5744_/B _6314_/B VDD VDD VSS VSS gf180mcu_fd_sc_mcu7t5v0__nand2_1
X_3525_ _3525_/A1 _3525_/A2 _7773_/D VDD VDD VSS VSS gf180mcu_fd_sc_mcu7t5v0__nor2_1
X_7293_ _7293_/D _7505_/CLK _7293_/Q VDD VDD VSS VSS gf180mcu_fd_sc_mcu7t5v0__dffq_1
X_6244_ _6244_/A1 _6244_/A2 _6244_/B1 _6237_/B _6244_/C _6245_/A3 VDD VDD VSS VSS
+ gf180mcu_fd_sc_mcu7t5v0__oai221_1
X_3456_ _7596_/Q _6288_/A1 VDD VDD VSS VSS gf180mcu_fd_sc_mcu7t5v0__clkinv_1
XPHY_EDGE_ROW_110_Left_229 VDD VSS gf180mcu_fd_sc_mcu7t5v0__endcap
X_3387_ _7726_/Q _5373_/A1 VDD VDD VSS VSS gf180mcu_fd_sc_mcu7t5v0__clkinv_1
X_6175_ _7197_/Q _6175_/A2 _6232_/A2 _7204_/Q _7218_/Q _6233_/A2 _6176_/A2 VDD VDD
+ VSS VSS gf180mcu_fd_sc_mcu7t5v0__oai222_1
X_5126_ _5126_/A1 _5134_/A2 _5126_/B _7277_/D VDD VDD VSS VSS gf180mcu_fd_sc_mcu7t5v0__oai21_1
XFILLER_57_458 VDD VDD VSS VSS gf180mcu_fd_sc_mcu7t5v0__fill_2
X_5057_ _7243_/Q _5064_/A2 _5058_/B VDD VDD VSS VSS gf180mcu_fd_sc_mcu7t5v0__nand2_1
X_4008_ wire248/Z _4490_/A2 _4008_/B _6755_/D VDD VDD VSS VSS gf180mcu_fd_sc_mcu7t5v0__oai21_1
XFILLER_26_801 VDD VDD VSS VSS gf180mcu_fd_sc_mcu7t5v0__fillcap_4
XFILLER_38_661 VDD VDD VSS VSS gf180mcu_fd_sc_mcu7t5v0__fillcap_4
XFILLER_66_981 VDD VDD VSS VSS gf180mcu_fd_sc_mcu7t5v0__fill_1
XFILLER_81_973 VDD VDD VSS VSS gf180mcu_fd_sc_mcu7t5v0__fillcap_4
X_5959_ _6844_/Q _5969_/B1 _6197_/B _5961_/A1 VDD VDD VSS VSS gf180mcu_fd_sc_mcu7t5v0__oai21_1
XFILLER_25_388 VDD VDD VSS VSS gf180mcu_fd_sc_mcu7t5v0__fill_2
XTAP_TAPCELL_ROW_23_578 VDD VSS gf180mcu_fd_sc_mcu7t5v0__filltie
XTAP_TAPCELL_ROW_97_1617 VDD VSS gf180mcu_fd_sc_mcu7t5v0__filltie
X_7629_ _7629_/D _7710_/RN _7710_/CLK _7629_/Q VDD VDD VSS VSS gf180mcu_fd_sc_mcu7t5v0__dffrnq_1
XFILLER_107_699 VDD VDD VSS VSS gf180mcu_fd_sc_mcu7t5v0__fill_1
XFILLER_0_410 VDD VDD VSS VSS gf180mcu_fd_sc_mcu7t5v0__fill_2
XFILLER_88_594 VDD VDD VSS VSS gf180mcu_fd_sc_mcu7t5v0__fill_1
XFILLER_35_108 VDD VDD VSS VSS gf180mcu_fd_sc_mcu7t5v0__fill_1
XTAP_TAPCELL_ROW_106_1746 VDD VSS gf180mcu_fd_sc_mcu7t5v0__filltie
XFILLER_44_675 VDD VDD VSS VSS gf180mcu_fd_sc_mcu7t5v0__fillcap_4
XTAP_TAPCELL_ROW_42_843 VDD VSS gf180mcu_fd_sc_mcu7t5v0__filltie
XFILLER_12_594 VDD VDD VSS VSS gf180mcu_fd_sc_mcu7t5v0__fill_1
XANTENNA_4 _7576_/D VDD VDD VSS VSS gf180mcu_fd_sc_mcu7t5v0__antenna
XTAP_TAPCELL_ROW_117_1897 VDD VSS gf180mcu_fd_sc_mcu7t5v0__filltie
XFILLER_98_314 VDD VDD VSS VSS gf180mcu_fd_sc_mcu7t5v0__fill_1
X_4290_ _5130_/A1 _4294_/A2 _4290_/B _6859_/D VDD VDD VSS VSS gf180mcu_fd_sc_mcu7t5v0__oai21_1
XFILLER_48_981 VDD VDD VSS VSS gf180mcu_fd_sc_mcu7t5v0__fill_1
XTAP_TAPCELL_ROW_68_1207 VDD VSS gf180mcu_fd_sc_mcu7t5v0__filltie
X_6931_ _6931_/D _7064_/CLK _6931_/Q VDD VDD VSS VSS gf180mcu_fd_sc_mcu7t5v0__dffq_1
X_6862_ _6862_/D _6882_/CLK _6862_/Q VDD VDD VSS VSS gf180mcu_fd_sc_mcu7t5v0__dffq_1
XFILLER_34_152 VDD VDD VSS VSS gf180mcu_fd_sc_mcu7t5v0__fill_2
XFILLER_63_973 VDD VDD VSS VSS gf180mcu_fd_sc_mcu7t5v0__fillcap_4
X_5813_ _5813_/A1 _5813_/A2 _5813_/Z VDD VDD VSS VSS gf180mcu_fd_sc_mcu7t5v0__or2_1
X_6793_ _6793_/D _7266_/CLK _6793_/Q VDD VDD VSS VSS gf180mcu_fd_sc_mcu7t5v0__dffq_1
X_5744_ _5744_/A1 input7/Z _5744_/B _7571_/D VDD VDD VSS VSS gf180mcu_fd_sc_mcu7t5v0__oai21_1
XTAP_TAPCELL_ROW_20_537 VDD VSS gf180mcu_fd_sc_mcu7t5v0__filltie
X_5675_ _7552_/Q input31/Z _5675_/S _7552_/D VDD VDD VSS VSS gf180mcu_fd_sc_mcu7t5v0__mux2_2
X_4626_ wire240/Z _4630_/A2 _4626_/B _7027_/D VDD VDD VSS VSS gf180mcu_fd_sc_mcu7t5v0__oai21_1
XTAP_TAPCELL_ROW_79_1358 VDD VSS gf180mcu_fd_sc_mcu7t5v0__filltie
X_7414_ _7414_/D _7456_/CLK _7414_/Q VDD VDD VSS VSS gf180mcu_fd_sc_mcu7t5v0__dffq_1
XTAP_TAPCELL_ROW_79_1369 VDD VSS gf180mcu_fd_sc_mcu7t5v0__filltie
X_7345_ _7345_/D _7804_/CLK _7345_/Q VDD VDD VSS VSS gf180mcu_fd_sc_mcu7t5v0__dffq_1
X_4557_ _6993_/Q _4560_/A2 _4558_/B VDD VDD VSS VSS gf180mcu_fd_sc_mcu7t5v0__nand2_1
X_4488_ _5118_/A1 _4490_/A2 _4488_/B _6958_/D VDD VDD VSS VSS gf180mcu_fd_sc_mcu7t5v0__oai21_1
X_7276_ _7276_/D _7276_/CLK _7276_/Q VDD VDD VSS VSS gf180mcu_fd_sc_mcu7t5v0__dffq_1
XTAP_TAPCELL_ROW_92_1547 VDD VSS gf180mcu_fd_sc_mcu7t5v0__filltie
X_3508_ _3504_/Z _3508_/A2 _3508_/B _3510_/A1 VDD VDD VSS VSS gf180mcu_fd_sc_mcu7t5v0__aoi21_1
X_6227_ _6750_/Q _6227_/A2 _6227_/B _6227_/C _6230_/B VDD VDD VSS VSS gf180mcu_fd_sc_mcu7t5v0__oai211_1
X_3439_ _7580_/Q _6255_/A1 VDD VDD VSS VSS gf180mcu_fd_sc_mcu7t5v0__clkinv_1
X_6158_ _7008_/Q _6162_/A2 _6221_/B _6160_/A1 VDD VDD VSS VSS gf180mcu_fd_sc_mcu7t5v0__oai21_1
XFILLER_98_881 VDD VDD VSS VSS gf180mcu_fd_sc_mcu7t5v0__fill_2
XFILLER_58_734 VDD VDD VSS VSS gf180mcu_fd_sc_mcu7t5v0__fill_1
X_5109_ _7269_/Q _5120_/A2 _5110_/B VDD VDD VSS VSS gf180mcu_fd_sc_mcu7t5v0__nand2_1
XFILLER_100_864 VDD VDD VSS VSS gf180mcu_fd_sc_mcu7t5v0__fill_1
X_6089_ _6860_/Q _6198_/C2 _6089_/B1 _6867_/Q _6094_/A1 VDD VDD VSS VSS gf180mcu_fd_sc_mcu7t5v0__oai22_1
XFILLER_85_575 VDD VDD VSS VSS gf180mcu_fd_sc_mcu7t5v0__fill_1
XFILLER_45_417 VDD VDD VSS VSS gf180mcu_fd_sc_mcu7t5v0__fill_2
XTAP_TAPCELL_ROW_28_648 VDD VSS gf180mcu_fd_sc_mcu7t5v0__filltie
XFILLER_38_491 VDD VDD VSS VSS gf180mcu_fd_sc_mcu7t5v0__fill_1
XTAP_TAPCELL_ROW_0_240 VDD VSS gf180mcu_fd_sc_mcu7t5v0__filltie
XTAP_TAPCELL_ROW_0_251 VDD VSS gf180mcu_fd_sc_mcu7t5v0__filltie
XTAP_TAPCELL_ROW_0_262 VDD VSS gf180mcu_fd_sc_mcu7t5v0__filltie
XTAP_TAPCELL_ROW_101_1676 VDD VSS gf180mcu_fd_sc_mcu7t5v0__filltie
XFILLER_13_369 VDD VDD VSS VSS gf180mcu_fd_sc_mcu7t5v0__fill_1
XFILLER_108_942 VDD VDD VSS VSS gf180mcu_fd_sc_mcu7t5v0__fill_2
XFILLER_5_535 VDD VDD VSS VSS gf180mcu_fd_sc_mcu7t5v0__fillcap_16
XFILLER_96_807 VDD VDD VSS VSS gf180mcu_fd_sc_mcu7t5v0__fill_2
XTAP_TAPCELL_ROW_8_373 VDD VSS gf180mcu_fd_sc_mcu7t5v0__filltie
XFILLER_0_240 VDD VDD VSS VSS gf180mcu_fd_sc_mcu7t5v0__fill_2
XTAP_TAPCELL_ROW_47_913 VDD VSS gf180mcu_fd_sc_mcu7t5v0__filltie
XFILLER_91_545 VDD VDD VSS VSS gf180mcu_fd_sc_mcu7t5v0__fill_2
XFILLER_76_597 VDD VDD VSS VSS gf180mcu_fd_sc_mcu7t5v0__fill_2
XFILLER_64_737 VDD VDD VSS VSS gf180mcu_fd_sc_mcu7t5v0__fill_2
XFILLER_72_770 VDD VDD VSS VSS gf180mcu_fd_sc_mcu7t5v0__fill_1
XFILLER_20_807 VDD VDD VSS VSS gf180mcu_fd_sc_mcu7t5v0__fillcap_64
XFILLER_32_667 VDD VDD VSS VSS gf180mcu_fd_sc_mcu7t5v0__fillcap_64
XTAP_TAPCELL_ROW_63_1137 VDD VSS gf180mcu_fd_sc_mcu7t5v0__filltie
X_3790_ _7768_/Q _7766_/Q _3790_/B _5634_/A2 VDD VDD VSS VSS gf180mcu_fd_sc_mcu7t5v0__oai21_1
Xclkbuf_leaf_43_clk_i clkload5/I _7008_/CLK VDD VDD VSS VSS gf180mcu_fd_sc_mcu7t5v0__clkbuf_8
X_5460_ _5614_/B _5460_/A2 _5460_/A3 _5460_/B1 _5460_/B2 _5461_/I0 VDD VDD VSS VSS
+ gf180mcu_fd_sc_mcu7t5v0__oai32_1
Xuart racl_error_o[0] VDD VDD VSS VSS gf180mcu_fd_sc_mcu7t5v0__tiel
X_4411_ _6920_/Q _4420_/A2 _4412_/B VDD VDD VSS VSS gf180mcu_fd_sc_mcu7t5v0__nand2_1
X_5391_ _5549_/C _5391_/A2 _5391_/A3 _5398_/A3 VDD VDD VSS VSS gf180mcu_fd_sc_mcu7t5v0__nor3_1
X_4342_ _5014_/A1 _4350_/A2 _4342_/B _6885_/D VDD VDD VSS VSS gf180mcu_fd_sc_mcu7t5v0__oai21_1
Xclkbuf_leaf_58_clk_i clkload4/I _7118_/CLK VDD VDD VSS VSS gf180mcu_fd_sc_mcu7t5v0__clkbuf_8
X_7130_ _7130_/D _7248_/CLK _7130_/Q VDD VDD VSS VSS gf180mcu_fd_sc_mcu7t5v0__dffq_1
X_4273_ _6851_/Q _4280_/A2 _4274_/B VDD VDD VSS VSS gf180mcu_fd_sc_mcu7t5v0__nand2_1
X_7061_ _7061_/D _7261_/CLK _7061_/Q VDD VDD VSS VSS gf180mcu_fd_sc_mcu7t5v0__dffq_1
Xfanout319 fanout323/Z _6198_/C2 VDD VDD VSS VSS gf180mcu_fd_sc_mcu7t5v0__dlyd_1
XTAP_TAPCELL_ROW_74_1288 VDD VSS gf180mcu_fd_sc_mcu7t5v0__filltie
Xfanout308 _6215_/B1 _6112_/A2 VDD VDD VSS VSS gf180mcu_fd_sc_mcu7t5v0__dlyd_1
XFILLER_113_488 VDD VDD VSS VSS gf180mcu_fd_sc_mcu7t5v0__fill_2
X_6012_ _7265_/Q _6198_/A2 _6076_/A2 _7258_/Q _7146_/Q wire322/Z _6013_/A2 VDD VDD
+ VSS VSS gf180mcu_fd_sc_mcu7t5v0__oai222_1
XTAP_TAPCELL_ROW_74_1299 VDD VSS gf180mcu_fd_sc_mcu7t5v0__filltie
.ends
