* NGSPICE file created from xbar_tlul_2to4.ext - technology: gf180mcuD

* Black-box entry subcircuit for gf180mcu_fd_sc_mcu7t5v0__fillcap_4 abstract view
.subckt gf180mcu_fd_sc_mcu7t5v0__fillcap_4 VDD VNW VPW VSS
.ends

* Black-box entry subcircuit for gf180mcu_fd_sc_mcu7t5v0__aoi22_1 abstract view
.subckt gf180mcu_fd_sc_mcu7t5v0__aoi22_1 A1 A2 B1 B2 ZN VDD VNW VPW VSS
.ends

* Black-box entry subcircuit for gf180mcu_fd_sc_mcu7t5v0__fillcap_32 abstract view
.subckt gf180mcu_fd_sc_mcu7t5v0__fillcap_32 VDD VNW VPW VSS
.ends

* Black-box entry subcircuit for gf180mcu_fd_sc_mcu7t5v0__clkinv_1 abstract view
.subckt gf180mcu_fd_sc_mcu7t5v0__clkinv_1 I ZN VDD VNW VPW VSS
.ends

* Black-box entry subcircuit for gf180mcu_fd_sc_mcu7t5v0__fillcap_8 abstract view
.subckt gf180mcu_fd_sc_mcu7t5v0__fillcap_8 VDD VNW VPW VSS
.ends

* Black-box entry subcircuit for gf180mcu_fd_sc_mcu7t5v0__filltie abstract view
.subckt gf180mcu_fd_sc_mcu7t5v0__filltie VDD VSS
.ends

* Black-box entry subcircuit for gf180mcu_fd_sc_mcu7t5v0__fillcap_64 abstract view
.subckt gf180mcu_fd_sc_mcu7t5v0__fillcap_64 VDD VNW VPW VSS
.ends

* Black-box entry subcircuit for gf180mcu_fd_sc_mcu7t5v0__fillcap_16 abstract view
.subckt gf180mcu_fd_sc_mcu7t5v0__fillcap_16 VDD VNW VPW VSS
.ends

* Black-box entry subcircuit for gf180mcu_fd_sc_mcu7t5v0__fill_2 abstract view
.subckt gf180mcu_fd_sc_mcu7t5v0__fill_2 VDD VNW VPW VSS
.ends

* Black-box entry subcircuit for gf180mcu_fd_sc_mcu7t5v0__fill_1 abstract view
.subckt gf180mcu_fd_sc_mcu7t5v0__fill_1 VDD VNW VPW VSS
.ends

* Black-box entry subcircuit for gf180mcu_fd_sc_mcu7t5v0__clkbuf_4 abstract view
.subckt gf180mcu_fd_sc_mcu7t5v0__clkbuf_4 I Z VDD VNW VPW VSS
.ends

* Black-box entry subcircuit for gf180mcu_fd_sc_mcu7t5v0__buf_1 abstract view
.subckt gf180mcu_fd_sc_mcu7t5v0__buf_1 I Z VDD VNW VPW VSS
.ends

* Black-box entry subcircuit for gf180mcu_fd_sc_mcu7t5v0__xor3_1 abstract view
.subckt gf180mcu_fd_sc_mcu7t5v0__xor3_1 A1 A2 A3 Z VDD VNW VPW VSS
.ends

* Black-box entry subcircuit for gf180mcu_fd_sc_mcu7t5v0__dffrnq_1 abstract view
.subckt gf180mcu_fd_sc_mcu7t5v0__dffrnq_1 D RN CLK Q VDD VNW VPW VSS
.ends

* Black-box entry subcircuit for gf180mcu_fd_sc_mcu7t5v0__or2_1 abstract view
.subckt gf180mcu_fd_sc_mcu7t5v0__or2_1 A1 A2 Z VDD VNW VPW VSS
.ends

* Black-box entry subcircuit for gf180mcu_fd_sc_mcu7t5v0__nor2_1 abstract view
.subckt gf180mcu_fd_sc_mcu7t5v0__nor2_1 A1 A2 ZN VDD VNW VPW VSS
.ends

* Black-box entry subcircuit for gf180mcu_fd_sc_mcu7t5v0__dlyd_1 abstract view
.subckt gf180mcu_fd_sc_mcu7t5v0__dlyd_1 I Z VDD VNW VPW VSS
.ends

* Black-box entry subcircuit for gf180mcu_fd_sc_mcu7t5v0__nand2_1 abstract view
.subckt gf180mcu_fd_sc_mcu7t5v0__nand2_1 A1 A2 ZN VDD VNW VPW VSS
.ends

* Black-box entry subcircuit for gf180mcu_fd_sc_mcu7t5v0__nand3_1 abstract view
.subckt gf180mcu_fd_sc_mcu7t5v0__nand3_1 A1 A2 A3 ZN VDD VNW VPW VSS
.ends

* Black-box entry subcircuit for gf180mcu_fd_sc_mcu7t5v0__and2_1 abstract view
.subckt gf180mcu_fd_sc_mcu7t5v0__and2_1 A1 A2 Z VDD VNW VPW VSS
.ends

* Black-box entry subcircuit for gf180mcu_fd_sc_mcu7t5v0__endcap abstract view
.subckt gf180mcu_fd_sc_mcu7t5v0__endcap VDD VSS
.ends

* Black-box entry subcircuit for gf180mcu_fd_sc_mcu7t5v0__aoi21_1 abstract view
.subckt gf180mcu_fd_sc_mcu7t5v0__aoi21_1 A1 A2 B ZN VDD VNW VPW VSS
.ends

* Black-box entry subcircuit for gf180mcu_fd_sc_mcu7t5v0__clkbuf_2 abstract view
.subckt gf180mcu_fd_sc_mcu7t5v0__clkbuf_2 I Z VDD VNW VPW VSS
.ends

* Black-box entry subcircuit for gf180mcu_fd_sc_mcu7t5v0__antenna abstract view
.subckt gf180mcu_fd_sc_mcu7t5v0__antenna I VDD VNW VPW VSS
.ends

* Black-box entry subcircuit for gf180mcu_fd_sc_mcu7t5v0__xor2_1 abstract view
.subckt gf180mcu_fd_sc_mcu7t5v0__xor2_1 A1 A2 Z VDD VNW VPW VSS
.ends

* Black-box entry subcircuit for gf180mcu_fd_sc_mcu7t5v0__buf_4 abstract view
.subckt gf180mcu_fd_sc_mcu7t5v0__buf_4 I Z VDD VNW VPW VSS
.ends

* Black-box entry subcircuit for gf180mcu_fd_sc_mcu7t5v0__oai21_1 abstract view
.subckt gf180mcu_fd_sc_mcu7t5v0__oai21_1 A1 A2 B ZN VDD VNW VPW VSS
.ends

* Black-box entry subcircuit for gf180mcu_fd_sc_mcu7t5v0__and3_1 abstract view
.subckt gf180mcu_fd_sc_mcu7t5v0__and3_1 A1 A2 A3 Z VDD VNW VPW VSS
.ends

* Black-box entry subcircuit for gf180mcu_fd_sc_mcu7t5v0__aoi22_2 abstract view
.subckt gf180mcu_fd_sc_mcu7t5v0__aoi22_2 A1 A2 B1 B2 ZN VDD VNW VPW VSS
.ends

* Black-box entry subcircuit for gf180mcu_fd_sc_mcu7t5v0__aoi221_1 abstract view
.subckt gf180mcu_fd_sc_mcu7t5v0__aoi221_1 A1 A2 B1 B2 C ZN VDD VNW VPW VSS
.ends

* Black-box entry subcircuit for gf180mcu_fd_sc_mcu7t5v0__buf_2 abstract view
.subckt gf180mcu_fd_sc_mcu7t5v0__buf_2 I Z VDD VNW VPW VSS
.ends

* Black-box entry subcircuit for gf180mcu_fd_sc_mcu7t5v0__nor3_1 abstract view
.subckt gf180mcu_fd_sc_mcu7t5v0__nor3_1 A1 A2 A3 ZN VDD VNW VPW VSS
.ends

* Black-box entry subcircuit for gf180mcu_fd_sc_mcu7t5v0__xnor2_1 abstract view
.subckt gf180mcu_fd_sc_mcu7t5v0__xnor2_1 A1 A2 ZN VDD VNW VPW VSS
.ends

* Black-box entry subcircuit for gf180mcu_fd_sc_mcu7t5v0__nor4_1 abstract view
.subckt gf180mcu_fd_sc_mcu7t5v0__nor4_1 A1 A2 A3 A4 ZN VDD VNW VPW VSS
.ends

* Black-box entry subcircuit for gf180mcu_fd_sc_mcu7t5v0__xor2_2 abstract view
.subckt gf180mcu_fd_sc_mcu7t5v0__xor2_2 A1 A2 Z VDD VNW VPW VSS
.ends

* Black-box entry subcircuit for gf180mcu_fd_sc_mcu7t5v0__oai211_1 abstract view
.subckt gf180mcu_fd_sc_mcu7t5v0__oai211_1 A1 A2 B C ZN VDD VNW VPW VSS
.ends

* Black-box entry subcircuit for gf180mcu_fd_sc_mcu7t5v0__oai22_1 abstract view
.subckt gf180mcu_fd_sc_mcu7t5v0__oai22_1 A1 A2 B1 B2 ZN VDD VNW VPW VSS
.ends

* Black-box entry subcircuit for gf180mcu_fd_sc_mcu7t5v0__buf_8 abstract view
.subckt gf180mcu_fd_sc_mcu7t5v0__buf_8 I Z VDD VNW VPW VSS
.ends

* Black-box entry subcircuit for gf180mcu_fd_sc_mcu7t5v0__clkbuf_16 abstract view
.subckt gf180mcu_fd_sc_mcu7t5v0__clkbuf_16 I Z VDD VNW VPW VSS
.ends

* Black-box entry subcircuit for gf180mcu_fd_sc_mcu7t5v0__aoi211_1 abstract view
.subckt gf180mcu_fd_sc_mcu7t5v0__aoi211_1 A1 A2 B C ZN VDD VNW VPW VSS
.ends

* Black-box entry subcircuit for gf180mcu_fd_sc_mcu7t5v0__or4_1 abstract view
.subckt gf180mcu_fd_sc_mcu7t5v0__or4_1 A1 A2 A3 A4 Z VDD VNW VPW VSS
.ends

* Black-box entry subcircuit for gf180mcu_fd_sc_mcu7t5v0__buf_3 abstract view
.subckt gf180mcu_fd_sc_mcu7t5v0__buf_3 I Z VDD VNW VPW VSS
.ends

* Black-box entry subcircuit for gf180mcu_fd_sc_mcu7t5v0__inv_3 abstract view
.subckt gf180mcu_fd_sc_mcu7t5v0__inv_3 I ZN VDD VNW VPW VSS
.ends

* Black-box entry subcircuit for gf180mcu_fd_sc_mcu7t5v0__mux2_2 abstract view
.subckt gf180mcu_fd_sc_mcu7t5v0__mux2_2 I0 I1 S Z VDD VNW VPW VSS
.ends

* Black-box entry subcircuit for gf180mcu_fd_sc_mcu7t5v0__dffsnq_1 abstract view
.subckt gf180mcu_fd_sc_mcu7t5v0__dffsnq_1 D SETN CLK Q VDD VNW VPW VSS
.ends

* Black-box entry subcircuit for gf180mcu_fd_sc_mcu7t5v0__inv_4 abstract view
.subckt gf180mcu_fd_sc_mcu7t5v0__inv_4 I ZN VDD VNW VPW VSS
.ends

* Black-box entry subcircuit for gf180mcu_fd_sc_mcu7t5v0__aoi222_1 abstract view
.subckt gf180mcu_fd_sc_mcu7t5v0__aoi222_1 A1 A2 B1 B2 C1 C2 ZN VDD VNW VPW VSS
.ends

* Black-box entry subcircuit for gf180mcu_fd_sc_mcu7t5v0__nand4_1 abstract view
.subckt gf180mcu_fd_sc_mcu7t5v0__nand4_1 A1 A2 A3 A4 ZN VDD VNW VPW VSS
.ends

* Black-box entry subcircuit for gf180mcu_fd_sc_mcu7t5v0__tiel abstract view
.subckt gf180mcu_fd_sc_mcu7t5v0__tiel ZN VDD VNW VPW VSS
.ends

* Black-box entry subcircuit for gf180mcu_fd_sc_mcu7t5v0__inv_2 abstract view
.subckt gf180mcu_fd_sc_mcu7t5v0__inv_2 I ZN VDD VNW VPW VSS
.ends

* Black-box entry subcircuit for gf180mcu_fd_sc_mcu7t5v0__nor2_2 abstract view
.subckt gf180mcu_fd_sc_mcu7t5v0__nor2_2 A1 A2 ZN VDD VNW VPW VSS
.ends

* Black-box entry subcircuit for gf180mcu_fd_sc_mcu7t5v0__clkbuf_8 abstract view
.subckt gf180mcu_fd_sc_mcu7t5v0__clkbuf_8 I Z VDD VNW VPW VSS
.ends

* Black-box entry subcircuit for gf180mcu_fd_sc_mcu7t5v0__oai31_1 abstract view
.subckt gf180mcu_fd_sc_mcu7t5v0__oai31_1 A1 A2 A3 B ZN VDD VNW VPW VSS
.ends

* Black-box entry subcircuit for gf180mcu_fd_sc_mcu7t5v0__aoi221_2 abstract view
.subckt gf180mcu_fd_sc_mcu7t5v0__aoi221_2 A1 A2 B1 B2 C ZN VDD VNW VPW VSS
.ends

* Black-box entry subcircuit for gf180mcu_fd_sc_mcu7t5v0__oai221_1 abstract view
.subckt gf180mcu_fd_sc_mcu7t5v0__oai221_1 A1 A2 B1 B2 C ZN VDD VNW VPW VSS
.ends

* Black-box entry subcircuit for gf180mcu_fd_sc_mcu7t5v0__xnor3_1 abstract view
.subckt gf180mcu_fd_sc_mcu7t5v0__xnor3_1 A1 A2 A3 ZN VDD VNW VPW VSS
.ends

* Black-box entry subcircuit for gf180mcu_fd_sc_mcu7t5v0__nand3_2 abstract view
.subckt gf180mcu_fd_sc_mcu7t5v0__nand3_2 A1 A2 A3 ZN VDD VNW VPW VSS
.ends

* Black-box entry subcircuit for gf180mcu_fd_sc_mcu7t5v0__oai31_2 abstract view
.subckt gf180mcu_fd_sc_mcu7t5v0__oai31_2 A1 A2 A3 B ZN VDD VNW VPW VSS
.ends

* Black-box entry subcircuit for gf180mcu_fd_sc_mcu7t5v0__and4_1 abstract view
.subckt gf180mcu_fd_sc_mcu7t5v0__and4_1 A1 A2 A3 A4 Z VDD VNW VPW VSS
.ends

* Black-box entry subcircuit for gf180mcu_fd_sc_mcu7t5v0__or3_1 abstract view
.subckt gf180mcu_fd_sc_mcu7t5v0__or3_1 A1 A2 A3 Z VDD VNW VPW VSS
.ends

* Black-box entry subcircuit for gf180mcu_fd_sc_mcu7t5v0__nor3_2 abstract view
.subckt gf180mcu_fd_sc_mcu7t5v0__nor3_2 A1 A2 A3 ZN VDD VNW VPW VSS
.ends

.subckt xbar_tlul_2to4 VDD VSS clk_i rst_ni scanmode_i[0] scanmode_i[1] scanmode_i[2]
+ scanmode_i[3] tl_d_dmem_i[0] tl_d_dmem_i[10] tl_d_dmem_i[11] tl_d_dmem_i[12] tl_d_dmem_i[13]
+ tl_d_dmem_i[14] tl_d_dmem_i[15] tl_d_dmem_i[16] tl_d_dmem_i[17] tl_d_dmem_i[18]
+ tl_d_dmem_i[19] tl_d_dmem_i[1] tl_d_dmem_i[20] tl_d_dmem_i[21] tl_d_dmem_i[22] tl_d_dmem_i[23]
+ tl_d_dmem_i[24] tl_d_dmem_i[25] tl_d_dmem_i[26] tl_d_dmem_i[27] tl_d_dmem_i[28]
+ tl_d_dmem_i[29] tl_d_dmem_i[2] tl_d_dmem_i[30] tl_d_dmem_i[31] tl_d_dmem_i[32] tl_d_dmem_i[33]
+ tl_d_dmem_i[34] tl_d_dmem_i[35] tl_d_dmem_i[36] tl_d_dmem_i[37] tl_d_dmem_i[38]
+ tl_d_dmem_i[39] tl_d_dmem_i[3] tl_d_dmem_i[40] tl_d_dmem_i[41] tl_d_dmem_i[42] tl_d_dmem_i[43]
+ tl_d_dmem_i[44] tl_d_dmem_i[45] tl_d_dmem_i[46] tl_d_dmem_i[47] tl_d_dmem_i[48]
+ tl_d_dmem_i[49] tl_d_dmem_i[4] tl_d_dmem_i[50] tl_d_dmem_i[51] tl_d_dmem_i[52] tl_d_dmem_i[53]
+ tl_d_dmem_i[54] tl_d_dmem_i[55] tl_d_dmem_i[56] tl_d_dmem_i[57] tl_d_dmem_i[58]
+ tl_d_dmem_i[59] tl_d_dmem_i[5] tl_d_dmem_i[60] tl_d_dmem_i[61] tl_d_dmem_i[62] tl_d_dmem_i[63]
+ tl_d_dmem_i[64] tl_d_dmem_i[65] tl_d_dmem_i[6] tl_d_dmem_i[7] tl_d_dmem_i[8] tl_d_dmem_i[9]
+ tl_d_dmem_o[0] tl_d_dmem_o[100] tl_d_dmem_o[101] tl_d_dmem_o[102] tl_d_dmem_o[103]
+ tl_d_dmem_o[104] tl_d_dmem_o[105] tl_d_dmem_o[106] tl_d_dmem_o[107] tl_d_dmem_o[108]
+ tl_d_dmem_o[109] tl_d_dmem_o[10] tl_d_dmem_o[110] tl_d_dmem_o[111] tl_d_dmem_o[112]
+ tl_d_dmem_o[113] tl_d_dmem_o[11] tl_d_dmem_o[12] tl_d_dmem_o[13] tl_d_dmem_o[14]
+ tl_d_dmem_o[15] tl_d_dmem_o[16] tl_d_dmem_o[17] tl_d_dmem_o[18] tl_d_dmem_o[19]
+ tl_d_dmem_o[1] tl_d_dmem_o[20] tl_d_dmem_o[21] tl_d_dmem_o[22] tl_d_dmem_o[23] tl_d_dmem_o[24]
+ tl_d_dmem_o[25] tl_d_dmem_o[26] tl_d_dmem_o[27] tl_d_dmem_o[28] tl_d_dmem_o[29]
+ tl_d_dmem_o[2] tl_d_dmem_o[30] tl_d_dmem_o[31] tl_d_dmem_o[32] tl_d_dmem_o[33] tl_d_dmem_o[34]
+ tl_d_dmem_o[35] tl_d_dmem_o[36] tl_d_dmem_o[37] tl_d_dmem_o[38] tl_d_dmem_o[39]
+ tl_d_dmem_o[3] tl_d_dmem_o[40] tl_d_dmem_o[41] tl_d_dmem_o[42] tl_d_dmem_o[43] tl_d_dmem_o[44]
+ tl_d_dmem_o[45] tl_d_dmem_o[46] tl_d_dmem_o[47] tl_d_dmem_o[48] tl_d_dmem_o[49]
+ tl_d_dmem_o[4] tl_d_dmem_o[50] tl_d_dmem_o[51] tl_d_dmem_o[52] tl_d_dmem_o[53] tl_d_dmem_o[54]
+ tl_d_dmem_o[55] tl_d_dmem_o[56] tl_d_dmem_o[57] tl_d_dmem_o[58] tl_d_dmem_o[59]
+ tl_d_dmem_o[5] tl_d_dmem_o[60] tl_d_dmem_o[61] tl_d_dmem_o[62] tl_d_dmem_o[63] tl_d_dmem_o[64]
+ tl_d_dmem_o[65] tl_d_dmem_o[66] tl_d_dmem_o[67] tl_d_dmem_o[68] tl_d_dmem_o[69]
+ tl_d_dmem_o[6] tl_d_dmem_o[70] tl_d_dmem_o[71] tl_d_dmem_o[72] tl_d_dmem_o[73] tl_d_dmem_o[74]
+ tl_d_dmem_o[75] tl_d_dmem_o[76] tl_d_dmem_o[77] tl_d_dmem_o[78] tl_d_dmem_o[79]
+ tl_d_dmem_o[7] tl_d_dmem_o[80] tl_d_dmem_o[81] tl_d_dmem_o[82] tl_d_dmem_o[83] tl_d_dmem_o[84]
+ tl_d_dmem_o[85] tl_d_dmem_o[86] tl_d_dmem_o[87] tl_d_dmem_o[88] tl_d_dmem_o[89]
+ tl_d_dmem_o[8] tl_d_dmem_o[90] tl_d_dmem_o[91] tl_d_dmem_o[92] tl_d_dmem_o[93] tl_d_dmem_o[94]
+ tl_d_dmem_o[95] tl_d_dmem_o[96] tl_d_dmem_o[97] tl_d_dmem_o[98] tl_d_dmem_o[99]
+ tl_d_dmem_o[9] tl_d_esram_i[0] tl_d_esram_i[10] tl_d_esram_i[11] tl_d_esram_i[12]
+ tl_d_esram_i[13] tl_d_esram_i[14] tl_d_esram_i[15] tl_d_esram_i[16] tl_d_esram_i[17]
+ tl_d_esram_i[18] tl_d_esram_i[19] tl_d_esram_i[1] tl_d_esram_i[20] tl_d_esram_i[21]
+ tl_d_esram_i[22] tl_d_esram_i[23] tl_d_esram_i[24] tl_d_esram_i[25] tl_d_esram_i[26]
+ tl_d_esram_i[27] tl_d_esram_i[28] tl_d_esram_i[29] tl_d_esram_i[2] tl_d_esram_i[30]
+ tl_d_esram_i[31] tl_d_esram_i[32] tl_d_esram_i[33] tl_d_esram_i[34] tl_d_esram_i[35]
+ tl_d_esram_i[36] tl_d_esram_i[37] tl_d_esram_i[38] tl_d_esram_i[39] tl_d_esram_i[3]
+ tl_d_esram_i[40] tl_d_esram_i[41] tl_d_esram_i[42] tl_d_esram_i[43] tl_d_esram_i[44]
+ tl_d_esram_i[45] tl_d_esram_i[46] tl_d_esram_i[47] tl_d_esram_i[48] tl_d_esram_i[49]
+ tl_d_esram_i[4] tl_d_esram_i[50] tl_d_esram_i[51] tl_d_esram_i[52] tl_d_esram_i[53]
+ tl_d_esram_i[54] tl_d_esram_i[55] tl_d_esram_i[56] tl_d_esram_i[57] tl_d_esram_i[58]
+ tl_d_esram_i[59] tl_d_esram_i[5] tl_d_esram_i[60] tl_d_esram_i[61] tl_d_esram_i[62]
+ tl_d_esram_i[63] tl_d_esram_i[64] tl_d_esram_i[65] tl_d_esram_i[6] tl_d_esram_i[7]
+ tl_d_esram_i[8] tl_d_esram_i[9] tl_d_esram_o[0] tl_d_esram_o[100] tl_d_esram_o[101]
+ tl_d_esram_o[102] tl_d_esram_o[103] tl_d_esram_o[104] tl_d_esram_o[105] tl_d_esram_o[106]
+ tl_d_esram_o[107] tl_d_esram_o[108] tl_d_esram_o[109] tl_d_esram_o[10] tl_d_esram_o[110]
+ tl_d_esram_o[111] tl_d_esram_o[112] tl_d_esram_o[113] tl_d_esram_o[11] tl_d_esram_o[12]
+ tl_d_esram_o[13] tl_d_esram_o[14] tl_d_esram_o[15] tl_d_esram_o[16] tl_d_esram_o[17]
+ tl_d_esram_o[18] tl_d_esram_o[19] tl_d_esram_o[1] tl_d_esram_o[20] tl_d_esram_o[21]
+ tl_d_esram_o[22] tl_d_esram_o[23] tl_d_esram_o[24] tl_d_esram_o[25] tl_d_esram_o[26]
+ tl_d_esram_o[27] tl_d_esram_o[28] tl_d_esram_o[29] tl_d_esram_o[2] tl_d_esram_o[30]
+ tl_d_esram_o[31] tl_d_esram_o[32] tl_d_esram_o[33] tl_d_esram_o[34] tl_d_esram_o[35]
+ tl_d_esram_o[36] tl_d_esram_o[37] tl_d_esram_o[38] tl_d_esram_o[39] tl_d_esram_o[3]
+ tl_d_esram_o[40] tl_d_esram_o[41] tl_d_esram_o[42] tl_d_esram_o[43] tl_d_esram_o[44]
+ tl_d_esram_o[45] tl_d_esram_o[46] tl_d_esram_o[47] tl_d_esram_o[48] tl_d_esram_o[49]
+ tl_d_esram_o[4] tl_d_esram_o[50] tl_d_esram_o[51] tl_d_esram_o[52] tl_d_esram_o[53]
+ tl_d_esram_o[54] tl_d_esram_o[55] tl_d_esram_o[56] tl_d_esram_o[57] tl_d_esram_o[58]
+ tl_d_esram_o[59] tl_d_esram_o[5] tl_d_esram_o[60] tl_d_esram_o[61] tl_d_esram_o[62]
+ tl_d_esram_o[63] tl_d_esram_o[64] tl_d_esram_o[65] tl_d_esram_o[66] tl_d_esram_o[67]
+ tl_d_esram_o[68] tl_d_esram_o[69] tl_d_esram_o[6] tl_d_esram_o[70] tl_d_esram_o[71]
+ tl_d_esram_o[72] tl_d_esram_o[73] tl_d_esram_o[74] tl_d_esram_o[75] tl_d_esram_o[76]
+ tl_d_esram_o[77] tl_d_esram_o[78] tl_d_esram_o[79] tl_d_esram_o[7] tl_d_esram_o[80]
+ tl_d_esram_o[81] tl_d_esram_o[82] tl_d_esram_o[83] tl_d_esram_o[84] tl_d_esram_o[85]
+ tl_d_esram_o[86] tl_d_esram_o[87] tl_d_esram_o[88] tl_d_esram_o[89] tl_d_esram_o[8]
+ tl_d_esram_o[90] tl_d_esram_o[91] tl_d_esram_o[92] tl_d_esram_o[93] tl_d_esram_o[94]
+ tl_d_esram_o[95] tl_d_esram_o[96] tl_d_esram_o[97] tl_d_esram_o[98] tl_d_esram_o[99]
+ tl_d_esram_o[9] tl_d_rom_i[0] tl_d_rom_i[10] tl_d_rom_i[11] tl_d_rom_i[12] tl_d_rom_i[13]
+ tl_d_rom_i[14] tl_d_rom_i[15] tl_d_rom_i[16] tl_d_rom_i[17] tl_d_rom_i[18] tl_d_rom_i[19]
+ tl_d_rom_i[1] tl_d_rom_i[20] tl_d_rom_i[21] tl_d_rom_i[22] tl_d_rom_i[23] tl_d_rom_i[24]
+ tl_d_rom_i[25] tl_d_rom_i[26] tl_d_rom_i[27] tl_d_rom_i[28] tl_d_rom_i[29] tl_d_rom_i[2]
+ tl_d_rom_i[30] tl_d_rom_i[31] tl_d_rom_i[32] tl_d_rom_i[33] tl_d_rom_i[34] tl_d_rom_i[35]
+ tl_d_rom_i[36] tl_d_rom_i[37] tl_d_rom_i[38] tl_d_rom_i[39] tl_d_rom_i[3] tl_d_rom_i[40]
+ tl_d_rom_i[41] tl_d_rom_i[42] tl_d_rom_i[43] tl_d_rom_i[44] tl_d_rom_i[45] tl_d_rom_i[46]
+ tl_d_rom_i[47] tl_d_rom_i[48] tl_d_rom_i[49] tl_d_rom_i[4] tl_d_rom_i[50] tl_d_rom_i[51]
+ tl_d_rom_i[52] tl_d_rom_i[53] tl_d_rom_i[54] tl_d_rom_i[55] tl_d_rom_i[56] tl_d_rom_i[57]
+ tl_d_rom_i[58] tl_d_rom_i[59] tl_d_rom_i[5] tl_d_rom_i[60] tl_d_rom_i[61] tl_d_rom_i[62]
+ tl_d_rom_i[63] tl_d_rom_i[64] tl_d_rom_i[65] tl_d_rom_i[6] tl_d_rom_i[7] tl_d_rom_i[8]
+ tl_d_rom_i[9] tl_d_rom_o[0] tl_d_rom_o[100] tl_d_rom_o[101] tl_d_rom_o[102] tl_d_rom_o[103]
+ tl_d_rom_o[104] tl_d_rom_o[105] tl_d_rom_o[106] tl_d_rom_o[107] tl_d_rom_o[108]
+ tl_d_rom_o[109] tl_d_rom_o[10] tl_d_rom_o[110] tl_d_rom_o[111] tl_d_rom_o[112] tl_d_rom_o[113]
+ tl_d_rom_o[11] tl_d_rom_o[12] tl_d_rom_o[13] tl_d_rom_o[14] tl_d_rom_o[15] tl_d_rom_o[16]
+ tl_d_rom_o[17] tl_d_rom_o[18] tl_d_rom_o[19] tl_d_rom_o[1] tl_d_rom_o[20] tl_d_rom_o[21]
+ tl_d_rom_o[22] tl_d_rom_o[23] tl_d_rom_o[24] tl_d_rom_o[25] tl_d_rom_o[26] tl_d_rom_o[27]
+ tl_d_rom_o[28] tl_d_rom_o[29] tl_d_rom_o[2] tl_d_rom_o[30] tl_d_rom_o[31] tl_d_rom_o[32]
+ tl_d_rom_o[33] tl_d_rom_o[34] tl_d_rom_o[35] tl_d_rom_o[36] tl_d_rom_o[37] tl_d_rom_o[38]
+ tl_d_rom_o[39] tl_d_rom_o[3] tl_d_rom_o[40] tl_d_rom_o[41] tl_d_rom_o[42] tl_d_rom_o[43]
+ tl_d_rom_o[44] tl_d_rom_o[45] tl_d_rom_o[46] tl_d_rom_o[47] tl_d_rom_o[48] tl_d_rom_o[49]
+ tl_d_rom_o[4] tl_d_rom_o[50] tl_d_rom_o[51] tl_d_rom_o[52] tl_d_rom_o[53] tl_d_rom_o[54]
+ tl_d_rom_o[55] tl_d_rom_o[56] tl_d_rom_o[57] tl_d_rom_o[58] tl_d_rom_o[59] tl_d_rom_o[5]
+ tl_d_rom_o[60] tl_d_rom_o[61] tl_d_rom_o[62] tl_d_rom_o[63] tl_d_rom_o[64] tl_d_rom_o[65]
+ tl_d_rom_o[66] tl_d_rom_o[67] tl_d_rom_o[68] tl_d_rom_o[69] tl_d_rom_o[6] tl_d_rom_o[70]
+ tl_d_rom_o[71] tl_d_rom_o[72] tl_d_rom_o[73] tl_d_rom_o[74] tl_d_rom_o[75] tl_d_rom_o[76]
+ tl_d_rom_o[77] tl_d_rom_o[78] tl_d_rom_o[79] tl_d_rom_o[7] tl_d_rom_o[80] tl_d_rom_o[81]
+ tl_d_rom_o[82] tl_d_rom_o[83] tl_d_rom_o[84] tl_d_rom_o[85] tl_d_rom_o[86] tl_d_rom_o[87]
+ tl_d_rom_o[88] tl_d_rom_o[89] tl_d_rom_o[8] tl_d_rom_o[90] tl_d_rom_o[91] tl_d_rom_o[92]
+ tl_d_rom_o[93] tl_d_rom_o[94] tl_d_rom_o[95] tl_d_rom_o[96] tl_d_rom_o[97] tl_d_rom_o[98]
+ tl_d_rom_o[99] tl_d_rom_o[9] tl_d_uart_i[0] tl_d_uart_i[10] tl_d_uart_i[11] tl_d_uart_i[12]
+ tl_d_uart_i[13] tl_d_uart_i[14] tl_d_uart_i[15] tl_d_uart_i[16] tl_d_uart_i[17]
+ tl_d_uart_i[18] tl_d_uart_i[19] tl_d_uart_i[1] tl_d_uart_i[20] tl_d_uart_i[21] tl_d_uart_i[22]
+ tl_d_uart_i[23] tl_d_uart_i[24] tl_d_uart_i[25] tl_d_uart_i[26] tl_d_uart_i[27]
+ tl_d_uart_i[28] tl_d_uart_i[29] tl_d_uart_i[2] tl_d_uart_i[30] tl_d_uart_i[31] tl_d_uart_i[32]
+ tl_d_uart_i[33] tl_d_uart_i[34] tl_d_uart_i[35] tl_d_uart_i[36] tl_d_uart_i[37]
+ tl_d_uart_i[38] tl_d_uart_i[39] tl_d_uart_i[3] tl_d_uart_i[40] tl_d_uart_i[41] tl_d_uart_i[42]
+ tl_d_uart_i[43] tl_d_uart_i[44] tl_d_uart_i[45] tl_d_uart_i[46] tl_d_uart_i[47]
+ tl_d_uart_i[48] tl_d_uart_i[49] tl_d_uart_i[4] tl_d_uart_i[50] tl_d_uart_i[51] tl_d_uart_i[52]
+ tl_d_uart_i[53] tl_d_uart_i[54] tl_d_uart_i[55] tl_d_uart_i[56] tl_d_uart_i[57]
+ tl_d_uart_i[58] tl_d_uart_i[59] tl_d_uart_i[5] tl_d_uart_i[60] tl_d_uart_i[61] tl_d_uart_i[62]
+ tl_d_uart_i[63] tl_d_uart_i[64] tl_d_uart_i[65] tl_d_uart_i[6] tl_d_uart_i[7] tl_d_uart_i[8]
+ tl_d_uart_i[9] tl_d_uart_o[0] tl_d_uart_o[100] tl_d_uart_o[101] tl_d_uart_o[102]
+ tl_d_uart_o[103] tl_d_uart_o[104] tl_d_uart_o[105] tl_d_uart_o[106] tl_d_uart_o[107]
+ tl_d_uart_o[108] tl_d_uart_o[109] tl_d_uart_o[10] tl_d_uart_o[110] tl_d_uart_o[111]
+ tl_d_uart_o[112] tl_d_uart_o[113] tl_d_uart_o[11] tl_d_uart_o[12] tl_d_uart_o[13]
+ tl_d_uart_o[14] tl_d_uart_o[15] tl_d_uart_o[16] tl_d_uart_o[17] tl_d_uart_o[18]
+ tl_d_uart_o[19] tl_d_uart_o[1] tl_d_uart_o[20] tl_d_uart_o[21] tl_d_uart_o[22] tl_d_uart_o[23]
+ tl_d_uart_o[24] tl_d_uart_o[25] tl_d_uart_o[26] tl_d_uart_o[27] tl_d_uart_o[28]
+ tl_d_uart_o[29] tl_d_uart_o[2] tl_d_uart_o[30] tl_d_uart_o[31] tl_d_uart_o[32] tl_d_uart_o[33]
+ tl_d_uart_o[34] tl_d_uart_o[35] tl_d_uart_o[36] tl_d_uart_o[37] tl_d_uart_o[38]
+ tl_d_uart_o[39] tl_d_uart_o[3] tl_d_uart_o[40] tl_d_uart_o[41] tl_d_uart_o[42] tl_d_uart_o[43]
+ tl_d_uart_o[44] tl_d_uart_o[45] tl_d_uart_o[46] tl_d_uart_o[47] tl_d_uart_o[48]
+ tl_d_uart_o[49] tl_d_uart_o[4] tl_d_uart_o[50] tl_d_uart_o[51] tl_d_uart_o[52] tl_d_uart_o[53]
+ tl_d_uart_o[54] tl_d_uart_o[55] tl_d_uart_o[56] tl_d_uart_o[57] tl_d_uart_o[58]
+ tl_d_uart_o[59] tl_d_uart_o[5] tl_d_uart_o[60] tl_d_uart_o[61] tl_d_uart_o[62] tl_d_uart_o[63]
+ tl_d_uart_o[64] tl_d_uart_o[65] tl_d_uart_o[66] tl_d_uart_o[67] tl_d_uart_o[68]
+ tl_d_uart_o[69] tl_d_uart_o[6] tl_d_uart_o[70] tl_d_uart_o[71] tl_d_uart_o[72] tl_d_uart_o[73]
+ tl_d_uart_o[74] tl_d_uart_o[75] tl_d_uart_o[76] tl_d_uart_o[77] tl_d_uart_o[78]
+ tl_d_uart_o[79] tl_d_uart_o[7] tl_d_uart_o[80] tl_d_uart_o[81] tl_d_uart_o[82] tl_d_uart_o[83]
+ tl_d_uart_o[84] tl_d_uart_o[85] tl_d_uart_o[86] tl_d_uart_o[87] tl_d_uart_o[88]
+ tl_d_uart_o[89] tl_d_uart_o[8] tl_d_uart_o[90] tl_d_uart_o[91] tl_d_uart_o[92] tl_d_uart_o[93]
+ tl_d_uart_o[94] tl_d_uart_o[95] tl_d_uart_o[96] tl_d_uart_o[97] tl_d_uart_o[98]
+ tl_d_uart_o[99] tl_d_uart_o[9] tl_h_d_i[0] tl_h_d_i[100] tl_h_d_i[101] tl_h_d_i[102]
+ tl_h_d_i[103] tl_h_d_i[104] tl_h_d_i[105] tl_h_d_i[106] tl_h_d_i[107] tl_h_d_i[108]
+ tl_h_d_i[109] tl_h_d_i[10] tl_h_d_i[110] tl_h_d_i[111] tl_h_d_i[112] tl_h_d_i[113]
+ tl_h_d_i[11] tl_h_d_i[12] tl_h_d_i[13] tl_h_d_i[14] tl_h_d_i[15] tl_h_d_i[16] tl_h_d_i[17]
+ tl_h_d_i[18] tl_h_d_i[19] tl_h_d_i[1] tl_h_d_i[20] tl_h_d_i[21] tl_h_d_i[22] tl_h_d_i[23]
+ tl_h_d_i[24] tl_h_d_i[25] tl_h_d_i[26] tl_h_d_i[27] tl_h_d_i[28] tl_h_d_i[29] tl_h_d_i[2]
+ tl_h_d_i[30] tl_h_d_i[31] tl_h_d_i[32] tl_h_d_i[33] tl_h_d_i[34] tl_h_d_i[35] tl_h_d_i[36]
+ tl_h_d_i[37] tl_h_d_i[38] tl_h_d_i[39] tl_h_d_i[3] tl_h_d_i[40] tl_h_d_i[41] tl_h_d_i[42]
+ tl_h_d_i[43] tl_h_d_i[44] tl_h_d_i[45] tl_h_d_i[46] tl_h_d_i[47] tl_h_d_i[48] tl_h_d_i[49]
+ tl_h_d_i[4] tl_h_d_i[50] tl_h_d_i[51] tl_h_d_i[52] tl_h_d_i[53] tl_h_d_i[54] tl_h_d_i[55]
+ tl_h_d_i[56] tl_h_d_i[57] tl_h_d_i[58] tl_h_d_i[59] tl_h_d_i[5] tl_h_d_i[60] tl_h_d_i[61]
+ tl_h_d_i[62] tl_h_d_i[63] tl_h_d_i[64] tl_h_d_i[65] tl_h_d_i[66] tl_h_d_i[67] tl_h_d_i[68]
+ tl_h_d_i[69] tl_h_d_i[6] tl_h_d_i[70] tl_h_d_i[71] tl_h_d_i[72] tl_h_d_i[73] tl_h_d_i[74]
+ tl_h_d_i[75] tl_h_d_i[76] tl_h_d_i[77] tl_h_d_i[78] tl_h_d_i[79] tl_h_d_i[7] tl_h_d_i[80]
+ tl_h_d_i[81] tl_h_d_i[82] tl_h_d_i[83] tl_h_d_i[84] tl_h_d_i[85] tl_h_d_i[86] tl_h_d_i[87]
+ tl_h_d_i[88] tl_h_d_i[89] tl_h_d_i[8] tl_h_d_i[90] tl_h_d_i[91] tl_h_d_i[92] tl_h_d_i[93]
+ tl_h_d_i[94] tl_h_d_i[95] tl_h_d_i[96] tl_h_d_i[97] tl_h_d_i[98] tl_h_d_i[99] tl_h_d_i[9]
+ tl_h_d_o[0] tl_h_d_o[10] tl_h_d_o[11] tl_h_d_o[12] tl_h_d_o[13] tl_h_d_o[14] tl_h_d_o[15]
+ tl_h_d_o[16] tl_h_d_o[17] tl_h_d_o[18] tl_h_d_o[19] tl_h_d_o[1] tl_h_d_o[20] tl_h_d_o[21]
+ tl_h_d_o[22] tl_h_d_o[23] tl_h_d_o[24] tl_h_d_o[25] tl_h_d_o[26] tl_h_d_o[27] tl_h_d_o[28]
+ tl_h_d_o[29] tl_h_d_o[2] tl_h_d_o[30] tl_h_d_o[31] tl_h_d_o[32] tl_h_d_o[33] tl_h_d_o[34]
+ tl_h_d_o[35] tl_h_d_o[36] tl_h_d_o[37] tl_h_d_o[38] tl_h_d_o[39] tl_h_d_o[3] tl_h_d_o[40]
+ tl_h_d_o[41] tl_h_d_o[42] tl_h_d_o[43] tl_h_d_o[44] tl_h_d_o[45] tl_h_d_o[46] tl_h_d_o[47]
+ tl_h_d_o[48] tl_h_d_o[49] tl_h_d_o[4] tl_h_d_o[50] tl_h_d_o[51] tl_h_d_o[52] tl_h_d_o[53]
+ tl_h_d_o[54] tl_h_d_o[55] tl_h_d_o[56] tl_h_d_o[57] tl_h_d_o[58] tl_h_d_o[59] tl_h_d_o[5]
+ tl_h_d_o[60] tl_h_d_o[61] tl_h_d_o[62] tl_h_d_o[63] tl_h_d_o[64] tl_h_d_o[65] tl_h_d_o[6]
+ tl_h_d_o[7] tl_h_d_o[8] tl_h_d_o[9] tl_h_i_i[0] tl_h_i_i[100] tl_h_i_i[101] tl_h_i_i[102]
+ tl_h_i_i[103] tl_h_i_i[104] tl_h_i_i[105] tl_h_i_i[106] tl_h_i_i[107] tl_h_i_i[108]
+ tl_h_i_i[109] tl_h_i_i[10] tl_h_i_i[110] tl_h_i_i[111] tl_h_i_i[112] tl_h_i_i[113]
+ tl_h_i_i[11] tl_h_i_i[12] tl_h_i_i[13] tl_h_i_i[14] tl_h_i_i[15] tl_h_i_i[16] tl_h_i_i[17]
+ tl_h_i_i[18] tl_h_i_i[19] tl_h_i_i[1] tl_h_i_i[20] tl_h_i_i[21] tl_h_i_i[22] tl_h_i_i[23]
+ tl_h_i_i[24] tl_h_i_i[25] tl_h_i_i[26] tl_h_i_i[27] tl_h_i_i[28] tl_h_i_i[29] tl_h_i_i[2]
+ tl_h_i_i[30] tl_h_i_i[31] tl_h_i_i[32] tl_h_i_i[33] tl_h_i_i[34] tl_h_i_i[35] tl_h_i_i[36]
+ tl_h_i_i[37] tl_h_i_i[38] tl_h_i_i[39] tl_h_i_i[3] tl_h_i_i[40] tl_h_i_i[41] tl_h_i_i[42]
+ tl_h_i_i[43] tl_h_i_i[44] tl_h_i_i[45] tl_h_i_i[46] tl_h_i_i[47] tl_h_i_i[48] tl_h_i_i[49]
+ tl_h_i_i[4] tl_h_i_i[50] tl_h_i_i[51] tl_h_i_i[52] tl_h_i_i[53] tl_h_i_i[54] tl_h_i_i[55]
+ tl_h_i_i[56] tl_h_i_i[57] tl_h_i_i[58] tl_h_i_i[59] tl_h_i_i[5] tl_h_i_i[60] tl_h_i_i[61]
+ tl_h_i_i[62] tl_h_i_i[63] tl_h_i_i[64] tl_h_i_i[65] tl_h_i_i[66] tl_h_i_i[67] tl_h_i_i[68]
+ tl_h_i_i[69] tl_h_i_i[6] tl_h_i_i[70] tl_h_i_i[71] tl_h_i_i[72] tl_h_i_i[73] tl_h_i_i[74]
+ tl_h_i_i[75] tl_h_i_i[76] tl_h_i_i[77] tl_h_i_i[78] tl_h_i_i[79] tl_h_i_i[7] tl_h_i_i[80]
+ tl_h_i_i[81] tl_h_i_i[82] tl_h_i_i[83] tl_h_i_i[84] tl_h_i_i[85] tl_h_i_i[86] tl_h_i_i[87]
+ tl_h_i_i[88] tl_h_i_i[89] tl_h_i_i[8] tl_h_i_i[90] tl_h_i_i[91] tl_h_i_i[92] tl_h_i_i[93]
+ tl_h_i_i[94] tl_h_i_i[95] tl_h_i_i[96] tl_h_i_i[97] tl_h_i_i[98] tl_h_i_i[99] tl_h_i_i[9]
+ tl_h_i_o[0] tl_h_i_o[10] tl_h_i_o[11] tl_h_i_o[12] tl_h_i_o[13] tl_h_i_o[14] tl_h_i_o[15]
+ tl_h_i_o[16] tl_h_i_o[17] tl_h_i_o[18] tl_h_i_o[19] tl_h_i_o[1] tl_h_i_o[20] tl_h_i_o[21]
+ tl_h_i_o[22] tl_h_i_o[23] tl_h_i_o[24] tl_h_i_o[25] tl_h_i_o[26] tl_h_i_o[27] tl_h_i_o[28]
+ tl_h_i_o[29] tl_h_i_o[2] tl_h_i_o[30] tl_h_i_o[31] tl_h_i_o[32] tl_h_i_o[33] tl_h_i_o[34]
+ tl_h_i_o[35] tl_h_i_o[36] tl_h_i_o[37] tl_h_i_o[38] tl_h_i_o[39] tl_h_i_o[3] tl_h_i_o[40]
+ tl_h_i_o[41] tl_h_i_o[42] tl_h_i_o[43] tl_h_i_o[44] tl_h_i_o[45] tl_h_i_o[46] tl_h_i_o[47]
+ tl_h_i_o[48] tl_h_i_o[49] tl_h_i_o[4] tl_h_i_o[50] tl_h_i_o[51] tl_h_i_o[52] tl_h_i_o[53]
+ tl_h_i_o[54] tl_h_i_o[55] tl_h_i_o[56] tl_h_i_o[57] tl_h_i_o[58] tl_h_i_o[59] tl_h_i_o[5]
+ tl_h_i_o[60] tl_h_i_o[61] tl_h_i_o[62] tl_h_i_o[63] tl_h_i_o[64] tl_h_i_o[65] tl_h_i_o[6]
+ tl_h_i_o[7] tl_h_i_o[8] tl_h_i_o[9]
XFILLER_54_225 VDD VDD VSS VSS gf180mcu_fd_sc_mcu7t5v0__fillcap_4
X_2106_ _2238_/B2 _2315_/A2 _2369_/A1 _2238_/A1 _2107_/I VDD VDD VSS VSS gf180mcu_fd_sc_mcu7t5v0__aoi22_1
XFILLER_54_247 VDD VDD VSS VSS gf180mcu_fd_sc_mcu7t5v0__fillcap_32
X_2037_ _2037_/I _2037_/ZN VDD VDD VSS VSS gf180mcu_fd_sc_mcu7t5v0__clkinv_1
XFILLER_52_18 VDD VDD VSS VSS gf180mcu_fd_sc_mcu7t5v0__fillcap_8
XTAP_TAPCELL_ROW_81_1226 VDD VSS gf180mcu_fd_sc_mcu7t5v0__filltie
XFILLER_10_317 VDD VDD VSS VSS gf180mcu_fd_sc_mcu7t5v0__fillcap_64
XTAP_TAPCELL_ROW_33_651 VDD VSS gf180mcu_fd_sc_mcu7t5v0__filltie
XTAP_TAPCELL_ROW_61_993 VDD VSS gf180mcu_fd_sc_mcu7t5v0__filltie
XTAP_TAPCELL_ROW_79_1199 VDD VSS gf180mcu_fd_sc_mcu7t5v0__filltie
XTAP_TAPCELL_ROW_92_1366 VDD VSS gf180mcu_fd_sc_mcu7t5v0__filltie
XTAP_TAPCELL_ROW_92_1355 VDD VSS gf180mcu_fd_sc_mcu7t5v0__filltie
XFILLER_78_807 VDD VDD VSS VSS gf180mcu_fd_sc_mcu7t5v0__fillcap_16
XFILLER_104_477 VDD VDD VSS VSS gf180mcu_fd_sc_mcu7t5v0__fill_2
XTAP_TAPCELL_ROW_5_321 VDD VSS gf180mcu_fd_sc_mcu7t5v0__filltie
XFILLER_46_715 VDD VDD VSS VSS gf180mcu_fd_sc_mcu7t5v0__fillcap_8
XFILLER_46_737 VDD VDD VSS VSS gf180mcu_fd_sc_mcu7t5v0__fillcap_64
XFILLER_58_597 VDD VDD VSS VSS gf180mcu_fd_sc_mcu7t5v0__fillcap_16
XFILLER_26_461 VDD VDD VSS VSS gf180mcu_fd_sc_mcu7t5v0__fill_1
XFILLER_14_667 VDD VDD VSS VSS gf180mcu_fd_sc_mcu7t5v0__fillcap_64
XTAP_TAPCELL_ROW_101_1473 VDD VSS gf180mcu_fd_sc_mcu7t5v0__filltie
XTAP_TAPCELL_ROW_11_389 VDD VSS gf180mcu_fd_sc_mcu7t5v0__filltie
XFILLER_68_317 VDD VDD VSS VSS gf180mcu_fd_sc_mcu7t5v0__fillcap_4
XFILLER_68_328 VDD VDD VSS VSS gf180mcu_fd_sc_mcu7t5v0__fillcap_8
XFILLER_49_531 VDD VDD VSS VSS gf180mcu_fd_sc_mcu7t5v0__fill_1
X_1270_ _1270_/A1 _1406_/A2 _1270_/B1 _2146_/C _1271_/A2 VDD VDD VSS VSS gf180mcu_fd_sc_mcu7t5v0__aoi22_1
XFILLER_36_214 VDD VDD VSS VSS gf180mcu_fd_sc_mcu7t5v0__fill_1
XFILLER_64_567 VDD VDD VSS VSS gf180mcu_fd_sc_mcu7t5v0__fill_2
Xload_slew1081 _2394_/S _2402_/S VDD VDD VSS VSS gf180mcu_fd_sc_mcu7t5v0__clkbuf_4
Xload_slew1092 _1722_/A2 _1720_/A2 VDD VDD VSS VSS gf180mcu_fd_sc_mcu7t5v0__clkbuf_4
XTAP_TAPCELL_ROW_19_489 VDD VSS gf180mcu_fd_sc_mcu7t5v0__filltie
XFILLER_91_364 VDD VDD VSS VSS gf180mcu_fd_sc_mcu7t5v0__fill_2
XTAP_TAPCELL_ROW_30_621 VDD VSS gf180mcu_fd_sc_mcu7t5v0__filltie
XFILLER_80_2 VDD VDD VSS VSS gf180mcu_fd_sc_mcu7t5v0__fill_1
XFILLER_9_671 VDD VDD VSS VSS gf180mcu_fd_sc_mcu7t5v0__fillcap_4
X_2724_ _2724_/I _2724_/Z VDD VDD VSS VSS gf180mcu_fd_sc_mcu7t5v0__buf_1
XFILLER_9_682 VDD VDD VSS VSS gf180mcu_fd_sc_mcu7t5v0__fill_2
X_2655_ _2727_/I _2655_/Z VDD VDD VSS VSS gf180mcu_fd_sc_mcu7t5v0__buf_1
X_1606_ _2745_/I _2747_/I _1604_/Z _1606_/Z VDD VDD VSS VSS gf180mcu_fd_sc_mcu7t5v0__xor3_1
X_2586_ _2586_/D _2586_/RN clkload4/I _2586_/Q VDD VDD VSS VSS gf180mcu_fd_sc_mcu7t5v0__dffrnq_1
X_1537_ _1962_/B2 _1619_/S _1537_/Z VDD VDD VSS VSS gf180mcu_fd_sc_mcu7t5v0__or2_1
XFILLER_99_486 VDD VDD VSS VSS gf180mcu_fd_sc_mcu7t5v0__fillcap_4
XFILLER_59_339 VDD VDD VSS VSS gf180mcu_fd_sc_mcu7t5v0__fill_1
X_1468_ input38/Z _1468_/A2 _1468_/B1 _1508_/B2 _1469_/I VDD VDD VSS VSS gf180mcu_fd_sc_mcu7t5v0__aoi22_1
X_1399_ _1399_/A1 _1399_/A2 _1399_/ZN VDD VDD VSS VSS gf180mcu_fd_sc_mcu7t5v0__nor2_1
XFILLER_28_737 VDD VDD VSS VSS gf180mcu_fd_sc_mcu7t5v0__fillcap_32
XFILLER_67_372 VDD VDD VSS VSS gf180mcu_fd_sc_mcu7t5v0__fill_1
XTAP_TAPCELL_ROW_38_710 VDD VSS gf180mcu_fd_sc_mcu7t5v0__filltie
XFILLER_55_578 VDD VDD VSS VSS gf180mcu_fd_sc_mcu7t5v0__fillcap_8
XFILLER_70_548 VDD VDD VSS VSS gf180mcu_fd_sc_mcu7t5v0__fillcap_16
XFILLER_11_626 VDD VDD VSS VSS gf180mcu_fd_sc_mcu7t5v0__fillcap_4
XFILLER_11_648 VDD VDD VSS VSS gf180mcu_fd_sc_mcu7t5v0__fill_2
XFILLER_23_486 VDD VDD VSS VSS gf180mcu_fd_sc_mcu7t5v0__fillcap_4
XFILLER_12_10 VDD VDD VSS VSS gf180mcu_fd_sc_mcu7t5v0__fill_2
XFILLER_3_858 VDD VDD VSS VSS gf180mcu_fd_sc_mcu7t5v0__fillcap_8
XFILLER_104_263 VDD VDD VSS VSS gf180mcu_fd_sc_mcu7t5v0__fill_1
Xoutput990 _2077_/ZN tl_h_i_o[14] VDD VDD VSS VSS gf180mcu_fd_sc_mcu7t5v0__dlyd_1
XFILLER_93_629 VDD VDD VSS VSS gf180mcu_fd_sc_mcu7t5v0__fill_1
XFILLER_77_158 VDD VDD VSS VSS gf180mcu_fd_sc_mcu7t5v0__fillcap_4
XFILLER_58_372 VDD VDD VSS VSS gf180mcu_fd_sc_mcu7t5v0__fillcap_8
XFILLER_100_491 VDD VDD VSS VSS gf180mcu_fd_sc_mcu7t5v0__fill_2
XFILLER_18_247 VDD VDD VSS VSS gf180mcu_fd_sc_mcu7t5v0__fillcap_16
XFILLER_46_556 VDD VDD VSS VSS gf180mcu_fd_sc_mcu7t5v0__fillcap_32
XFILLER_18_269 VDD VDD VSS VSS gf180mcu_fd_sc_mcu7t5v0__fillcap_32
XTAP_TAPCELL_ROW_16_448 VDD VSS gf180mcu_fd_sc_mcu7t5v0__filltie
XTAP_TAPCELL_ROW_44_779 VDD VSS gf180mcu_fd_sc_mcu7t5v0__filltie
X_2440_ _2564_/Q _2440_/A2 _2442_/A3 VDD VDD VSS VSS gf180mcu_fd_sc_mcu7t5v0__nand2_1
XTAP_TAPCELL_ROW_114_1620 VDD VSS gf180mcu_fd_sc_mcu7t5v0__filltie
X_2371_ _2371_/A1 _2371_/A2 _2375_/A3 _2372_/A2 VDD VDD VSS VSS gf180mcu_fd_sc_mcu7t5v0__nand3_1
X_1322_ input84/Z _1418_/A2 _2311_/A3 _1323_/B VDD VDD VSS VSS gf180mcu_fd_sc_mcu7t5v0__nand3_1
X_1253_ _1393_/A1 _2249_/A2 _1253_/Z VDD VDD VSS VSS gf180mcu_fd_sc_mcu7t5v0__and2_1
X_1184_ _1158_/Z _2534_/A2 _1184_/ZN VDD VDD VSS VSS gf180mcu_fd_sc_mcu7t5v0__nor2_1
XFILLER_91_183 VDD VDD VSS VSS gf180mcu_fd_sc_mcu7t5v0__fill_1
X_2707_ _2707_/I _2707_/Z VDD VDD VSS VSS gf180mcu_fd_sc_mcu7t5v0__buf_1
X_2638_ _2710_/I _2638_/Z VDD VDD VSS VSS gf180mcu_fd_sc_mcu7t5v0__buf_1
XTAP_TAPCELL_ROW_76_1169 VDD VSS gf180mcu_fd_sc_mcu7t5v0__filltie
XFILLER_0_806 VDD VDD VSS VSS gf180mcu_fd_sc_mcu7t5v0__fillcap_8
XFILLER_58_28 VDD VDD VSS VSS gf180mcu_fd_sc_mcu7t5v0__fill_1
X_2569_ _2569_/D _2594_/RN clkload6/I _2569_/Q VDD VDD VSS VSS gf180mcu_fd_sc_mcu7t5v0__dffrnq_1
XFILLER_87_412 VDD VDD VSS VSS gf180mcu_fd_sc_mcu7t5v0__fillcap_8
XFILLER_87_489 VDD VDD VSS VSS gf180mcu_fd_sc_mcu7t5v0__fill_1
XFILLER_83_684 VDD VDD VSS VSS gf180mcu_fd_sc_mcu7t5v0__fill_2
XTAP_TAPCELL_ROW_87_1298 VDD VSS gf180mcu_fd_sc_mcu7t5v0__filltie
XFILLER_70_345 VDD VDD VSS VSS gf180mcu_fd_sc_mcu7t5v0__fill_2
XTAP_TAPCELL_ROW_41_749 VDD VSS gf180mcu_fd_sc_mcu7t5v0__filltie
XTAP_TAPCELL_ROW_13_418 VDD VSS gf180mcu_fd_sc_mcu7t5v0__filltie
XTAP_TAPCELL_ROW_13_407 VDD VSS gf180mcu_fd_sc_mcu7t5v0__filltie
XFILLER_78_401 VDD VDD VSS VSS gf180mcu_fd_sc_mcu7t5v0__fillcap_32
XTAP_TAPCELL_ROW_49_849 VDD VSS gf180mcu_fd_sc_mcu7t5v0__filltie
XFILLER_78_489 VDD VDD VSS VSS gf180mcu_fd_sc_mcu7t5v0__fillcap_8
XFILLER_19_556 VDD VDD VSS VSS gf180mcu_fd_sc_mcu7t5v0__fillcap_4
XFILLER_64_71 VDD VDD VSS VSS gf180mcu_fd_sc_mcu7t5v0__fillcap_4
XPHY_EDGE_ROW_14_Left_133 VDD VSS gf180mcu_fd_sc_mcu7t5v0__endcap
X_1940_ _1940_/A1 _1976_/A2 _1958_/B1 _1940_/B2 _1941_/I VDD VDD VSS VSS gf180mcu_fd_sc_mcu7t5v0__aoi22_1
X_1871_ _1871_/I _1871_/ZN VDD VDD VSS VSS gf180mcu_fd_sc_mcu7t5v0__clkinv_1
XPHY_EDGE_ROW_104_Right_104 VDD VSS gf180mcu_fd_sc_mcu7t5v0__endcap
XPHY_EDGE_ROW_23_Left_142 VDD VSS gf180mcu_fd_sc_mcu7t5v0__endcap
X_2423_ _2423_/A1 _2434_/A3 _2429_/A2 VDD VDD VSS VSS gf180mcu_fd_sc_mcu7t5v0__nand2_1
X_2354_ _2378_/A1 _2354_/A2 _2356_/A1 VDD VDD VSS VSS gf180mcu_fd_sc_mcu7t5v0__nand2_1
X_1305_ _1393_/A1 _2277_/A2 _1305_/Z VDD VDD VSS VSS gf180mcu_fd_sc_mcu7t5v0__and2_1
XFILLER_57_629 VDD VDD VSS VSS gf180mcu_fd_sc_mcu7t5v0__fill_1
X_2285_ _2333_/A1 _2285_/A2 _2286_/A2 VDD VDD VSS VSS gf180mcu_fd_sc_mcu7t5v0__nand2_1
X_1236_ _1248_/A1 _2231_/C _1247_/A2 VDD VDD VSS VSS gf180mcu_fd_sc_mcu7t5v0__nand2_1
X_1167_ _1167_/A1 _1167_/A2 _1167_/A3 _1173_/A2 VDD VDD VSS VSS gf180mcu_fd_sc_mcu7t5v0__nand3_1
XPHY_EDGE_ROW_32_Left_151 VDD VSS gf180mcu_fd_sc_mcu7t5v0__endcap
X_1098_ _1098_/I _2198_/A1 VDD VDD VSS VSS gf180mcu_fd_sc_mcu7t5v0__clkinv_1
XPHY_EDGE_ROW_41_Left_160 VDD VSS gf180mcu_fd_sc_mcu7t5v0__endcap
XFILLER_88_710 VDD VDD VSS VSS gf180mcu_fd_sc_mcu7t5v0__fillcap_16
XFILLER_79_209 VDD VDD VSS VSS gf180mcu_fd_sc_mcu7t5v0__fill_1
XFILLER_102_531 VDD VDD VSS VSS gf180mcu_fd_sc_mcu7t5v0__fill_1
XFILLER_87_253 VDD VDD VSS VSS gf180mcu_fd_sc_mcu7t5v0__fillcap_4
XTAP_TAPCELL_ROW_89_1327 VDD VSS gf180mcu_fd_sc_mcu7t5v0__filltie
XFILLER_75_437 VDD VDD VSS VSS gf180mcu_fd_sc_mcu7t5v0__fill_2
XFILLER_47_139 VDD VDD VSS VSS gf180mcu_fd_sc_mcu7t5v0__fill_1
XTAP_TAPCELL_ROW_46_808 VDD VSS gf180mcu_fd_sc_mcu7t5v0__filltie
XFILLER_90_429 VDD VDD VSS VSS gf180mcu_fd_sc_mcu7t5v0__fill_1
XFILLER_71_610 VDD VDD VSS VSS gf180mcu_fd_sc_mcu7t5v0__fillcap_8
XFILLER_55_172 VDD VDD VSS VSS gf180mcu_fd_sc_mcu7t5v0__fillcap_32
XFILLER_83_492 VDD VDD VSS VSS gf180mcu_fd_sc_mcu7t5v0__fillcap_4
XFILLER_71_632 VDD VDD VSS VSS gf180mcu_fd_sc_mcu7t5v0__fillcap_32
XFILLER_71_676 VDD VDD VSS VSS gf180mcu_fd_sc_mcu7t5v0__fill_1
XFILLER_70_131 VDD VDD VSS VSS gf180mcu_fd_sc_mcu7t5v0__fillcap_8
XTAP_TAPCELL_ROW_26_565 VDD VSS gf180mcu_fd_sc_mcu7t5v0__filltie
XFILLER_98_518 VDD VDD VSS VSS gf180mcu_fd_sc_mcu7t5v0__fillcap_4
XFILLER_78_242 VDD VDD VSS VSS gf180mcu_fd_sc_mcu7t5v0__fill_2
X_2070_ _2070_/I _2070_/ZN VDD VDD VSS VSS gf180mcu_fd_sc_mcu7t5v0__clkinv_1
XTAP_TAPCELL_ROW_109_1563 VDD VSS gf180mcu_fd_sc_mcu7t5v0__filltie
XFILLER_62_621 VDD VDD VSS VSS gf180mcu_fd_sc_mcu7t5v0__fill_1
XFILLER_61_142 VDD VDD VSS VSS gf180mcu_fd_sc_mcu7t5v0__fillcap_16
X_1923_ _1923_/I _1923_/ZN VDD VDD VSS VSS gf180mcu_fd_sc_mcu7t5v0__clkinv_1
X_1854_ _2391_/I0 _1854_/A2 _1854_/B1 _2771_/I _1855_/I VDD VDD VSS VSS gf180mcu_fd_sc_mcu7t5v0__aoi22_1
X_1785_ _1785_/I _1785_/ZN VDD VDD VSS VSS gf180mcu_fd_sc_mcu7t5v0__clkinv_1
XTAP_TAPCELL_ROW_73_1128 VDD VSS gf180mcu_fd_sc_mcu7t5v0__filltie
X_2406_ _2560_/Q _2434_/B _2406_/Z VDD VDD VSS VSS gf180mcu_fd_sc_mcu7t5v0__and2_1
XFILLER_97_562 VDD VDD VSS VSS gf180mcu_fd_sc_mcu7t5v0__fillcap_32
XFILLER_97_540 VDD VDD VSS VSS gf180mcu_fd_sc_mcu7t5v0__fillcap_4
XFILLER_85_702 VDD VDD VSS VSS gf180mcu_fd_sc_mcu7t5v0__fillcap_64
X_2337_ _2373_/A1 _2337_/A2 _2338_/A2 VDD VDD VSS VSS gf180mcu_fd_sc_mcu7t5v0__nand2_1
X_2268_ _2268_/A1 _2268_/A2 _2296_/B _2268_/ZN VDD VDD VSS VSS gf180mcu_fd_sc_mcu7t5v0__aoi21_1
X_1219_ _1219_/A1 _1221_/A2 _1535_/A2 VDD VDD VSS VSS gf180mcu_fd_sc_mcu7t5v0__nand2_1
XFILLER_72_429 VDD VDD VSS VSS gf180mcu_fd_sc_mcu7t5v0__fillcap_16
XFILLER_53_632 VDD VDD VSS VSS gf180mcu_fd_sc_mcu7t5v0__fillcap_16
XFILLER_65_470 VDD VDD VSS VSS gf180mcu_fd_sc_mcu7t5v0__fillcap_4
X_2199_ _2199_/A1 _2199_/A2 _2201_/A2 VDD VDD VSS VSS gf180mcu_fd_sc_mcu7t5v0__nand2_1
XFILLER_52_120 VDD VDD VSS VSS gf180mcu_fd_sc_mcu7t5v0__fillcap_8
XTAP_TAPCELL_ROW_84_1268 VDD VSS gf180mcu_fd_sc_mcu7t5v0__filltie
XFILLER_80_451 VDD VDD VSS VSS gf180mcu_fd_sc_mcu7t5v0__fillcap_4
XTAP_TAPCELL_ROW_23_535 VDD VSS gf180mcu_fd_sc_mcu7t5v0__filltie
XFILLER_21_562 VDD VDD VSS VSS gf180mcu_fd_sc_mcu7t5v0__fillcap_64
XTAP_TAPCELL_ROW_51_866 VDD VSS gf180mcu_fd_sc_mcu7t5v0__filltie
XTAP_TAPCELL_ROW_95_1397 VDD VSS gf180mcu_fd_sc_mcu7t5v0__filltie
XFILLER_0_444 VDD VDD VSS VSS gf180mcu_fd_sc_mcu7t5v0__fill_1
Xinput301 tl_h_d_i[29] _1912_/B2 VDD VDD VSS VSS gf180mcu_fd_sc_mcu7t5v0__dlyd_1
Xinput312 tl_h_d_i[39] _1932_/B2 VDD VDD VSS VSS gf180mcu_fd_sc_mcu7t5v0__dlyd_1
XFILLER_76_702 VDD VDD VSS VSS gf180mcu_fd_sc_mcu7t5v0__fillcap_16
Xinput323 tl_h_d_i[49] _1952_/B2 VDD VDD VSS VSS gf180mcu_fd_sc_mcu7t5v0__dlyd_1
Xinput334 tl_h_d_i[59] _1972_/B2 VDD VDD VSS VSS gf180mcu_fd_sc_mcu7t5v0__dlyd_1
Xinput345 tl_h_d_i[69] _2728_/I VDD VDD VSS VSS gf180mcu_fd_sc_mcu7t5v0__clkbuf_2
XFILLER_75_212 VDD VDD VSS VSS gf180mcu_fd_sc_mcu7t5v0__fillcap_64
Xinput356 tl_h_d_i[79] _2738_/I VDD VDD VSS VSS gf180mcu_fd_sc_mcu7t5v0__clkbuf_2
Xinput367 tl_h_d_i[89] _2748_/I VDD VDD VSS VSS gf180mcu_fd_sc_mcu7t5v0__clkbuf_2
Xinput378 tl_h_d_i[99] _2758_/I VDD VDD VSS VSS gf180mcu_fd_sc_mcu7t5v0__dlyd_1
Xinput389 tl_h_i_i[108] _2036_/A1 VDD VDD VSS VSS gf180mcu_fd_sc_mcu7t5v0__dlyd_1
XTAP_TAPCELL_ROW_59_966 VDD VSS gf180mcu_fd_sc_mcu7t5v0__filltie
XFILLER_91_716 VDD VDD VSS VSS gf180mcu_fd_sc_mcu7t5v0__fillcap_16
XFILLER_17_846 VDD VDD VSS VSS gf180mcu_fd_sc_mcu7t5v0__fill_1
XFILLER_28_172 VDD VDD VSS VSS gf180mcu_fd_sc_mcu7t5v0__fill_2
XTAP_TAPCELL_ROW_3_293 VDD VSS gf180mcu_fd_sc_mcu7t5v0__filltie
XFILLER_90_226 VDD VDD VSS VSS gf180mcu_fd_sc_mcu7t5v0__fillcap_16
XFILLER_43_142 VDD VDD VSS VSS gf180mcu_fd_sc_mcu7t5v0__fillcap_8
XFILLER_44_643 VDD VDD VSS VSS gf180mcu_fd_sc_mcu7t5v0__fillcap_16
XANTENNA_5 _1319_/ZN VDD VDD VSS VSS gf180mcu_fd_sc_mcu7t5v0__antenna
Xoutput808 _2761_/Z tl_d_uart_o[102] VDD VDD VSS VSS gf180mcu_fd_sc_mcu7t5v0__dlyd_1
X_1570_ _2736_/I _1567_/Z _1569_/Z _1570_/Z VDD VDD VSS VSS gf180mcu_fd_sc_mcu7t5v0__xor3_1
Xoutput819 _2771_/Z tl_d_uart_o[112] VDD VDD VSS VSS gf180mcu_fd_sc_mcu7t5v0__dlyd_1
XFILLER_98_337 VDD VDD VSS VSS gf180mcu_fd_sc_mcu7t5v0__fill_1
XFILLER_39_415 VDD VDD VSS VSS gf180mcu_fd_sc_mcu7t5v0__fill_1
XFILLER_67_702 VDD VDD VSS VSS gf180mcu_fd_sc_mcu7t5v0__fillcap_64
XFILLER_79_562 VDD VDD VSS VSS gf180mcu_fd_sc_mcu7t5v0__fillcap_8
Xfanout1061 _2014_/B1 _1952_/B1 VDD VDD VSS VSS gf180mcu_fd_sc_mcu7t5v0__dlyd_1
Xfanout1072 _1183_/ZN _1938_/A2 VDD VDD VSS VSS gf180mcu_fd_sc_mcu7t5v0__dlyd_1
X_2122_ _2122_/A1 _2171_/B _2125_/B VDD VDD VSS VSS gf180mcu_fd_sc_mcu7t5v0__nand2_1
XFILLER_54_418 VDD VDD VSS VSS gf180mcu_fd_sc_mcu7t5v0__fillcap_4
Xfanout1094 _1830_/A2 _1826_/A2 VDD VDD VSS VSS gf180mcu_fd_sc_mcu7t5v0__dlyd_1
XFILLER_35_632 VDD VDD VSS VSS gf180mcu_fd_sc_mcu7t5v0__fillcap_64
XFILLER_47_492 VDD VDD VSS VSS gf180mcu_fd_sc_mcu7t5v0__fillcap_8
X_2053_ _2053_/I _2053_/ZN VDD VDD VSS VSS gf180mcu_fd_sc_mcu7t5v0__clkinv_1
XFILLER_22_304 VDD VDD VSS VSS gf180mcu_fd_sc_mcu7t5v0__fillcap_8
XFILLER_50_613 VDD VDD VSS VSS gf180mcu_fd_sc_mcu7t5v0__fillcap_32
XFILLER_34_186 VDD VDD VSS VSS gf180mcu_fd_sc_mcu7t5v0__fill_2
X_1906_ _1906_/A1 _1914_/A2 _1930_/B1 _2717_/I _1907_/I VDD VDD VSS VSS gf180mcu_fd_sc_mcu7t5v0__aoi22_1
X_1837_ _1837_/I _1837_/ZN VDD VDD VSS VSS gf180mcu_fd_sc_mcu7t5v0__clkinv_1
X_1768_ _1958_/A1 _1768_/A2 _1768_/B1 _1958_/B2 _1769_/I VDD VDD VSS VSS gf180mcu_fd_sc_mcu7t5v0__aoi22_1
X_1699_ _1699_/I _1699_/ZN VDD VDD VSS VSS gf180mcu_fd_sc_mcu7t5v0__clkinv_1
XFILLER_57_212 VDD VDD VSS VSS gf180mcu_fd_sc_mcu7t5v0__fillcap_8
XTAP_TAPCELL_ROW_56_925 VDD VSS gf180mcu_fd_sc_mcu7t5v0__filltie
XTAP_TAPCELL_ROW_0_252 VDD VSS gf180mcu_fd_sc_mcu7t5v0__filltie
XTAP_TAPCELL_ROW_0_241 VDD VSS gf180mcu_fd_sc_mcu7t5v0__filltie
XFILLER_41_602 VDD VDD VSS VSS gf180mcu_fd_sc_mcu7t5v0__fill_2
XFILLER_80_270 VDD VDD VSS VSS gf180mcu_fd_sc_mcu7t5v0__fillcap_4
XFILLER_13_348 VDD VDD VSS VSS gf180mcu_fd_sc_mcu7t5v0__fill_2
XTAP_TAPCELL_ROW_36_693 VDD VSS gf180mcu_fd_sc_mcu7t5v0__filltie
XTAP_TAPCELL_ROW_97_1415 VDD VSS gf180mcu_fd_sc_mcu7t5v0__filltie
XTAP_TAPCELL_ROW_97_1426 VDD VSS gf180mcu_fd_sc_mcu7t5v0__filltie
XFILLER_110_2 VDD VDD VSS VSS gf180mcu_fd_sc_mcu7t5v0__fill_1
XTAP_TAPCELL_ROW_8_352 VDD VSS gf180mcu_fd_sc_mcu7t5v0__filltie
XFILLER_49_702 VDD VDD VSS VSS gf180mcu_fd_sc_mcu7t5v0__fillcap_64
Xinput120 tl_d_esram_i[57] _1088_/I VDD VDD VSS VSS gf180mcu_fd_sc_mcu7t5v0__dlyd_1
XFILLER_88_370 VDD VDD VSS VSS gf180mcu_fd_sc_mcu7t5v0__fillcap_8
XFILLER_0_274 VDD VDD VSS VSS gf180mcu_fd_sc_mcu7t5v0__fillcap_32
Xinput131 tl_d_esram_i[7] _2133_/B2 VDD VDD VSS VSS gf180mcu_fd_sc_mcu7t5v0__dlyd_1
Xinput142 tl_d_rom_i[17] _1264_/A1 VDD VDD VSS VSS gf180mcu_fd_sc_mcu7t5v0__dlyd_1
Xinput153 tl_d_rom_i[27] _1344_/A1 VDD VDD VSS VSS gf180mcu_fd_sc_mcu7t5v0__dlyd_1
Xinput164 tl_d_rom_i[37] _1424_/A1 VDD VDD VSS VSS gf180mcu_fd_sc_mcu7t5v0__dlyd_1
Xinput175 tl_d_rom_i[47] _1504_/A1 VDD VDD VSS VSS gf180mcu_fd_sc_mcu7t5v0__dlyd_1
Xinput186 tl_d_rom_i[57] _2227_/A1 VDD VDD VSS VSS gf180mcu_fd_sc_mcu7t5v0__dlyd_1
XFILLER_17_632 VDD VDD VSS VSS gf180mcu_fd_sc_mcu7t5v0__fillcap_64
Xinput197 tl_d_rom_i[7] _2133_/A1 VDD VDD VSS VSS gf180mcu_fd_sc_mcu7t5v0__dlyd_1
XFILLER_91_546 VDD VDD VSS VSS gf180mcu_fd_sc_mcu7t5v0__fillcap_8
XFILLER_29_492 VDD VDD VSS VSS gf180mcu_fd_sc_mcu7t5v0__fillcap_64
XTAP_TAPCELL_ROW_106_1533 VDD VSS gf180mcu_fd_sc_mcu7t5v0__filltie
XFILLER_12_381 VDD VDD VSS VSS gf180mcu_fd_sc_mcu7t5v0__fillcap_4
X_2740_ _2740_/I _2740_/Z VDD VDD VSS VSS gf180mcu_fd_sc_mcu7t5v0__buf_1
XFILLER_9_842 VDD VDD VSS VSS gf180mcu_fd_sc_mcu7t5v0__fillcap_4
X_2671_ _2743_/I _2671_/Z VDD VDD VSS VSS gf180mcu_fd_sc_mcu7t5v0__buf_1
X_1622_ _1916_/B2 _1664_/S _1622_/Z VDD VDD VSS VSS gf180mcu_fd_sc_mcu7t5v0__or2_1
Xoutput605 _2685_/Z tl_d_dmem_o[98] VDD VDD VSS VSS gf180mcu_fd_sc_mcu7t5v0__dlyd_1
Xoutput616 _2035_/ZN tl_d_esram_o[107] VDD VDD VSS VSS gf180mcu_fd_sc_mcu7t5v0__dlyd_1
Xoutput627 _1883_/ZN tl_d_esram_o[14] VDD VDD VSS VSS gf180mcu_fd_sc_mcu7t5v0__dlyd_1
XTAP_TAPCELL_ROW_117_1662 VDD VSS gf180mcu_fd_sc_mcu7t5v0__filltie
Xoutput638 _1903_/ZN tl_d_esram_o[24] VDD VDD VSS VSS gf180mcu_fd_sc_mcu7t5v0__dlyd_1
Xoutput649 _1923_/ZN tl_d_esram_o[34] VDD VDD VSS VSS gf180mcu_fd_sc_mcu7t5v0__dlyd_1
X_1553_ _1551_/Z _1552_/Z _1553_/Z VDD VDD VSS VSS gf180mcu_fd_sc_mcu7t5v0__xor2_1
X_1484_ input40/Z _1500_/A2 _1484_/B1 _2247_/A2 _1485_/I VDD VDD VSS VSS gf180mcu_fd_sc_mcu7t5v0__aoi22_1
XFILLER_39_212 VDD VDD VSS VSS gf180mcu_fd_sc_mcu7t5v0__fillcap_16
XFILLER_39_278 VDD VDD VSS VSS gf180mcu_fd_sc_mcu7t5v0__fill_2
X_2105_ _2105_/A1 _2105_/A2 _2105_/ZN VDD VDD VSS VSS gf180mcu_fd_sc_mcu7t5v0__nand2_1
XPHY_EDGE_ROW_6_Left_125 VDD VSS gf180mcu_fd_sc_mcu7t5v0__endcap
XFILLER_94_373 VDD VDD VSS VSS gf180mcu_fd_sc_mcu7t5v0__fillcap_4
XFILLER_82_524 VDD VDD VSS VSS gf180mcu_fd_sc_mcu7t5v0__fill_1
X_2036_ _2036_/A1 _2044_/A2 _2038_/B1 _2767_/I _2037_/I VDD VDD VSS VSS gf180mcu_fd_sc_mcu7t5v0__aoi22_1
XTAP_TAPCELL_ROW_81_1227 VDD VSS gf180mcu_fd_sc_mcu7t5v0__filltie
XTAP_TAPCELL_ROW_33_652 VDD VSS gf180mcu_fd_sc_mcu7t5v0__filltie
XTAP_TAPCELL_ROW_61_994 VDD VSS gf180mcu_fd_sc_mcu7t5v0__filltie
XTAP_TAPCELL_ROW_61_983 VDD VSS gf180mcu_fd_sc_mcu7t5v0__filltie
XTAP_TAPCELL_ROW_92_1356 VDD VSS gf180mcu_fd_sc_mcu7t5v0__filltie
XTAP_TAPCELL_ROW_5_322 VDD VSS gf180mcu_fd_sc_mcu7t5v0__filltie
XTAP_TAPCELL_ROW_5_311 VDD VSS gf180mcu_fd_sc_mcu7t5v0__filltie
XFILLER_58_543 VDD VDD VSS VSS gf180mcu_fd_sc_mcu7t5v0__fillcap_4
XFILLER_73_524 VDD VDD VSS VSS gf180mcu_fd_sc_mcu7t5v0__fillcap_4
XFILLER_26_451 VDD VDD VSS VSS gf180mcu_fd_sc_mcu7t5v0__fillcap_4
XFILLER_41_443 VDD VDD VSS VSS gf180mcu_fd_sc_mcu7t5v0__fillcap_16
XTAP_TAPCELL_ROW_101_1474 VDD VSS gf180mcu_fd_sc_mcu7t5v0__filltie
XTAP_TAPCELL_ROW_101_1463 VDD VSS gf180mcu_fd_sc_mcu7t5v0__filltie
XFILLER_6_823 VDD VDD VSS VSS gf180mcu_fd_sc_mcu7t5v0__fillcap_8
XFILLER_96_616 VDD VDD VSS VSS gf180mcu_fd_sc_mcu7t5v0__fill_2
XFILLER_96_605 VDD VDD VSS VSS gf180mcu_fd_sc_mcu7t5v0__fill_2
XPHY_EDGE_ROW_79_Left_198 VDD VSS gf180mcu_fd_sc_mcu7t5v0__endcap
XFILLER_64_524 VDD VDD VSS VSS gf180mcu_fd_sc_mcu7t5v0__fill_1
XFILLER_76_384 VDD VDD VSS VSS gf180mcu_fd_sc_mcu7t5v0__fill_1
XFILLER_76_362 VDD VDD VSS VSS gf180mcu_fd_sc_mcu7t5v0__fill_2
Xload_slew1071 _1912_/A2 _1900_/A2 VDD VDD VSS VSS gf180mcu_fd_sc_mcu7t5v0__buf_4
Xload_slew1082 _2398_/S _2394_/S VDD VDD VSS VSS gf180mcu_fd_sc_mcu7t5v0__clkbuf_4
XTAP_TAPCELL_ROW_67_1060 VDD VSS gf180mcu_fd_sc_mcu7t5v0__filltie
XTAP_TAPCELL_ROW_19_479 VDD VSS gf180mcu_fd_sc_mcu7t5v0__filltie
XFILLER_32_454 VDD VDD VSS VSS gf180mcu_fd_sc_mcu7t5v0__fill_1
XTAP_TAPCELL_ROW_30_622 VDD VSS gf180mcu_fd_sc_mcu7t5v0__filltie
XTAP_TAPCELL_ROW_30_611 VDD VSS gf180mcu_fd_sc_mcu7t5v0__filltie
X_2723_ _2723_/I _2723_/Z VDD VDD VSS VSS gf180mcu_fd_sc_mcu7t5v0__buf_1
X_2654_ _2726_/I _2654_/Z VDD VDD VSS VSS gf180mcu_fd_sc_mcu7t5v0__buf_1
X_2585_ _2585_/D _2587_/RN clkload4/I _2585_/Q VDD VDD VSS VSS gf180mcu_fd_sc_mcu7t5v0__dffrnq_1
X_1605_ _2727_/I _2729_/I _2731_/I _1605_/Z VDD VDD VSS VSS gf180mcu_fd_sc_mcu7t5v0__xor3_1
X_1536_ _1960_/B2 _1619_/S _1536_/Z VDD VDD VSS VSS gf180mcu_fd_sc_mcu7t5v0__or2_1
XFILLER_87_627 VDD VDD VSS VSS gf180mcu_fd_sc_mcu7t5v0__fill_2
X_1467_ _1467_/A1 _1465_/Z _1467_/B _1468_/B1 VDD VDD VSS VSS gf180mcu_fd_sc_mcu7t5v0__oai21_1
XFILLER_67_340 VDD VDD VSS VSS gf180mcu_fd_sc_mcu7t5v0__fillcap_8
X_1398_ _1398_/A1 _1398_/A2 _1398_/B1 _2160_/C _1399_/A2 VDD VDD VSS VSS gf180mcu_fd_sc_mcu7t5v0__aoi22_1
XTAP_TAPCELL_ROW_38_711 VDD VSS gf180mcu_fd_sc_mcu7t5v0__filltie
XPHY_EDGE_ROW_118_Right_118 VDD VSS gf180mcu_fd_sc_mcu7t5v0__endcap
XFILLER_82_387 VDD VDD VSS VSS gf180mcu_fd_sc_mcu7t5v0__fillcap_16
XFILLER_82_365 VDD VDD VSS VSS gf180mcu_fd_sc_mcu7t5v0__fill_2
XFILLER_70_527 VDD VDD VSS VSS gf180mcu_fd_sc_mcu7t5v0__fillcap_4
X_2019_ _2019_/I _2019_/ZN VDD VDD VSS VSS gf180mcu_fd_sc_mcu7t5v0__clkinv_1
XFILLER_23_454 VDD VDD VSS VSS gf180mcu_fd_sc_mcu7t5v0__fillcap_4
XFILLER_109_559 VDD VDD VSS VSS gf180mcu_fd_sc_mcu7t5v0__fill_1
XFILLER_88_26 VDD VDD VSS VSS gf180mcu_fd_sc_mcu7t5v0__fill_1
Xoutput980 _2774_/Z tl_h_d_o[65] VDD VDD VSS VSS gf180mcu_fd_sc_mcu7t5v0__dlyd_1
Xoutput991 _2079_/ZN tl_h_i_o[15] VDD VDD VSS VSS gf180mcu_fd_sc_mcu7t5v0__dlyd_1
XFILLER_78_605 VDD VDD VSS VSS gf180mcu_fd_sc_mcu7t5v0__fill_2
XFILLER_77_137 VDD VDD VSS VSS gf180mcu_fd_sc_mcu7t5v0__fill_2
XFILLER_59_852 VDD VDD VSS VSS gf180mcu_fd_sc_mcu7t5v0__fillcap_4
XFILLER_58_384 VDD VDD VSS VSS gf180mcu_fd_sc_mcu7t5v0__fill_1
XFILLER_86_693 VDD VDD VSS VSS gf180mcu_fd_sc_mcu7t5v0__fillcap_32
XTAP_TAPCELL_ROW_16_449 VDD VSS gf180mcu_fd_sc_mcu7t5v0__filltie
XTAP_TAPCELL_ROW_114_1621 VDD VSS gf180mcu_fd_sc_mcu7t5v0__filltie
XFILLER_68_104 VDD VDD VSS VSS gf180mcu_fd_sc_mcu7t5v0__fill_1
X_2370_ _2374_/A1 _2370_/A2 _2372_/A1 VDD VDD VSS VSS gf180mcu_fd_sc_mcu7t5v0__nand2_1
XPHY_EDGE_ROW_87_Left_206 VDD VSS gf180mcu_fd_sc_mcu7t5v0__endcap
X_1321_ _1441_/A1 _2285_/A2 _1321_/Z VDD VDD VSS VSS gf180mcu_fd_sc_mcu7t5v0__and2_1
XFILLER_96_446 VDD VDD VSS VSS gf180mcu_fd_sc_mcu7t5v0__fill_2
XFILLER_96_435 VDD VDD VSS VSS gf180mcu_fd_sc_mcu7t5v0__fillcap_4
X_1252_ _1252_/A1 _1368_/A2 _2249_/A2 VDD VDD VSS VSS gf180mcu_fd_sc_mcu7t5v0__nand2_1
XFILLER_96_457 VDD VDD VSS VSS gf180mcu_fd_sc_mcu7t5v0__fillcap_8
XFILLER_37_524 VDD VDD VSS VSS gf180mcu_fd_sc_mcu7t5v0__fillcap_8
XFILLER_37_557 VDD VDD VSS VSS gf180mcu_fd_sc_mcu7t5v0__fill_2
X_1183_ _1183_/A1 _2538_/A2 _1183_/ZN VDD VDD VSS VSS gf180mcu_fd_sc_mcu7t5v0__nor2_1
XFILLER_52_527 VDD VDD VSS VSS gf180mcu_fd_sc_mcu7t5v0__fillcap_64
XFILLER_64_365 VDD VDD VSS VSS gf180mcu_fd_sc_mcu7t5v0__fillcap_8
XFILLER_92_663 VDD VDD VSS VSS gf180mcu_fd_sc_mcu7t5v0__fill_2
XPHY_EDGE_ROW_96_Left_215 VDD VSS gf180mcu_fd_sc_mcu7t5v0__endcap
XFILLER_20_435 VDD VDD VSS VSS gf180mcu_fd_sc_mcu7t5v0__fillcap_16
XFILLER_20_457 VDD VDD VSS VSS gf180mcu_fd_sc_mcu7t5v0__fillcap_64
X_2706_ _2706_/I _2706_/Z VDD VDD VSS VSS gf180mcu_fd_sc_mcu7t5v0__buf_1
X_2637_ _2709_/I _2637_/Z VDD VDD VSS VSS gf180mcu_fd_sc_mcu7t5v0__buf_1
XPHY_EDGE_ROW_12_Right_12 VDD VSS gf180mcu_fd_sc_mcu7t5v0__endcap
XFILLER_0_818 VDD VDD VSS VSS gf180mcu_fd_sc_mcu7t5v0__fillcap_32
XFILLER_58_18 VDD VDD VSS VSS gf180mcu_fd_sc_mcu7t5v0__fillcap_8
X_2568_ _2568_/D _2594_/RN clkload6/I _2568_/Q VDD VDD VSS VSS gf180mcu_fd_sc_mcu7t5v0__dffrnq_1
XFILLER_59_137 VDD VDD VSS VSS gf180mcu_fd_sc_mcu7t5v0__fill_2
X_2499_ _2499_/A1 _2504_/A3 _2499_/Z VDD VDD VSS VSS gf180mcu_fd_sc_mcu7t5v0__xor2_1
X_1519_ _1926_/B2 _1533_/A2 _1519_/Z VDD VDD VSS VSS gf180mcu_fd_sc_mcu7t5v0__or2_1
XFILLER_99_295 VDD VDD VSS VSS gf180mcu_fd_sc_mcu7t5v0__fill_1
XFILLER_28_524 VDD VDD VSS VSS gf180mcu_fd_sc_mcu7t5v0__fill_1
XFILLER_55_343 VDD VDD VSS VSS gf180mcu_fd_sc_mcu7t5v0__fillcap_4
XPHY_EDGE_ROW_21_Right_21 VDD VSS gf180mcu_fd_sc_mcu7t5v0__endcap
XTAP_TAPCELL_ROW_87_1299 VDD VSS gf180mcu_fd_sc_mcu7t5v0__filltie
XFILLER_71_858 VDD VDD VSS VSS gf180mcu_fd_sc_mcu7t5v0__fillcap_8
XTAP_TAPCELL_ROW_13_408 VDD VSS gf180mcu_fd_sc_mcu7t5v0__filltie
XPHY_EDGE_ROW_30_Right_30 VDD VSS gf180mcu_fd_sc_mcu7t5v0__endcap
XFILLER_66_619 VDD VDD VSS VSS gf180mcu_fd_sc_mcu7t5v0__fill_1
XFILLER_78_457 VDD VDD VSS VSS gf180mcu_fd_sc_mcu7t5v0__fillcap_32
XTAP_TAPCELL_ROW_49_839 VDD VSS gf180mcu_fd_sc_mcu7t5v0__filltie
XFILLER_47_844 VDD VDD VSS VSS gf180mcu_fd_sc_mcu7t5v0__fillcap_16
XFILLER_0_36 VDD VDD VSS VSS gf180mcu_fd_sc_mcu7t5v0__fillcap_16
XFILLER_34_527 VDD VDD VSS VSS gf180mcu_fd_sc_mcu7t5v0__fillcap_16
XFILLER_46_387 VDD VDD VSS VSS gf180mcu_fd_sc_mcu7t5v0__fill_1
XTAP_TAPCELL_ROW_64_1030 VDD VSS gf180mcu_fd_sc_mcu7t5v0__filltie
X_1870_ _1870_/A1 _1900_/A2 _1900_/B1 _1870_/B2 _1871_/I VDD VDD VSS VSS gf180mcu_fd_sc_mcu7t5v0__aoi22_1
X_2422_ _2422_/A1 _2439_/A3 _2434_/A3 VDD VDD VSS VSS gf180mcu_fd_sc_mcu7t5v0__nand2_1
XFILLER_36_2 VDD VDD VSS VSS gf180mcu_fd_sc_mcu7t5v0__fillcap_8
X_2353_ _2369_/A1 _2353_/A2 _2354_/A2 VDD VDD VSS VSS gf180mcu_fd_sc_mcu7t5v0__nand2_1
XFILLER_57_619 VDD VDD VSS VSS gf180mcu_fd_sc_mcu7t5v0__fillcap_8
X_1304_ _1304_/A1 _1368_/A2 _2277_/A2 VDD VDD VSS VSS gf180mcu_fd_sc_mcu7t5v0__nand2_1
XFILLER_56_107 VDD VDD VSS VSS gf180mcu_fd_sc_mcu7t5v0__fillcap_8
X_2284_ _2284_/A1 _2284_/A2 _2296_/B _2284_/ZN VDD VDD VSS VSS gf180mcu_fd_sc_mcu7t5v0__aoi21_1
XFILLER_49_192 VDD VDD VSS VSS gf180mcu_fd_sc_mcu7t5v0__fill_2
X_1235_ input61/Z _1508_/B2 _1235_/B _1247_/A1 VDD VDD VSS VSS gf180mcu_fd_sc_mcu7t5v0__oai21_1
X_1166_ _1167_/A1 _1167_/A2 _1167_/A3 _1166_/Z VDD VDD VSS VSS gf180mcu_fd_sc_mcu7t5v0__and3_1
XFILLER_52_313 VDD VDD VSS VSS gf180mcu_fd_sc_mcu7t5v0__fill_2
XFILLER_64_162 VDD VDD VSS VSS gf180mcu_fd_sc_mcu7t5v0__fillcap_8
X_1097_ _1097_/I _2192_/A1 VDD VDD VSS VSS gf180mcu_fd_sc_mcu7t5v0__clkinv_1
XFILLER_80_655 VDD VDD VSS VSS gf180mcu_fd_sc_mcu7t5v0__fillcap_8
XFILLER_21_766 VDD VDD VSS VSS gf180mcu_fd_sc_mcu7t5v0__fillcap_4
X_1999_ _1999_/I _1999_/ZN VDD VDD VSS VSS gf180mcu_fd_sc_mcu7t5v0__clkinv_1
XFILLER_48_608 VDD VDD VSS VSS gf180mcu_fd_sc_mcu7t5v0__fillcap_16
XTAP_TAPCELL_ROW_89_1328 VDD VSS gf180mcu_fd_sc_mcu7t5v0__filltie
XFILLER_55_151 VDD VDD VSS VSS gf180mcu_fd_sc_mcu7t5v0__fillcap_4
XFILLER_56_663 VDD VDD VSS VSS gf180mcu_fd_sc_mcu7t5v0__fill_2
XTAP_TAPCELL_ROW_46_809 VDD VSS gf180mcu_fd_sc_mcu7t5v0__filltie
XFILLER_16_527 VDD VDD VSS VSS gf180mcu_fd_sc_mcu7t5v0__fillcap_64
XFILLER_43_368 VDD VDD VSS VSS gf180mcu_fd_sc_mcu7t5v0__fill_1
XTAP_TAPCELL_ROW_26_566 VDD VSS gf180mcu_fd_sc_mcu7t5v0__filltie
XFILLER_71_699 VDD VDD VSS VSS gf180mcu_fd_sc_mcu7t5v0__fill_1
XFILLER_51_390 VDD VDD VSS VSS gf180mcu_fd_sc_mcu7t5v0__fillcap_16
XFILLER_59_72 VDD VDD VSS VSS gf180mcu_fd_sc_mcu7t5v0__fillcap_8
Xfanout1210 _1257_/ZN _2355_/A3 VDD VDD VSS VSS gf180mcu_fd_sc_mcu7t5v0__dlyd_1
Xfanout1221 _1126_/ZN fanout1221/Z VDD VDD VSS VSS gf180mcu_fd_sc_mcu7t5v0__dlyd_1
XFILLER_79_766 VDD VDD VSS VSS gf180mcu_fd_sc_mcu7t5v0__fillcap_4
Xfanout1243 _2601_/RN _2586_/RN VDD VDD VSS VSS gf180mcu_fd_sc_mcu7t5v0__dlyd_1
XFILLER_66_438 VDD VDD VSS VSS gf180mcu_fd_sc_mcu7t5v0__fillcap_16
XTAP_TAPCELL_ROW_109_1564 VDD VSS gf180mcu_fd_sc_mcu7t5v0__filltie
XFILLER_35_858 VDD VDD VSS VSS gf180mcu_fd_sc_mcu7t5v0__fillcap_8
XFILLER_46_173 VDD VDD VSS VSS gf180mcu_fd_sc_mcu7t5v0__fill_2
XFILLER_61_110 VDD VDD VSS VSS gf180mcu_fd_sc_mcu7t5v0__fillcap_16
XFILLER_74_493 VDD VDD VSS VSS gf180mcu_fd_sc_mcu7t5v0__fill_2
X_1922_ _1922_/A1 _1938_/A2 _1930_/B1 _1922_/B2 _1923_/I VDD VDD VSS VSS gf180mcu_fd_sc_mcu7t5v0__aoi22_1
X_1853_ _1853_/I _1853_/ZN VDD VDD VSS VSS gf180mcu_fd_sc_mcu7t5v0__clkinv_1
X_1784_ _1974_/A1 _1822_/A2 _1812_/B1 _1974_/B2 _1785_/I VDD VDD VSS VSS gf180mcu_fd_sc_mcu7t5v0__aoi22_1
XTAP_TAPCELL_ROW_73_1129 VDD VSS gf180mcu_fd_sc_mcu7t5v0__filltie
X_2405_ _2409_/A1 _2451_/B _2559_/D VDD VDD VSS VSS gf180mcu_fd_sc_mcu7t5v0__xor2_1
XFILLER_112_852 VDD VDD VSS VSS gf180mcu_fd_sc_mcu7t5v0__fillcap_8
X_2336_ _2336_/A1 _2336_/A2 _2376_/B _2336_/ZN VDD VDD VSS VSS gf180mcu_fd_sc_mcu7t5v0__aoi21_1
XFILLER_69_254 VDD VDD VSS VSS gf180mcu_fd_sc_mcu7t5v0__fill_1
X_2267_ input78/Z _2323_/A2 _2295_/A3 _2268_/A2 VDD VDD VSS VSS gf180mcu_fd_sc_mcu7t5v0__nand3_1
XFILLER_84_224 VDD VDD VSS VSS gf180mcu_fd_sc_mcu7t5v0__fillcap_16
X_1218_ _1218_/A1 _1218_/A2 _2774_/I VDD VDD VSS VSS gf180mcu_fd_sc_mcu7t5v0__nand2_1
XFILLER_84_279 VDD VDD VSS VSS gf180mcu_fd_sc_mcu7t5v0__fillcap_16
X_2198_ _2198_/A1 _2224_/C _2198_/B1 _2198_/B2 _2198_/ZN VDD VDD VSS VSS gf180mcu_fd_sc_mcu7t5v0__aoi22_2
X_1149_ _2568_/Q _2454_/A1 _1147_/Z _1149_/B2 _1149_/C _1155_/A2 VDD VDD VSS VSS gf180mcu_fd_sc_mcu7t5v0__aoi221_1
XFILLER_53_699 VDD VDD VSS VSS gf180mcu_fd_sc_mcu7t5v0__fill_1
XTAP_TAPCELL_ROW_84_1269 VDD VSS gf180mcu_fd_sc_mcu7t5v0__filltie
XFILLER_40_349 VDD VDD VSS VSS gf180mcu_fd_sc_mcu7t5v0__fillcap_4
XTAP_TAPCELL_ROW_23_536 VDD VSS gf180mcu_fd_sc_mcu7t5v0__filltie
XTAP_TAPCELL_ROW_51_867 VDD VSS gf180mcu_fd_sc_mcu7t5v0__filltie
XTAP_TAPCELL_ROW_95_1398 VDD VSS gf180mcu_fd_sc_mcu7t5v0__filltie
XFILLER_96_26 VDD VDD VSS VSS gf180mcu_fd_sc_mcu7t5v0__fill_1
XFILLER_0_423 VDD VDD VSS VSS gf180mcu_fd_sc_mcu7t5v0__fillcap_16
Xinput302 tl_h_d_i[2] _1084_/I VDD VDD VSS VSS gf180mcu_fd_sc_mcu7t5v0__dlyd_1
XFILLER_0_467 VDD VDD VSS VSS gf180mcu_fd_sc_mcu7t5v0__fillcap_8
XFILLER_0_478 VDD VDD VSS VSS gf180mcu_fd_sc_mcu7t5v0__fillcap_32
Xinput313 tl_h_d_i[3] _1860_/B2 VDD VDD VSS VSS gf180mcu_fd_sc_mcu7t5v0__dlyd_1
Xinput324 tl_h_d_i[4] _1085_/I VDD VDD VSS VSS gf180mcu_fd_sc_mcu7t5v0__dlyd_1
Xinput335 tl_h_d_i[5] _1864_/B2 VDD VDD VSS VSS gf180mcu_fd_sc_mcu7t5v0__dlyd_1
XFILLER_88_563 VDD VDD VSS VSS gf180mcu_fd_sc_mcu7t5v0__fillcap_32
XFILLER_102_384 VDD VDD VSS VSS gf180mcu_fd_sc_mcu7t5v0__fill_1
XFILLER_102_395 VDD VDD VSS VSS gf180mcu_fd_sc_mcu7t5v0__fillcap_4
Xinput346 tl_h_d_i[6] _1086_/I VDD VDD VSS VSS gf180mcu_fd_sc_mcu7t5v0__dlyd_1
Xinput357 tl_h_d_i[7] _1868_/B2 VDD VDD VSS VSS gf180mcu_fd_sc_mcu7t5v0__dlyd_1
Xinput368 tl_h_d_i[8] _1870_/B2 VDD VDD VSS VSS gf180mcu_fd_sc_mcu7t5v0__dlyd_1
Xinput379 tl_h_d_i[9] _1872_/B2 VDD VDD VSS VSS gf180mcu_fd_sc_mcu7t5v0__dlyd_1
XTAP_TAPCELL_ROW_59_967 VDD VSS gf180mcu_fd_sc_mcu7t5v0__filltie
XFILLER_29_696 VDD VDD VSS VSS gf180mcu_fd_sc_mcu7t5v0__fillcap_4
XTAP_TAPCELL_ROW_3_294 VDD VSS gf180mcu_fd_sc_mcu7t5v0__filltie
XFILLER_71_430 VDD VDD VSS VSS gf180mcu_fd_sc_mcu7t5v0__fillcap_4
XFILLER_43_154 VDD VDD VSS VSS gf180mcu_fd_sc_mcu7t5v0__fill_2
XFILLER_43_165 VDD VDD VSS VSS gf180mcu_fd_sc_mcu7t5v0__fill_2
XFILLER_71_485 VDD VDD VSS VSS gf180mcu_fd_sc_mcu7t5v0__fillcap_4
XFILLER_31_349 VDD VDD VSS VSS gf180mcu_fd_sc_mcu7t5v0__fill_1
XANTENNA_6 _1335_/ZN VDD VDD VSS VSS gf180mcu_fd_sc_mcu7t5v0__antenna
Xoutput809 _2762_/Z tl_d_uart_o[103] VDD VDD VSS VSS gf180mcu_fd_sc_mcu7t5v0__dlyd_1
XPHY_EDGE_ROW_60_Left_179 VDD VSS gf180mcu_fd_sc_mcu7t5v0__endcap
Xfanout1051 _2477_/S _2462_/S VDD VDD VSS VSS gf180mcu_fd_sc_mcu7t5v0__dlyd_1
Xfanout1073 fanout1075/Z _1964_/A2 VDD VDD VSS VSS gf180mcu_fd_sc_mcu7t5v0__dlyd_1
X_2121_ _2170_/C _2121_/A2 _2121_/B _2121_/ZN VDD VDD VSS VSS gf180mcu_fd_sc_mcu7t5v0__aoi21_1
Xfanout1084 _1407_/A1 _1503_/A1 VDD VDD VSS VSS gf180mcu_fd_sc_mcu7t5v0__dlyd_1
X_2052_ _2123_/B2 _2315_/A2 _2277_/A1 _2123_/A1 _2053_/I VDD VDD VSS VSS gf180mcu_fd_sc_mcu7t5v0__aoi22_1
XFILLER_82_728 VDD VDD VSS VSS gf180mcu_fd_sc_mcu7t5v0__fillcap_4
X_1905_ _1905_/I _1905_/ZN VDD VDD VSS VSS gf180mcu_fd_sc_mcu7t5v0__clkinv_1
X_1836_ _2400_/I0 _1836_/A2 _1850_/B1 _2761_/I _1837_/I VDD VDD VSS VSS gf180mcu_fd_sc_mcu7t5v0__aoi22_1
XPHY_EDGE_ROW_6_Right_6 VDD VSS gf180mcu_fd_sc_mcu7t5v0__endcap
X_1767_ _1767_/I _1767_/ZN VDD VDD VSS VSS gf180mcu_fd_sc_mcu7t5v0__clkinv_1
X_1698_ _2387_/I0 _1728_/A2 _1722_/B1 _1698_/B2 _1699_/I VDD VDD VSS VSS gf180mcu_fd_sc_mcu7t5v0__aoi22_1
XFILLER_57_202 VDD VDD VSS VSS gf180mcu_fd_sc_mcu7t5v0__fillcap_8
X_2319_ input93/Z _2343_/A2 _2331_/A3 _2320_/A2 VDD VDD VSS VSS gf180mcu_fd_sc_mcu7t5v0__nand3_1
XFILLER_45_419 VDD VDD VSS VSS gf180mcu_fd_sc_mcu7t5v0__fill_1
XFILLER_57_279 VDD VDD VSS VSS gf180mcu_fd_sc_mcu7t5v0__fill_1
XTAP_TAPCELL_ROW_56_926 VDD VSS gf180mcu_fd_sc_mcu7t5v0__filltie
XTAP_TAPCELL_ROW_0_253 VDD VSS gf180mcu_fd_sc_mcu7t5v0__filltie
XTAP_TAPCELL_ROW_0_242 VDD VSS gf180mcu_fd_sc_mcu7t5v0__filltie
XFILLER_72_238 VDD VDD VSS VSS gf180mcu_fd_sc_mcu7t5v0__fillcap_4
XTAP_TAPCELL_ROW_36_694 VDD VSS gf180mcu_fd_sc_mcu7t5v0__filltie
XTAP_TAPCELL_ROW_36_683 VDD VSS gf180mcu_fd_sc_mcu7t5v0__filltie
XFILLER_21_360 VDD VDD VSS VSS gf180mcu_fd_sc_mcu7t5v0__fill_2
XFILLER_21_371 VDD VDD VSS VSS gf180mcu_fd_sc_mcu7t5v0__fillcap_32
XTAP_TAPCELL_ROW_97_1416 VDD VSS gf180mcu_fd_sc_mcu7t5v0__filltie
XFILLER_107_465 VDD VDD VSS VSS gf180mcu_fd_sc_mcu7t5v0__fillcap_16
XFILLER_107_487 VDD VDD VSS VSS gf180mcu_fd_sc_mcu7t5v0__fill_1
XTAP_TAPCELL_ROW_8_353 VDD VSS gf180mcu_fd_sc_mcu7t5v0__filltie
Xinput110 tl_d_esram_i[48] _2178_/B2 VDD VDD VSS VSS gf180mcu_fd_sc_mcu7t5v0__dlyd_1
Xinput121 tl_d_esram_i[58] _2235_/A1 VDD VDD VSS VSS gf180mcu_fd_sc_mcu7t5v0__dlyd_1
Xinput132 tl_d_esram_i[8] _2136_/B2 VDD VDD VSS VSS gf180mcu_fd_sc_mcu7t5v0__dlyd_1
Xinput143 tl_d_rom_i[18] _1272_/A1 VDD VDD VSS VSS gf180mcu_fd_sc_mcu7t5v0__dlyd_1
Xinput154 tl_d_rom_i[28] _1352_/A1 VDD VDD VSS VSS gf180mcu_fd_sc_mcu7t5v0__dlyd_1
XFILLER_88_382 VDD VDD VSS VSS gf180mcu_fd_sc_mcu7t5v0__fill_2
XFILLER_48_268 VDD VDD VSS VSS gf180mcu_fd_sc_mcu7t5v0__fillcap_32
Xinput165 tl_d_rom_i[38] _1432_/A1 VDD VDD VSS VSS gf180mcu_fd_sc_mcu7t5v0__dlyd_1
Xinput176 tl_d_rom_i[48] _2178_/A1 VDD VDD VSS VSS gf180mcu_fd_sc_mcu7t5v0__dlyd_1
Xinput187 tl_d_rom_i[58] _2233_/A1 VDD VDD VSS VSS gf180mcu_fd_sc_mcu7t5v0__dlyd_1
Xinput198 tl_d_rom_i[8] _2136_/A1 VDD VDD VSS VSS gf180mcu_fd_sc_mcu7t5v0__dlyd_1
Xload_slew1220 _2357_/A1 _2293_/A1 VDD VDD VSS VSS gf180mcu_fd_sc_mcu7t5v0__buf_2
Xload_slew1242 _2558_/RN _2550_/RN VDD VDD VSS VSS gf180mcu_fd_sc_mcu7t5v0__buf_4
XTAP_TAPCELL_ROW_106_1534 VDD VSS gf180mcu_fd_sc_mcu7t5v0__filltie
XTAP_TAPCELL_ROW_106_1523 VDD VSS gf180mcu_fd_sc_mcu7t5v0__filltie
XFILLER_91_558 VDD VDD VSS VSS gf180mcu_fd_sc_mcu7t5v0__fill_2
XFILLER_71_282 VDD VDD VSS VSS gf180mcu_fd_sc_mcu7t5v0__fillcap_8
XPHY_EDGE_ROW_59_Right_59 VDD VSS gf180mcu_fd_sc_mcu7t5v0__endcap
X_2670_ _2742_/I _2670_/Z VDD VDD VSS VSS gf180mcu_fd_sc_mcu7t5v0__buf_1
XFILLER_9_865 VDD VDD VSS VSS gf180mcu_fd_sc_mcu7t5v0__fill_1
X_1621_ _1914_/B2 _1664_/S _1621_/Z VDD VDD VSS VSS gf180mcu_fd_sc_mcu7t5v0__or2_1
Xoutput606 _2686_/Z tl_d_dmem_o[99] VDD VDD VSS VSS gf180mcu_fd_sc_mcu7t5v0__dlyd_1
Xoutput617 _2037_/ZN tl_d_esram_o[108] VDD VDD VSS VSS gf180mcu_fd_sc_mcu7t5v0__dlyd_1
XTAP_TAPCELL_ROW_117_1663 VDD VSS gf180mcu_fd_sc_mcu7t5v0__filltie
Xoutput628 _1885_/ZN tl_d_esram_o[15] VDD VDD VSS VSS gf180mcu_fd_sc_mcu7t5v0__dlyd_1
Xoutput639 _1905_/ZN tl_d_esram_o[25] VDD VDD VSS VSS gf180mcu_fd_sc_mcu7t5v0__dlyd_1
X_1552_ _2755_/I _2706_/I _1552_/Z VDD VDD VSS VSS gf180mcu_fd_sc_mcu7t5v0__xor2_1
XFILLER_99_614 VDD VDD VSS VSS gf180mcu_fd_sc_mcu7t5v0__fill_2
X_1483_ _1491_/A1 _1481_/Z _1483_/B _1484_/B1 VDD VDD VSS VSS gf180mcu_fd_sc_mcu7t5v0__oai21_1
XFILLER_100_107 VDD VDD VSS VSS gf180mcu_fd_sc_mcu7t5v0__fill_2
XPHY_EDGE_ROW_68_Right_68 VDD VSS gf180mcu_fd_sc_mcu7t5v0__endcap
XFILLER_95_842 VDD VDD VSS VSS gf180mcu_fd_sc_mcu7t5v0__fillcap_4
X_2104_ _2235_/A1 _2347_/A2 _2345_/A1 _2233_/A1 _2105_/A2 VDD VDD VSS VSS gf180mcu_fd_sc_mcu7t5v0__aoi22_1
XFILLER_95_864 VDD VDD VSS VSS gf180mcu_fd_sc_mcu7t5v0__fill_2
XFILLER_47_290 VDD VDD VSS VSS gf180mcu_fd_sc_mcu7t5v0__fillcap_4
X_2035_ _2035_/I _2035_/ZN VDD VDD VSS VSS gf180mcu_fd_sc_mcu7t5v0__clkinv_1
XFILLER_63_772 VDD VDD VSS VSS gf180mcu_fd_sc_mcu7t5v0__fillcap_64
XFILLER_50_411 VDD VDD VSS VSS gf180mcu_fd_sc_mcu7t5v0__fill_2
XTAP_TAPCELL_ROW_81_1228 VDD VSS gf180mcu_fd_sc_mcu7t5v0__filltie
XTAP_TAPCELL_ROW_33_653 VDD VSS gf180mcu_fd_sc_mcu7t5v0__filltie
XPHY_EDGE_ROW_77_Right_77 VDD VSS gf180mcu_fd_sc_mcu7t5v0__endcap
XTAP_TAPCELL_ROW_61_984 VDD VSS gf180mcu_fd_sc_mcu7t5v0__filltie
X_1819_ _1819_/I _1819_/ZN VDD VDD VSS VSS gf180mcu_fd_sc_mcu7t5v0__clkinv_1
XPHY_EDGE_ROW_107_Left_226 VDD VSS gf180mcu_fd_sc_mcu7t5v0__endcap
XTAP_TAPCELL_ROW_92_1357 VDD VSS gf180mcu_fd_sc_mcu7t5v0__filltie
XFILLER_104_457 VDD VDD VSS VSS gf180mcu_fd_sc_mcu7t5v0__fillcap_16
XFILLER_104_479 VDD VDD VSS VSS gf180mcu_fd_sc_mcu7t5v0__fill_1
XTAP_TAPCELL_ROW_5_312 VDD VSS gf180mcu_fd_sc_mcu7t5v0__filltie
XPHY_EDGE_ROW_86_Right_86 VDD VSS gf180mcu_fd_sc_mcu7t5v0__endcap
XFILLER_58_522 VDD VDD VSS VSS gf180mcu_fd_sc_mcu7t5v0__fill_2
XFILLER_86_831 VDD VDD VSS VSS gf180mcu_fd_sc_mcu7t5v0__fill_1
XFILLER_85_352 VDD VDD VSS VSS gf180mcu_fd_sc_mcu7t5v0__fillcap_8
XPHY_EDGE_ROW_116_Left_235 VDD VSS gf180mcu_fd_sc_mcu7t5v0__endcap
XFILLER_93_38 VDD VDD VSS VSS gf180mcu_fd_sc_mcu7t5v0__fillcap_32
XFILLER_26_10 VDD VDD VSS VSS gf180mcu_fd_sc_mcu7t5v0__fillcap_4
XFILLER_41_422 VDD VDD VSS VSS gf180mcu_fd_sc_mcu7t5v0__fillcap_4
XFILLER_53_282 VDD VDD VSS VSS gf180mcu_fd_sc_mcu7t5v0__fillcap_16
XPHY_EDGE_ROW_95_Right_95 VDD VSS gf180mcu_fd_sc_mcu7t5v0__endcap
XTAP_TAPCELL_ROW_101_1464 VDD VSS gf180mcu_fd_sc_mcu7t5v0__filltie
XFILLER_10_831 VDD VDD VSS VSS gf180mcu_fd_sc_mcu7t5v0__fill_1
XFILLER_49_500 VDD VDD VSS VSS gf180mcu_fd_sc_mcu7t5v0__fill_2
XFILLER_68_308 VDD VDD VSS VSS gf180mcu_fd_sc_mcu7t5v0__fillcap_4
XFILLER_89_680 VDD VDD VSS VSS gf180mcu_fd_sc_mcu7t5v0__fillcap_8
XFILLER_77_842 VDD VDD VSS VSS gf180mcu_fd_sc_mcu7t5v0__fillcap_16
XFILLER_49_555 VDD VDD VSS VSS gf180mcu_fd_sc_mcu7t5v0__fillcap_4
XFILLER_67_72 VDD VDD VSS VSS gf180mcu_fd_sc_mcu7t5v0__fillcap_64
XFILLER_92_823 VDD VDD VSS VSS gf180mcu_fd_sc_mcu7t5v0__fillcap_8
XFILLER_36_238 VDD VDD VSS VSS gf180mcu_fd_sc_mcu7t5v0__fill_2
XFILLER_51_219 VDD VDD VSS VSS gf180mcu_fd_sc_mcu7t5v0__fill_2
Xload_slew1083 _2397_/S _2398_/S VDD VDD VSS VSS gf180mcu_fd_sc_mcu7t5v0__buf_4
XTAP_TAPCELL_ROW_67_1061 VDD VSS gf180mcu_fd_sc_mcu7t5v0__filltie
XFILLER_60_731 VDD VDD VSS VSS gf180mcu_fd_sc_mcu7t5v0__fillcap_4
XTAP_TAPCELL_ROW_30_612 VDD VSS gf180mcu_fd_sc_mcu7t5v0__filltie
X_2722_ _2722_/I _2722_/Z VDD VDD VSS VSS gf180mcu_fd_sc_mcu7t5v0__buf_1
X_2653_ _2725_/I _2653_/Z VDD VDD VSS VSS gf180mcu_fd_sc_mcu7t5v0__buf_1
X_2584_ _2584_/D _2586_/RN clkload4/I _2584_/Q VDD VDD VSS VSS gf180mcu_fd_sc_mcu7t5v0__dffrnq_1
X_1604_ _2750_/I _2751_/I _1604_/Z VDD VDD VSS VSS gf180mcu_fd_sc_mcu7t5v0__xor2_1
XTAP_TAPCELL_ROW_78_1190 VDD VSS gf180mcu_fd_sc_mcu7t5v0__filltie
XTAP_TAPCELL_ROW_10_380 VDD VSS gf180mcu_fd_sc_mcu7t5v0__filltie
X_1535_ _1958_/B2 _1535_/A2 _1535_/Z VDD VDD VSS VSS gf180mcu_fd_sc_mcu7t5v0__or2_1
XFILLER_99_422 VDD VDD VSS VSS gf180mcu_fd_sc_mcu7t5v0__fillcap_4
XFILLER_59_319 VDD VDD VSS VSS gf180mcu_fd_sc_mcu7t5v0__fillcap_16
X_1466_ _2359_/A1 _1490_/A2 _2363_/A3 _1467_/B VDD VDD VSS VSS gf180mcu_fd_sc_mcu7t5v0__nand3_1
XFILLER_68_831 VDD VDD VSS VSS gf180mcu_fd_sc_mcu7t5v0__fill_1
XFILLER_67_352 VDD VDD VSS VSS gf180mcu_fd_sc_mcu7t5v0__fillcap_16
X_1397_ _1397_/I _1398_/B1 VDD VDD VSS VSS gf180mcu_fd_sc_mcu7t5v0__clkinv_1
XTAP_TAPCELL_ROW_38_712 VDD VSS gf180mcu_fd_sc_mcu7t5v0__filltie
XFILLER_55_558 VDD VDD VSS VSS gf180mcu_fd_sc_mcu7t5v0__fill_2
XFILLER_67_396 VDD VDD VSS VSS gf180mcu_fd_sc_mcu7t5v0__fillcap_8
X_2018_ _2396_/I0 _2022_/A2 _2022_/B1 _2757_/I _2019_/I VDD VDD VSS VSS gf180mcu_fd_sc_mcu7t5v0__aoi22_1
XFILLER_23_422 VDD VDD VSS VSS gf180mcu_fd_sc_mcu7t5v0__fillcap_32
XFILLER_35_282 VDD VDD VSS VSS gf180mcu_fd_sc_mcu7t5v0__fillcap_8
Xoutput970 _2226_/ZN tl_h_d_o[56] VDD VDD VSS VSS gf180mcu_fd_sc_mcu7t5v0__dlyd_1
Xoutput981 _2132_/ZN tl_h_d_o[6] VDD VDD VSS VSS gf180mcu_fd_sc_mcu7t5v0__dlyd_1
Xoutput992 _2256_/ZN tl_h_i_o[16] VDD VDD VSS VSS gf180mcu_fd_sc_mcu7t5v0__dlyd_1
XFILLER_59_842 VDD VDD VSS VSS gf180mcu_fd_sc_mcu7t5v0__fillcap_4
XFILLER_59_864 VDD VDD VSS VSS gf180mcu_fd_sc_mcu7t5v0__fill_2
XFILLER_100_471 VDD VDD VSS VSS gf180mcu_fd_sc_mcu7t5v0__fillcap_16
XFILLER_86_683 VDD VDD VSS VSS gf180mcu_fd_sc_mcu7t5v0__fillcap_4
XFILLER_86_661 VDD VDD VSS VSS gf180mcu_fd_sc_mcu7t5v0__fillcap_4
XFILLER_74_823 VDD VDD VSS VSS gf180mcu_fd_sc_mcu7t5v0__fillcap_8
XFILLER_100_493 VDD VDD VSS VSS gf180mcu_fd_sc_mcu7t5v0__fill_1
XFILLER_18_238 VDD VDD VSS VSS gf180mcu_fd_sc_mcu7t5v0__fillcap_4
XFILLER_26_271 VDD VDD VSS VSS gf180mcu_fd_sc_mcu7t5v0__fill_1
XFILLER_42_731 VDD VDD VSS VSS gf180mcu_fd_sc_mcu7t5v0__fillcap_4
XFILLER_54_591 VDD VDD VSS VSS gf180mcu_fd_sc_mcu7t5v0__fillcap_4
XTAP_TAPCELL_ROW_114_1622 VDD VSS gf180mcu_fd_sc_mcu7t5v0__filltie
X_1320_ _1320_/A1 _1368_/A2 _2285_/A2 VDD VDD VSS VSS gf180mcu_fd_sc_mcu7t5v0__nand2_1
X_1251_ _1251_/A1 _1251_/A2 _1251_/A3 _1464_/A2 VDD VDD VSS VSS gf180mcu_fd_sc_mcu7t5v0__nor3_1
XFILLER_96_469 VDD VDD VSS VSS gf180mcu_fd_sc_mcu7t5v0__fillcap_32
XFILLER_49_352 VDD VDD VSS VSS gf180mcu_fd_sc_mcu7t5v0__fillcap_16
X_1182_ _1207_/B _1209_/A1 _2538_/A2 VDD VDD VSS VSS gf180mcu_fd_sc_mcu7t5v0__nand2_1
XFILLER_64_311 VDD VDD VSS VSS gf180mcu_fd_sc_mcu7t5v0__fillcap_4
XFILLER_94_70 VDD VDD VSS VSS gf180mcu_fd_sc_mcu7t5v0__fill_1
XFILLER_92_631 VDD VDD VSS VSS gf180mcu_fd_sc_mcu7t5v0__fill_1
XFILLER_24_208 VDD VDD VSS VSS gf180mcu_fd_sc_mcu7t5v0__fill_2
XFILLER_17_282 VDD VDD VSS VSS gf180mcu_fd_sc_mcu7t5v0__fillcap_64
XFILLER_32_241 VDD VDD VSS VSS gf180mcu_fd_sc_mcu7t5v0__fillcap_4
XTAP_TAPCELL_ROW_43_770 VDD VSS gf180mcu_fd_sc_mcu7t5v0__filltie
X_2705_ _2705_/I _2705_/Z VDD VDD VSS VSS gf180mcu_fd_sc_mcu7t5v0__buf_1
XFILLER_9_492 VDD VDD VSS VSS gf180mcu_fd_sc_mcu7t5v0__fillcap_64
X_2636_ _2708_/I _2636_/Z VDD VDD VSS VSS gf180mcu_fd_sc_mcu7t5v0__buf_1
X_2567_ _2567_/D _2567_/RN clkload2/I _2567_/Q VDD VDD VSS VSS gf180mcu_fd_sc_mcu7t5v0__dffrnq_1
X_2498_ _2592_/Q _2517_/B _2504_/A3 VDD VDD VSS VSS gf180mcu_fd_sc_mcu7t5v0__xnor2_1
X_1518_ _1924_/B2 _1533_/A2 _1518_/Z VDD VDD VSS VSS gf180mcu_fd_sc_mcu7t5v0__or2_1
X_1449_ _2233_/A2 _2349_/A2 _1449_/Z VDD VDD VSS VSS gf180mcu_fd_sc_mcu7t5v0__and2_1
XFILLER_87_469 VDD VDD VSS VSS gf180mcu_fd_sc_mcu7t5v0__fillcap_16
XFILLER_56_801 VDD VDD VSS VSS gf180mcu_fd_sc_mcu7t5v0__fillcap_4
XFILLER_56_823 VDD VDD VSS VSS gf180mcu_fd_sc_mcu7t5v0__fillcap_8
XFILLER_68_683 VDD VDD VSS VSS gf180mcu_fd_sc_mcu7t5v0__fill_2
XFILLER_95_480 VDD VDD VSS VSS gf180mcu_fd_sc_mcu7t5v0__fillcap_8
XFILLER_68_694 VDD VDD VSS VSS gf180mcu_fd_sc_mcu7t5v0__fillcap_32
XFILLER_15_208 VDD VDD VSS VSS gf180mcu_fd_sc_mcu7t5v0__fill_2
XFILLER_55_377 VDD VDD VSS VSS gf180mcu_fd_sc_mcu7t5v0__fill_2
XFILLER_83_664 VDD VDD VSS VSS gf180mcu_fd_sc_mcu7t5v0__fillcap_16
XFILLER_71_804 VDD VDD VSS VSS gf180mcu_fd_sc_mcu7t5v0__fill_2
XFILLER_24_731 VDD VDD VSS VSS gf180mcu_fd_sc_mcu7t5v0__fillcap_4
XFILLER_23_230 VDD VDD VSS VSS gf180mcu_fd_sc_mcu7t5v0__fill_2
XFILLER_70_347 VDD VDD VSS VSS gf180mcu_fd_sc_mcu7t5v0__fill_1
XTAP_TAPCELL_ROW_13_409 VDD VSS gf180mcu_fd_sc_mcu7t5v0__filltie
XFILLER_46_311 VDD VDD VSS VSS gf180mcu_fd_sc_mcu7t5v0__fillcap_4
XFILLER_46_333 VDD VDD VSS VSS gf180mcu_fd_sc_mcu7t5v0__fill_2
XFILLER_58_193 VDD VDD VSS VSS gf180mcu_fd_sc_mcu7t5v0__fillcap_4
XFILLER_74_675 VDD VDD VSS VSS gf180mcu_fd_sc_mcu7t5v0__fillcap_4
XFILLER_46_377 VDD VDD VSS VSS gf180mcu_fd_sc_mcu7t5v0__fillcap_8
XTAP_TAPCELL_ROW_64_1020 VDD VSS gf180mcu_fd_sc_mcu7t5v0__filltie
XFILLER_14_252 VDD VDD VSS VSS gf180mcu_fd_sc_mcu7t5v0__fillcap_16
XFILLER_42_594 VDD VDD VSS VSS gf180mcu_fd_sc_mcu7t5v0__fill_1
XTAP_TAPCELL_ROW_40_740 VDD VSS gf180mcu_fd_sc_mcu7t5v0__filltie
X_2421_ _2421_/I _2423_/A1 VDD VDD VSS VSS gf180mcu_fd_sc_mcu7t5v0__clkinv_1
XTAP_TAPCELL_ROW_75_1160 VDD VSS gf180mcu_fd_sc_mcu7t5v0__filltie
X_2352_ _2352_/A1 _2352_/A2 _2376_/B _2352_/ZN VDD VDD VSS VSS gf180mcu_fd_sc_mcu7t5v0__aoi21_1
X_2283_ input83/Z _2323_/A2 _2295_/A3 _2284_/A2 VDD VDD VSS VSS gf180mcu_fd_sc_mcu7t5v0__nand3_1
X_1303_ _1399_/A1 _1303_/A2 _1303_/ZN VDD VDD VSS VSS gf180mcu_fd_sc_mcu7t5v0__nor2_1
XFILLER_38_801 VDD VDD VSS VSS gf180mcu_fd_sc_mcu7t5v0__fillcap_4
XFILLER_38_823 VDD VDD VSS VSS gf180mcu_fd_sc_mcu7t5v0__fillcap_8
XFILLER_56_119 VDD VDD VSS VSS gf180mcu_fd_sc_mcu7t5v0__fill_1
X_1234_ _2202_/B _1234_/A2 _1235_/B VDD VDD VSS VSS gf180mcu_fd_sc_mcu7t5v0__nand2_1
XFILLER_84_428 VDD VDD VSS VSS gf180mcu_fd_sc_mcu7t5v0__fillcap_16
XFILLER_37_366 VDD VDD VSS VSS gf180mcu_fd_sc_mcu7t5v0__fill_1
X_1165_ _1165_/A1 _1165_/A2 _1165_/A3 _1165_/A4 _1167_/A3 VDD VDD VSS VSS gf180mcu_fd_sc_mcu7t5v0__nor4_1
XFILLER_64_174 VDD VDD VSS VSS gf180mcu_fd_sc_mcu7t5v0__fill_1
XFILLER_64_185 VDD VDD VSS VSS gf180mcu_fd_sc_mcu7t5v0__fillcap_4
X_1096_ _1096_/I _2186_/A1 VDD VDD VSS VSS gf180mcu_fd_sc_mcu7t5v0__clkinv_1
XFILLER_80_634 VDD VDD VSS VSS gf180mcu_fd_sc_mcu7t5v0__fill_1
XFILLER_18_591 VDD VDD VSS VSS gf180mcu_fd_sc_mcu7t5v0__fillcap_4
XFILLER_80_667 VDD VDD VSS VSS gf180mcu_fd_sc_mcu7t5v0__fillcap_8
XFILLER_20_244 VDD VDD VSS VSS gf180mcu_fd_sc_mcu7t5v0__fill_1
X_1998_ _1998_/A1 _2022_/A2 _1998_/B1 _2731_/I _1999_/I VDD VDD VSS VSS gf180mcu_fd_sc_mcu7t5v0__aoi22_1
XFILLER_88_734 VDD VDD VSS VSS gf180mcu_fd_sc_mcu7t5v0__fill_1
XTAP_TAPCELL_ROW_89_1329 VDD VSS gf180mcu_fd_sc_mcu7t5v0__filltie
XFILLER_87_266 VDD VDD VSS VSS gf180mcu_fd_sc_mcu7t5v0__fillcap_8
XFILLER_75_439 VDD VDD VSS VSS gf180mcu_fd_sc_mcu7t5v0__fill_1
XFILLER_83_483 VDD VDD VSS VSS gf180mcu_fd_sc_mcu7t5v0__fillcap_4
XTAP_TAPCELL_ROW_26_567 VDD VSS gf180mcu_fd_sc_mcu7t5v0__filltie
XFILLER_98_509 VDD VDD VSS VSS gf180mcu_fd_sc_mcu7t5v0__fill_2
XFILLER_3_487 VDD VDD VSS VSS gf180mcu_fd_sc_mcu7t5v0__fill_2
Xfanout1200 _1117_/Z _2246_/C VDD VDD VSS VSS gf180mcu_fd_sc_mcu7t5v0__dlyd_1
XFILLER_78_244 VDD VDD VSS VSS gf180mcu_fd_sc_mcu7t5v0__fill_1
XFILLER_78_255 VDD VDD VSS VSS gf180mcu_fd_sc_mcu7t5v0__fillcap_4
XFILLER_46_141 VDD VDD VSS VSS gf180mcu_fd_sc_mcu7t5v0__fillcap_32
XFILLER_34_314 VDD VDD VSS VSS gf180mcu_fd_sc_mcu7t5v0__fill_1
XTAP_TAPCELL_ROW_109_1565 VDD VSS gf180mcu_fd_sc_mcu7t5v0__filltie
XFILLER_50_807 VDD VDD VSS VSS gf180mcu_fd_sc_mcu7t5v0__fillcap_16
XFILLER_62_656 VDD VDD VSS VSS gf180mcu_fd_sc_mcu7t5v0__fillcap_8
XFILLER_62_667 VDD VDD VSS VSS gf180mcu_fd_sc_mcu7t5v0__fillcap_16
XFILLER_22_509 VDD VDD VSS VSS gf180mcu_fd_sc_mcu7t5v0__fillcap_16
X_1921_ _1921_/I _1921_/ZN VDD VDD VSS VSS gf180mcu_fd_sc_mcu7t5v0__clkinv_1
X_1852_ _2390_/I0 _1854_/A2 _1854_/B1 _2770_/I _1853_/I VDD VDD VSS VSS gf180mcu_fd_sc_mcu7t5v0__aoi22_1
X_1783_ _1783_/I _1783_/ZN VDD VDD VSS VSS gf180mcu_fd_sc_mcu7t5v0__clkinv_1
X_2404_ _2434_/B _2433_/B _2451_/B VDD VDD VSS VSS gf180mcu_fd_sc_mcu7t5v0__xor2_2
XFILLER_69_200 VDD VDD VSS VSS gf180mcu_fd_sc_mcu7t5v0__fillcap_8
XFILLER_97_553 VDD VDD VSS VSS gf180mcu_fd_sc_mcu7t5v0__fillcap_4
XFILLER_112_864 VDD VDD VSS VSS gf180mcu_fd_sc_mcu7t5v0__fill_2
X_2335_ input97/Z _2343_/A2 _2375_/A3 _2336_/A2 VDD VDD VSS VSS gf180mcu_fd_sc_mcu7t5v0__nand3_1
X_2266_ _2282_/A1 _2266_/A2 _2268_/A1 VDD VDD VSS VSS gf180mcu_fd_sc_mcu7t5v0__nand2_1
X_2197_ input48/Z _2236_/A2 _2236_/B _2198_/B2 VDD VDD VSS VSS gf180mcu_fd_sc_mcu7t5v0__aoi21_1
X_1217_ input63/Z _2215_/B _1217_/B _1217_/C _1218_/A2 VDD VDD VSS VSS gf180mcu_fd_sc_mcu7t5v0__oai211_1
XFILLER_84_247 VDD VDD VSS VSS gf180mcu_fd_sc_mcu7t5v0__fillcap_32
XFILLER_25_314 VDD VDD VSS VSS gf180mcu_fd_sc_mcu7t5v0__fillcap_16
XFILLER_25_347 VDD VDD VSS VSS gf180mcu_fd_sc_mcu7t5v0__fill_2
X_1148_ _2570_/Q _2457_/A1 _1149_/B2 VDD VDD VSS VSS gf180mcu_fd_sc_mcu7t5v0__nand2_1
XTAP_TAPCELL_ROW_84_1259 VDD VSS gf180mcu_fd_sc_mcu7t5v0__filltie
XFILLER_40_317 VDD VDD VSS VSS gf180mcu_fd_sc_mcu7t5v0__fillcap_32
XFILLER_52_166 VDD VDD VSS VSS gf180mcu_fd_sc_mcu7t5v0__fillcap_8
XFILLER_52_177 VDD VDD VSS VSS gf180mcu_fd_sc_mcu7t5v0__fill_2
X_1079_ _2598_/Q _2531_/B2 VDD VDD VSS VSS gf180mcu_fd_sc_mcu7t5v0__clkinv_1
XTAP_TAPCELL_ROW_23_537 VDD VSS gf180mcu_fd_sc_mcu7t5v0__filltie
XTAP_TAPCELL_ROW_51_868 VDD VSS gf180mcu_fd_sc_mcu7t5v0__filltie
XFILLER_106_102 VDD VDD VSS VSS gf180mcu_fd_sc_mcu7t5v0__fill_2
XTAP_TAPCELL_ROW_95_1399 VDD VSS gf180mcu_fd_sc_mcu7t5v0__filltie
XFILLER_103_842 VDD VDD VSS VSS gf180mcu_fd_sc_mcu7t5v0__fillcap_4
Xinput303 tl_h_d_i[30] _1914_/B2 VDD VDD VSS VSS gf180mcu_fd_sc_mcu7t5v0__dlyd_1
XFILLER_103_864 VDD VDD VSS VSS gf180mcu_fd_sc_mcu7t5v0__fill_2
Xinput314 tl_h_d_i[40] _1934_/B2 VDD VDD VSS VSS gf180mcu_fd_sc_mcu7t5v0__dlyd_1
Xinput325 tl_h_d_i[50] _1954_/B2 VDD VDD VSS VSS gf180mcu_fd_sc_mcu7t5v0__dlyd_1
Xinput336 tl_h_d_i[60] _1974_/B2 VDD VDD VSS VSS gf180mcu_fd_sc_mcu7t5v0__dlyd_1
XFILLER_76_726 VDD VDD VSS VSS gf180mcu_fd_sc_mcu7t5v0__fill_2
Xinput347 tl_h_d_i[70] _2729_/I VDD VDD VSS VSS gf180mcu_fd_sc_mcu7t5v0__clkbuf_2
Xinput358 tl_h_d_i[80] _2739_/I VDD VDD VSS VSS gf180mcu_fd_sc_mcu7t5v0__clkbuf_2
Xinput369 tl_h_d_i[90] _2749_/I VDD VDD VSS VSS gf180mcu_fd_sc_mcu7t5v0__clkbuf_2
XFILLER_88_597 VDD VDD VSS VSS gf180mcu_fd_sc_mcu7t5v0__fillcap_64
XFILLER_76_737 VDD VDD VSS VSS gf180mcu_fd_sc_mcu7t5v0__fillcap_64
XFILLER_28_141 VDD VDD VSS VSS gf180mcu_fd_sc_mcu7t5v0__fill_1
XFILLER_56_450 VDD VDD VSS VSS gf180mcu_fd_sc_mcu7t5v0__fillcap_4
XTAP_TAPCELL_ROW_59_968 VDD VSS gf180mcu_fd_sc_mcu7t5v0__filltie
XFILLER_28_174 VDD VDD VSS VSS gf180mcu_fd_sc_mcu7t5v0__fill_1
XTAP_TAPCELL_ROW_3_295 VDD VSS gf180mcu_fd_sc_mcu7t5v0__filltie
XFILLER_17_859 VDD VDD VSS VSS gf180mcu_fd_sc_mcu7t5v0__fillcap_4
XFILLER_32_807 VDD VDD VSS VSS gf180mcu_fd_sc_mcu7t5v0__fillcap_16
XFILLER_44_667 VDD VDD VSS VSS gf180mcu_fd_sc_mcu7t5v0__fillcap_64
XFILLER_31_339 VDD VDD VSS VSS gf180mcu_fd_sc_mcu7t5v0__fillcap_8
XFILLER_12_597 VDD VDD VSS VSS gf180mcu_fd_sc_mcu7t5v0__fillcap_64
XFILLER_6_14 VDD VDD VSS VSS gf180mcu_fd_sc_mcu7t5v0__fill_2
XANTENNA_7 _2118_/ZN VDD VDD VSS VSS gf180mcu_fd_sc_mcu7t5v0__antenna
XFILLER_98_317 VDD VDD VSS VSS gf180mcu_fd_sc_mcu7t5v0__fillcap_16
XFILLER_20_6 VDD VDD VSS VSS gf180mcu_fd_sc_mcu7t5v0__fill_1
Xfanout1063 _2030_/B1 _2022_/B1 VDD VDD VSS VSS gf180mcu_fd_sc_mcu7t5v0__dlyd_1
X_2120_ _2120_/A1 _2146_/C _2154_/A2 input35/Z _2121_/B VDD VDD VSS VSS gf180mcu_fd_sc_mcu7t5v0__oai22_1
XFILLER_66_247 VDD VDD VSS VSS gf180mcu_fd_sc_mcu7t5v0__fillcap_64
Xfanout1096 _1830_/A2 _1836_/A2 VDD VDD VSS VSS gf180mcu_fd_sc_mcu7t5v0__dlyd_1
X_2051_ _2051_/I _2051_/ZN VDD VDD VSS VSS gf180mcu_fd_sc_mcu7t5v0__clkinv_1
XFILLER_94_567 VDD VDD VSS VSS gf180mcu_fd_sc_mcu7t5v0__fillcap_8
XFILLER_74_291 VDD VDD VSS VSS gf180mcu_fd_sc_mcu7t5v0__fillcap_8
X_1904_ _1904_/A1 _1912_/A2 _1926_/B1 _2716_/I _1905_/I VDD VDD VSS VSS gf180mcu_fd_sc_mcu7t5v0__aoi22_1
XFILLER_30_383 VDD VDD VSS VSS gf180mcu_fd_sc_mcu7t5v0__fill_2
X_1835_ _1835_/I _1835_/ZN VDD VDD VSS VSS gf180mcu_fd_sc_mcu7t5v0__clkinv_1
X_1766_ _1956_/A1 _1818_/A2 _1838_/B1 _1956_/B2 _1767_/I VDD VDD VSS VSS gf180mcu_fd_sc_mcu7t5v0__aoi22_1
XFILLER_104_606 VDD VDD VSS VSS gf180mcu_fd_sc_mcu7t5v0__fill_1
X_1697_ _1697_/I _1697_/ZN VDD VDD VSS VSS gf180mcu_fd_sc_mcu7t5v0__clkinv_1
XFILLER_100_823 VDD VDD VSS VSS gf180mcu_fd_sc_mcu7t5v0__fillcap_8
XFILLER_58_737 VDD VDD VSS VSS gf180mcu_fd_sc_mcu7t5v0__fillcap_64
X_2318_ _2346_/A1 _2318_/A2 _2320_/A1 VDD VDD VSS VSS gf180mcu_fd_sc_mcu7t5v0__nand2_1
XFILLER_97_394 VDD VDD VSS VSS gf180mcu_fd_sc_mcu7t5v0__fillcap_16
X_2249_ _2333_/A1 _2249_/A2 _2253_/A1 VDD VDD VSS VSS gf180mcu_fd_sc_mcu7t5v0__nand2_1
XTAP_TAPCELL_ROW_56_927 VDD VSS gf180mcu_fd_sc_mcu7t5v0__filltie
XTAP_TAPCELL_ROW_0_254 VDD VSS gf180mcu_fd_sc_mcu7t5v0__filltie
XTAP_TAPCELL_ROW_0_243 VDD VSS gf180mcu_fd_sc_mcu7t5v0__filltie
XFILLER_14_807 VDD VDD VSS VSS gf180mcu_fd_sc_mcu7t5v0__fillcap_16
XFILLER_26_667 VDD VDD VSS VSS gf180mcu_fd_sc_mcu7t5v0__fillcap_64
XFILLER_41_604 VDD VDD VSS VSS gf180mcu_fd_sc_mcu7t5v0__fill_1
XFILLER_13_328 VDD VDD VSS VSS gf180mcu_fd_sc_mcu7t5v0__fillcap_16
XFILLER_25_199 VDD VDD VSS VSS gf180mcu_fd_sc_mcu7t5v0__fillcap_4
XFILLER_53_486 VDD VDD VSS VSS gf180mcu_fd_sc_mcu7t5v0__fillcap_4
XTAP_TAPCELL_ROW_36_684 VDD VSS gf180mcu_fd_sc_mcu7t5v0__filltie
XTAP_TAPCELL_ROW_97_1417 VDD VSS gf180mcu_fd_sc_mcu7t5v0__filltie
XTAP_TAPCELL_ROW_8_354 VDD VSS gf180mcu_fd_sc_mcu7t5v0__filltie
Xinput100 tl_d_esram_i[39] _2347_/A1 VDD VDD VSS VSS gf180mcu_fd_sc_mcu7t5v0__dlyd_1
Xinput111 tl_d_esram_i[49] _1230_/A1 VDD VDD VSS VSS gf180mcu_fd_sc_mcu7t5v0__dlyd_1
Xinput122 tl_d_esram_i[59] _2238_/B2 VDD VDD VSS VSS gf180mcu_fd_sc_mcu7t5v0__dlyd_1
Xinput133 tl_d_esram_i[9] _2143_/A1 VDD VDD VSS VSS gf180mcu_fd_sc_mcu7t5v0__dlyd_1
Xinput144 tl_d_rom_i[19] _1280_/A1 VDD VDD VSS VSS gf180mcu_fd_sc_mcu7t5v0__dlyd_1
XFILLER_76_512 VDD VDD VSS VSS gf180mcu_fd_sc_mcu7t5v0__fillcap_8
XFILLER_48_247 VDD VDD VSS VSS gf180mcu_fd_sc_mcu7t5v0__fillcap_4
Xinput155 tl_d_rom_i[29] _1360_/A1 VDD VDD VSS VSS gf180mcu_fd_sc_mcu7t5v0__dlyd_1
Xinput166 tl_d_rom_i[39] _1440_/A1 VDD VDD VSS VSS gf180mcu_fd_sc_mcu7t5v0__dlyd_1
Xinput177 tl_d_rom_i[49] _1228_/B2 VDD VDD VSS VSS gf180mcu_fd_sc_mcu7t5v0__dlyd_1
XFILLER_64_729 VDD VDD VSS VSS gf180mcu_fd_sc_mcu7t5v0__fillcap_4
Xinput188 tl_d_rom_i[59] _2238_/A1 VDD VDD VSS VSS gf180mcu_fd_sc_mcu7t5v0__dlyd_1
Xinput199 tl_d_rom_i[9] _2142_/A1 VDD VDD VSS VSS gf180mcu_fd_sc_mcu7t5v0__dlyd_1
Xload_slew1232 _1886_/B2 _2707_/I VDD VDD VSS VSS gf180mcu_fd_sc_mcu7t5v0__buf_8
XFILLER_91_504 VDD VDD VSS VSS gf180mcu_fd_sc_mcu7t5v0__fillcap_8
XFILLER_56_291 VDD VDD VSS VSS gf180mcu_fd_sc_mcu7t5v0__fillcap_16
XTAP_TAPCELL_ROW_106_1524 VDD VSS gf180mcu_fd_sc_mcu7t5v0__filltie
XFILLER_44_453 VDD VDD VSS VSS gf180mcu_fd_sc_mcu7t5v0__fill_2
XFILLER_13_851 VDD VDD VSS VSS gf180mcu_fd_sc_mcu7t5v0__fillcap_8
X_1620_ _1912_/B2 _1664_/S _1620_/Z VDD VDD VSS VSS gf180mcu_fd_sc_mcu7t5v0__or2_1
XFILLER_8_387 VDD VDD VSS VSS gf180mcu_fd_sc_mcu7t5v0__fillcap_8
Xoutput607 _1572_/Z tl_d_dmem_o[9] VDD VDD VSS VSS gf180mcu_fd_sc_mcu7t5v0__dlyd_1
Xoutput618 _2039_/ZN tl_d_esram_o[109] VDD VDD VSS VSS gf180mcu_fd_sc_mcu7t5v0__dlyd_1
XTAP_TAPCELL_ROW_117_1664 VDD VSS gf180mcu_fd_sc_mcu7t5v0__filltie
Xoutput629 _1887_/ZN tl_d_esram_o[16] VDD VDD VSS VSS gf180mcu_fd_sc_mcu7t5v0__dlyd_1
X_1551_ _2753_/I _2752_/I _2754_/I _1551_/Z VDD VDD VSS VSS gf180mcu_fd_sc_mcu7t5v0__xor3_1
XFILLER_99_604 VDD VDD VSS VSS gf180mcu_fd_sc_mcu7t5v0__fill_1
X_1482_ _2367_/A1 _2158_/A2 _2375_/A3 _1483_/B VDD VDD VSS VSS gf180mcu_fd_sc_mcu7t5v0__nand3_1
XFILLER_67_534 VDD VDD VSS VSS gf180mcu_fd_sc_mcu7t5v0__fillcap_16
XFILLER_39_236 VDD VDD VSS VSS gf180mcu_fd_sc_mcu7t5v0__fill_2
X_2103_ _2230_/A1 _2291_/A2 _2103_/B _2103_/ZN VDD VDD VSS VSS gf180mcu_fd_sc_mcu7t5v0__aoi21_1
XFILLER_94_342 VDD VDD VSS VSS gf180mcu_fd_sc_mcu7t5v0__fillcap_16
X_2034_ _2034_/A1 _2044_/A2 _2038_/B1 _2766_/I _2035_/I VDD VDD VSS VSS gf180mcu_fd_sc_mcu7t5v0__aoi22_1
XFILLER_23_626 VDD VDD VSS VSS gf180mcu_fd_sc_mcu7t5v0__fillcap_4
XFILLER_35_486 VDD VDD VSS VSS gf180mcu_fd_sc_mcu7t5v0__fillcap_4
XFILLER_50_434 VDD VDD VSS VSS gf180mcu_fd_sc_mcu7t5v0__fillcap_4
XTAP_TAPCELL_ROW_81_1229 VDD VSS gf180mcu_fd_sc_mcu7t5v0__filltie
XFILLER_50_467 VDD VDD VSS VSS gf180mcu_fd_sc_mcu7t5v0__fillcap_16
XFILLER_62_294 VDD VDD VSS VSS gf180mcu_fd_sc_mcu7t5v0__fillcap_16
XTAP_TAPCELL_ROW_33_654 VDD VSS gf180mcu_fd_sc_mcu7t5v0__filltie
XTAP_TAPCELL_ROW_61_985 VDD VSS gf180mcu_fd_sc_mcu7t5v0__filltie
X_1818_ _2008_/A1 _1818_/A2 _1838_/B1 _2736_/I _1819_/I VDD VDD VSS VSS gf180mcu_fd_sc_mcu7t5v0__aoi22_1
XFILLER_104_403 VDD VDD VSS VSS gf180mcu_fd_sc_mcu7t5v0__fill_2
X_1749_ _1749_/I _1749_/ZN VDD VDD VSS VSS gf180mcu_fd_sc_mcu7t5v0__clkinv_1
XTAP_TAPCELL_ROW_92_1358 VDD VSS gf180mcu_fd_sc_mcu7t5v0__filltie
XTAP_TAPCELL_ROW_5_313 VDD VSS gf180mcu_fd_sc_mcu7t5v0__filltie
XFILLER_100_664 VDD VDD VSS VSS gf180mcu_fd_sc_mcu7t5v0__fill_1
XFILLER_42_10 VDD VDD VSS VSS gf180mcu_fd_sc_mcu7t5v0__fill_2
XFILLER_42_21 VDD VDD VSS VSS gf180mcu_fd_sc_mcu7t5v0__fillcap_8
Xclkbuf_3_3__f_clk_i clkbuf_0_clk_i/Z clkload3/I VDD VDD VSS VSS gf180mcu_fd_sc_mcu7t5v0__clkbuf_16
XTAP_TAPCELL_ROW_101_1465 VDD VSS gf180mcu_fd_sc_mcu7t5v0__filltie
XFILLER_96_607 VDD VDD VSS VSS gf180mcu_fd_sc_mcu7t5v0__fill_1
XFILLER_49_523 VDD VDD VSS VSS gf180mcu_fd_sc_mcu7t5v0__fillcap_8
XFILLER_89_692 VDD VDD VSS VSS gf180mcu_fd_sc_mcu7t5v0__fill_2
XFILLER_76_342 VDD VDD VSS VSS gf180mcu_fd_sc_mcu7t5v0__fillcap_16
XFILLER_49_578 VDD VDD VSS VSS gf180mcu_fd_sc_mcu7t5v0__fillcap_8
XFILLER_76_364 VDD VDD VSS VSS gf180mcu_fd_sc_mcu7t5v0__fill_1
Xload_slew1062 _1952_/B1 _1998_/B1 VDD VDD VSS VSS gf180mcu_fd_sc_mcu7t5v0__buf_4
Xload_slew1095 _1826_/A2 _1822_/A2 VDD VDD VSS VSS gf180mcu_fd_sc_mcu7t5v0__buf_4
XFILLER_17_486 VDD VDD VSS VSS gf180mcu_fd_sc_mcu7t5v0__fillcap_4
XTAP_TAPCELL_ROW_67_1062 VDD VSS gf180mcu_fd_sc_mcu7t5v0__filltie
XFILLER_44_294 VDD VDD VSS VSS gf180mcu_fd_sc_mcu7t5v0__fill_2
XTAP_TAPCELL_ROW_30_613 VDD VSS gf180mcu_fd_sc_mcu7t5v0__filltie
X_2721_ _2721_/I _2721_/Z VDD VDD VSS VSS gf180mcu_fd_sc_mcu7t5v0__buf_1
X_2652_ _2724_/I _2652_/Z VDD VDD VSS VSS gf180mcu_fd_sc_mcu7t5v0__buf_1
X_2583_ _2583_/D _2583_/RN _2596_/CLK _2583_/Q VDD VDD VSS VSS gf180mcu_fd_sc_mcu7t5v0__dffrnq_1
X_1603_ _2734_/I _1568_/Z _1602_/Z _1603_/Z VDD VDD VSS VSS gf180mcu_fd_sc_mcu7t5v0__xor3_1
XTAP_TAPCELL_ROW_10_381 VDD VSS gf180mcu_fd_sc_mcu7t5v0__filltie
X_1534_ _1956_/B2 _1534_/A2 _1534_/Z VDD VDD VSS VSS gf180mcu_fd_sc_mcu7t5v0__or2_1
XTAP_TAPCELL_ROW_78_1191 VDD VSS gf180mcu_fd_sc_mcu7t5v0__filltie
XFILLER_99_478 VDD VDD VSS VSS gf180mcu_fd_sc_mcu7t5v0__fillcap_8
X_1465_ _2199_/A2 _2357_/A2 _1465_/Z VDD VDD VSS VSS gf180mcu_fd_sc_mcu7t5v0__and2_1
XFILLER_87_629 VDD VDD VSS VSS gf180mcu_fd_sc_mcu7t5v0__fill_1
X_1396_ input28/Z _1396_/A2 _1396_/B1 _1476_/B2 _1397_/I VDD VDD VSS VSS gf180mcu_fd_sc_mcu7t5v0__aoi22_1
XFILLER_55_515 VDD VDD VSS VSS gf180mcu_fd_sc_mcu7t5v0__fill_2
XTAP_TAPCELL_ROW_38_713 VDD VSS gf180mcu_fd_sc_mcu7t5v0__filltie
XFILLER_82_301 VDD VDD VSS VSS gf180mcu_fd_sc_mcu7t5v0__fillcap_8
XFILLER_27_228 VDD VDD VSS VSS gf180mcu_fd_sc_mcu7t5v0__fillcap_32
XFILLER_42_209 VDD VDD VSS VSS gf180mcu_fd_sc_mcu7t5v0__fill_2
X_2017_ _2017_/I _2017_/ZN VDD VDD VSS VSS gf180mcu_fd_sc_mcu7t5v0__clkinv_1
XFILLER_82_367 VDD VDD VSS VSS gf180mcu_fd_sc_mcu7t5v0__fill_1
XFILLER_23_412 VDD VDD VSS VSS gf180mcu_fd_sc_mcu7t5v0__fillcap_8
XTAP_TAPCELL_ROW_18_470 VDD VSS gf180mcu_fd_sc_mcu7t5v0__filltie
XFILLER_35_294 VDD VDD VSS VSS gf180mcu_fd_sc_mcu7t5v0__fill_1
Xoutput960 _1511_/ZN tl_h_d_o[47] VDD VDD VSS VSS gf180mcu_fd_sc_mcu7t5v0__dlyd_1
Xoutput971 _2232_/ZN tl_h_d_o[57] VDD VDD VSS VSS gf180mcu_fd_sc_mcu7t5v0__dlyd_1
Xoutput982 _2135_/ZN tl_h_d_o[7] VDD VDD VSS VSS gf180mcu_fd_sc_mcu7t5v0__dlyd_1
XFILLER_78_607 VDD VDD VSS VSS gf180mcu_fd_sc_mcu7t5v0__fill_1
Xoutput993 _2260_/ZN tl_h_i_o[17] VDD VDD VSS VSS gf180mcu_fd_sc_mcu7t5v0__dlyd_1
XFILLER_77_139 VDD VDD VSS VSS gf180mcu_fd_sc_mcu7t5v0__fill_1
XFILLER_33_209 VDD VDD VSS VSS gf180mcu_fd_sc_mcu7t5v0__fill_1
XFILLER_73_345 VDD VDD VSS VSS gf180mcu_fd_sc_mcu7t5v0__fillcap_4
XFILLER_41_264 VDD VDD VSS VSS gf180mcu_fd_sc_mcu7t5v0__fillcap_16
XFILLER_10_662 VDD VDD VSS VSS gf180mcu_fd_sc_mcu7t5v0__fill_2
XTAP_TAPCELL_ROW_114_1623 VDD VSS gf180mcu_fd_sc_mcu7t5v0__filltie
XFILLER_68_139 VDD VDD VSS VSS gf180mcu_fd_sc_mcu7t5v0__fill_1
X_1250_ input61/Z _1250_/A2 _1508_/A2 VDD VDD VSS VSS gf180mcu_fd_sc_mcu7t5v0__nor2_1
X_1181_ _1190_/A1 _1190_/A2 _1190_/C _1208_/C _1200_/A2 VDD VDD VSS VSS gf180mcu_fd_sc_mcu7t5v0__aoi211_1
XFILLER_94_60 VDD VDD VSS VSS gf180mcu_fd_sc_mcu7t5v0__fillcap_8
XFILLER_37_559 VDD VDD VSS VSS gf180mcu_fd_sc_mcu7t5v0__fill_1
XFILLER_92_676 VDD VDD VSS VSS gf180mcu_fd_sc_mcu7t5v0__fill_2
XTAP_TAPCELL_ROW_43_771 VDD VSS gf180mcu_fd_sc_mcu7t5v0__filltie
XTAP_TAPCELL_ROW_15_440 VDD VSS gf180mcu_fd_sc_mcu7t5v0__filltie
XFILLER_32_297 VDD VDD VSS VSS gf180mcu_fd_sc_mcu7t5v0__fillcap_16
X_2704_ _2704_/I _2704_/Z VDD VDD VSS VSS gf180mcu_fd_sc_mcu7t5v0__buf_1
X_2635_ _2707_/I _2635_/Z VDD VDD VSS VSS gf180mcu_fd_sc_mcu7t5v0__buf_1
X_2566_ _2566_/D _2580_/RN clkload2/I _2566_/Q VDD VDD VSS VSS gf180mcu_fd_sc_mcu7t5v0__dffrnq_1
X_2497_ _2497_/A1 _2497_/A2 _2497_/B _2499_/A1 VDD VDD VSS VSS gf180mcu_fd_sc_mcu7t5v0__aoi21_1
X_1517_ _1922_/B2 _1550_/A2 _1517_/Z VDD VDD VSS VSS gf180mcu_fd_sc_mcu7t5v0__or2_1
XFILLER_99_286 VDD VDD VSS VSS gf180mcu_fd_sc_mcu7t5v0__fill_2
XFILLER_87_437 VDD VDD VSS VSS gf180mcu_fd_sc_mcu7t5v0__fillcap_32
XFILLER_59_139 VDD VDD VSS VSS gf180mcu_fd_sc_mcu7t5v0__fill_1
X_1448_ _1448_/A1 _1496_/A2 _2349_/A2 VDD VDD VSS VSS gf180mcu_fd_sc_mcu7t5v0__nand2_1
XFILLER_28_504 VDD VDD VSS VSS gf180mcu_fd_sc_mcu7t5v0__fillcap_16
X_1379_ _1467_/A1 _1377_/Z _1379_/B _1380_/B1 VDD VDD VSS VSS gf180mcu_fd_sc_mcu7t5v0__oai21_1
XFILLER_95_492 VDD VDD VSS VSS gf180mcu_fd_sc_mcu7t5v0__fillcap_32
XFILLER_83_632 VDD VDD VSS VSS gf180mcu_fd_sc_mcu7t5v0__fillcap_32
XFILLER_28_559 VDD VDD VSS VSS gf180mcu_fd_sc_mcu7t5v0__fill_1
XFILLER_51_540 VDD VDD VSS VSS gf180mcu_fd_sc_mcu7t5v0__fillcap_4
XFILLER_23_275 VDD VDD VSS VSS gf180mcu_fd_sc_mcu7t5v0__fillcap_4
XFILLER_99_38 VDD VDD VSS VSS gf180mcu_fd_sc_mcu7t5v0__fillcap_32
Xoutput790 _1809_/ZN tl_d_rom_o[72] VDD VDD VSS VSS gf180mcu_fd_sc_mcu7t5v0__dlyd_1
XFILLER_34_507 VDD VDD VSS VSS gf180mcu_fd_sc_mcu7t5v0__fillcap_16
XFILLER_64_30 VDD VDD VSS VSS gf180mcu_fd_sc_mcu7t5v0__fillcap_4
XFILLER_73_142 VDD VDD VSS VSS gf180mcu_fd_sc_mcu7t5v0__fill_2
XFILLER_61_326 VDD VDD VSS VSS gf180mcu_fd_sc_mcu7t5v0__fillcap_4
XFILLER_74_698 VDD VDD VSS VSS gf180mcu_fd_sc_mcu7t5v0__fillcap_32
XFILLER_73_175 VDD VDD VSS VSS gf180mcu_fd_sc_mcu7t5v0__fillcap_16
XFILLER_73_164 VDD VDD VSS VSS gf180mcu_fd_sc_mcu7t5v0__fill_2
XFILLER_61_337 VDD VDD VSS VSS gf180mcu_fd_sc_mcu7t5v0__fillcap_4
XFILLER_64_96 VDD VDD VSS VSS gf180mcu_fd_sc_mcu7t5v0__fillcap_8
XTAP_TAPCELL_ROW_64_1021 VDD VSS gf180mcu_fd_sc_mcu7t5v0__filltie
XFILLER_14_297 VDD VDD VSS VSS gf180mcu_fd_sc_mcu7t5v0__fillcap_8
XTAP_TAPCELL_ROW_40_741 VDD VSS gf180mcu_fd_sc_mcu7t5v0__filltie
X_2420_ _2439_/A1 _2434_/B _2421_/I VDD VDD VSS VSS gf180mcu_fd_sc_mcu7t5v0__xor2_1
XTAP_TAPCELL_ROW_75_1161 VDD VSS gf180mcu_fd_sc_mcu7t5v0__filltie
X_2351_ _2351_/A1 _2375_/A2 _2379_/A3 _2352_/A2 VDD VDD VSS VSS gf180mcu_fd_sc_mcu7t5v0__nand3_1
XFILLER_69_415 VDD VDD VSS VSS gf180mcu_fd_sc_mcu7t5v0__fillcap_4
X_2282_ _2282_/A1 _2282_/A2 _2284_/A1 VDD VDD VSS VSS gf180mcu_fd_sc_mcu7t5v0__nand2_1
X_1302_ _1302_/A1 _1398_/A2 _1302_/B1 _2160_/C _1303_/A2 VDD VDD VSS VSS gf180mcu_fd_sc_mcu7t5v0__aoi22_1
X_1233_ _1251_/A2 _2246_/A2 _2246_/B1 _1257_/A2 _1234_/A2 VDD VDD VSS VSS gf180mcu_fd_sc_mcu7t5v0__aoi22_1
XFILLER_65_632 VDD VDD VSS VSS gf180mcu_fd_sc_mcu7t5v0__fill_1
XTAP_TAPCELL_ROW_48_830 VDD VSS gf180mcu_fd_sc_mcu7t5v0__filltie
XFILLER_77_492 VDD VDD VSS VSS gf180mcu_fd_sc_mcu7t5v0__fill_2
X_1164_ _1164_/A1 _1164_/A2 _1164_/A3 _1164_/A4 _1164_/Z VDD VDD VSS VSS gf180mcu_fd_sc_mcu7t5v0__or4_1
XFILLER_65_698 VDD VDD VSS VSS gf180mcu_fd_sc_mcu7t5v0__fill_2
X_1095_ _1095_/I _2172_/A1 VDD VDD VSS VSS gf180mcu_fd_sc_mcu7t5v0__clkinv_1
XFILLER_52_337 VDD VDD VSS VSS gf180mcu_fd_sc_mcu7t5v0__fill_1
XFILLER_64_197 VDD VDD VSS VSS gf180mcu_fd_sc_mcu7t5v0__fillcap_8
XTAP_TAPCELL_ROW_86_1290 VDD VSS gf180mcu_fd_sc_mcu7t5v0__filltie
XFILLER_21_702 VDD VDD VSS VSS gf180mcu_fd_sc_mcu7t5v0__fillcap_64
XFILLER_33_551 VDD VDD VSS VSS gf180mcu_fd_sc_mcu7t5v0__fillcap_8
XFILLER_33_562 VDD VDD VSS VSS gf180mcu_fd_sc_mcu7t5v0__fillcap_64
XFILLER_80_679 VDD VDD VSS VSS gf180mcu_fd_sc_mcu7t5v0__fill_2
X_1997_ _1997_/I _1997_/ZN VDD VDD VSS VSS gf180mcu_fd_sc_mcu7t5v0__clkinv_1
XFILLER_115_862 VDD VDD VSS VSS gf180mcu_fd_sc_mcu7t5v0__fillcap_4
X_2549_ _2549_/D _2550_/RN clkload0/I _2549_/Q VDD VDD VSS VSS gf180mcu_fd_sc_mcu7t5v0__dffrnq_1
XFILLER_87_212 VDD VDD VSS VSS gf180mcu_fd_sc_mcu7t5v0__fillcap_16
XTAP_TAPCELL_ROW_89_1319 VDD VSS gf180mcu_fd_sc_mcu7t5v0__filltie
XFILLER_87_278 VDD VDD VSS VSS gf180mcu_fd_sc_mcu7t5v0__fill_2
XFILLER_75_418 VDD VDD VSS VSS gf180mcu_fd_sc_mcu7t5v0__fill_2
XFILLER_56_643 VDD VDD VSS VSS gf180mcu_fd_sc_mcu7t5v0__fillcap_16
XFILLER_43_348 VDD VDD VSS VSS gf180mcu_fd_sc_mcu7t5v0__fill_2
XTAP_TAPCELL_ROW_26_568 VDD VSS gf180mcu_fd_sc_mcu7t5v0__filltie
XFILLER_51_370 VDD VDD VSS VSS gf180mcu_fd_sc_mcu7t5v0__fillcap_4
XTAP_TAPCELL_ROW_54_899 VDD VSS gf180mcu_fd_sc_mcu7t5v0__filltie
XFILLER_3_444 VDD VDD VSS VSS gf180mcu_fd_sc_mcu7t5v0__fillcap_4
XFILLER_79_702 VDD VDD VSS VSS gf180mcu_fd_sc_mcu7t5v0__fillcap_64
Xfanout1212 _1368_/A2 _1432_/A2 VDD VDD VSS VSS gf180mcu_fd_sc_mcu7t5v0__dlyd_1
XFILLER_59_492 VDD VDD VSS VSS gf180mcu_fd_sc_mcu7t5v0__fillcap_64
XTAP_TAPCELL_ROW_70_1091 VDD VSS gf180mcu_fd_sc_mcu7t5v0__filltie
XFILLER_19_356 VDD VDD VSS VSS gf180mcu_fd_sc_mcu7t5v0__fill_2
XFILLER_74_451 VDD VDD VSS VSS gf180mcu_fd_sc_mcu7t5v0__fillcap_4
XFILLER_47_676 VDD VDD VSS VSS gf180mcu_fd_sc_mcu7t5v0__fillcap_16
XFILLER_62_613 VDD VDD VSS VSS gf180mcu_fd_sc_mcu7t5v0__fillcap_8
XTAP_TAPCELL_ROW_45_800 VDD VSS gf180mcu_fd_sc_mcu7t5v0__filltie
XTAP_TAPCELL_ROW_109_1566 VDD VSS gf180mcu_fd_sc_mcu7t5v0__filltie
XFILLER_61_134 VDD VDD VSS VSS gf180mcu_fd_sc_mcu7t5v0__fillcap_4
XFILLER_15_562 VDD VDD VSS VSS gf180mcu_fd_sc_mcu7t5v0__fillcap_64
X_1920_ _1920_/A1 _1938_/A2 _1958_/B1 _1920_/B2 _1921_/I VDD VDD VSS VSS gf180mcu_fd_sc_mcu7t5v0__aoi22_1
XFILLER_30_543 VDD VDD VSS VSS gf180mcu_fd_sc_mcu7t5v0__fillcap_4
X_1851_ _1851_/I _1851_/ZN VDD VDD VSS VSS gf180mcu_fd_sc_mcu7t5v0__clkinv_1
X_1782_ _1972_/A1 _1822_/A2 _1812_/B1 _1972_/B2 _1783_/I VDD VDD VSS VSS gf180mcu_fd_sc_mcu7t5v0__aoi22_1
X_2403_ _2403_/A1 _2776_/I _2433_/B VDD VDD VSS VSS gf180mcu_fd_sc_mcu7t5v0__and2_1
X_2334_ _2374_/A1 _2334_/A2 _2336_/A1 VDD VDD VSS VSS gf180mcu_fd_sc_mcu7t5v0__nand2_1
XFILLER_57_418 VDD VDD VSS VSS gf180mcu_fd_sc_mcu7t5v0__fill_2
X_2265_ _2293_/A1 _2265_/A2 _2266_/A2 VDD VDD VSS VSS gf180mcu_fd_sc_mcu7t5v0__nand2_1
XFILLER_97_598 VDD VDD VSS VSS gf180mcu_fd_sc_mcu7t5v0__fillcap_4
X_2196_ _2196_/A1 _1116_/B _2215_/B _2196_/C _2198_/B1 VDD VDD VSS VSS gf180mcu_fd_sc_mcu7t5v0__oai211_1
X_1216_ _2202_/B _1216_/A2 _1216_/A3 _1217_/B VDD VDD VSS VSS gf180mcu_fd_sc_mcu7t5v0__nand3_1
X_1147_ _2570_/Q _2457_/A1 _1147_/Z VDD VDD VSS VSS gf180mcu_fd_sc_mcu7t5v0__or2_1
XFILLER_37_197 VDD VDD VSS VSS gf180mcu_fd_sc_mcu7t5v0__fillcap_8
XFILLER_52_112 VDD VDD VSS VSS gf180mcu_fd_sc_mcu7t5v0__fill_2
XFILLER_52_134 VDD VDD VSS VSS gf180mcu_fd_sc_mcu7t5v0__fillcap_32
XFILLER_53_679 VDD VDD VSS VSS gf180mcu_fd_sc_mcu7t5v0__fillcap_16
X_1078_ _1078_/I _1208_/B2 VDD VDD VSS VSS gf180mcu_fd_sc_mcu7t5v0__clkinv_1
XFILLER_33_370 VDD VDD VSS VSS gf180mcu_fd_sc_mcu7t5v0__fillcap_16
XTAP_TAPCELL_ROW_23_538 VDD VSS gf180mcu_fd_sc_mcu7t5v0__filltie
XTAP_TAPCELL_ROW_23_527 VDD VSS gf180mcu_fd_sc_mcu7t5v0__filltie
XTAP_TAPCELL_ROW_51_869 VDD VSS gf180mcu_fd_sc_mcu7t5v0__filltie
XFILLER_0_447 VDD VDD VSS VSS gf180mcu_fd_sc_mcu7t5v0__fill_2
Xinput304 tl_h_d_i[31] _1916_/B2 VDD VDD VSS VSS gf180mcu_fd_sc_mcu7t5v0__dlyd_1
Xinput315 tl_h_d_i[41] _1936_/B2 VDD VDD VSS VSS gf180mcu_fd_sc_mcu7t5v0__dlyd_1
Xinput326 tl_h_d_i[51] _1956_/B2 VDD VDD VSS VSS gf180mcu_fd_sc_mcu7t5v0__dlyd_1
Xinput337 tl_h_d_i[61] _2720_/I VDD VDD VSS VSS gf180mcu_fd_sc_mcu7t5v0__clkbuf_2
Xinput348 tl_h_d_i[71] _2730_/I VDD VDD VSS VSS gf180mcu_fd_sc_mcu7t5v0__clkbuf_2
Xinput359 tl_h_d_i[81] _2740_/I VDD VDD VSS VSS gf180mcu_fd_sc_mcu7t5v0__clkbuf_2
XFILLER_29_632 VDD VDD VSS VSS gf180mcu_fd_sc_mcu7t5v0__fillcap_64
XTAP_TAPCELL_ROW_59_969 VDD VSS gf180mcu_fd_sc_mcu7t5v0__filltie
XFILLER_44_613 VDD VDD VSS VSS gf180mcu_fd_sc_mcu7t5v0__fillcap_4
XTAP_TAPCELL_ROW_3_296 VDD VSS gf180mcu_fd_sc_mcu7t5v0__filltie
XFILLER_28_197 VDD VDD VSS VSS gf180mcu_fd_sc_mcu7t5v0__fillcap_8
XFILLER_31_307 VDD VDD VSS VSS gf180mcu_fd_sc_mcu7t5v0__fillcap_32
XFILLER_43_156 VDD VDD VSS VSS gf180mcu_fd_sc_mcu7t5v0__fill_1
XFILLER_43_167 VDD VDD VSS VSS gf180mcu_fd_sc_mcu7t5v0__fill_1
XFILLER_12_521 VDD VDD VSS VSS gf180mcu_fd_sc_mcu7t5v0__fillcap_4
XFILLER_24_381 VDD VDD VSS VSS gf180mcu_fd_sc_mcu7t5v0__fillcap_4
XFILLER_52_690 VDD VDD VSS VSS gf180mcu_fd_sc_mcu7t5v0__fillcap_32
XANTENNA_8 _1447_/ZN VDD VDD VSS VSS gf180mcu_fd_sc_mcu7t5v0__antenna
XTAP_TAPCELL_ROW_72_1120 VDD VSS gf180mcu_fd_sc_mcu7t5v0__filltie
XFILLER_94_535 VDD VDD VSS VSS gf180mcu_fd_sc_mcu7t5v0__fillcap_32
XFILLER_94_524 VDD VDD VSS VSS gf180mcu_fd_sc_mcu7t5v0__fill_1
Xfanout1075 _1183_/ZN fanout1075/Z VDD VDD VSS VSS gf180mcu_fd_sc_mcu7t5v0__dlyd_1
Xfanout1086 _1511_/A1 _1407_/A1 VDD VDD VSS VSS gf180mcu_fd_sc_mcu7t5v0__dlyd_1
X_2050_ _2119_/B2 _2064_/B _2102_/B2 _2119_/A1 _2051_/I VDD VDD VSS VSS gf180mcu_fd_sc_mcu7t5v0__oai22_1
XFILLER_94_579 VDD VDD VSS VSS gf180mcu_fd_sc_mcu7t5v0__fill_1
XFILLER_35_624 VDD VDD VSS VSS gf180mcu_fd_sc_mcu7t5v0__fillcap_4
XFILLER_47_473 VDD VDD VSS VSS gf180mcu_fd_sc_mcu7t5v0__fill_1
XFILLER_34_156 VDD VDD VSS VSS gf180mcu_fd_sc_mcu7t5v0__fillcap_16
XFILLER_50_649 VDD VDD VSS VSS gf180mcu_fd_sc_mcu7t5v0__fill_2
X_1903_ _1903_/I _1903_/ZN VDD VDD VSS VSS gf180mcu_fd_sc_mcu7t5v0__clkinv_1
XFILLER_30_395 VDD VDD VSS VSS gf180mcu_fd_sc_mcu7t5v0__fill_1
X_1834_ _2399_/I0 _1836_/A2 _2533_/A2 _2760_/I _1835_/I VDD VDD VSS VSS gf180mcu_fd_sc_mcu7t5v0__aoi22_1
X_1765_ _1765_/I _1765_/ZN VDD VDD VSS VSS gf180mcu_fd_sc_mcu7t5v0__clkinv_1
X_1696_ _2386_/I0 _1720_/A2 _1720_/B1 _1886_/B2 _1697_/I VDD VDD VSS VSS gf180mcu_fd_sc_mcu7t5v0__aoi22_1
X_2317_ _2317_/A1 _2317_/A2 _2318_/A2 VDD VDD VSS VSS gf180mcu_fd_sc_mcu7t5v0__nand2_1
XFILLER_97_384 VDD VDD VSS VSS gf180mcu_fd_sc_mcu7t5v0__fillcap_4
X_2248_ _2248_/A1 _2248_/A2 _2248_/B _2248_/ZN VDD VDD VSS VSS gf180mcu_fd_sc_mcu7t5v0__oai21_1
XFILLER_85_546 VDD VDD VSS VSS gf180mcu_fd_sc_mcu7t5v0__fill_2
XFILLER_38_451 VDD VDD VSS VSS gf180mcu_fd_sc_mcu7t5v0__fillcap_4
XTAP_TAPCELL_ROW_56_928 VDD VSS gf180mcu_fd_sc_mcu7t5v0__filltie
X_2179_ input44/Z _2247_/A2 _2180_/A2 VDD VDD VSS VSS gf180mcu_fd_sc_mcu7t5v0__nor2_1
XTAP_TAPCELL_ROW_0_244 VDD VSS gf180mcu_fd_sc_mcu7t5v0__filltie
XTAP_TAPCELL_ROW_0_255 VDD VSS gf180mcu_fd_sc_mcu7t5v0__filltie
XFILLER_25_189 VDD VDD VSS VSS gf180mcu_fd_sc_mcu7t5v0__fill_1
XTAP_TAPCELL_ROW_36_685 VDD VSS gf180mcu_fd_sc_mcu7t5v0__filltie
XFILLER_21_362 VDD VDD VSS VSS gf180mcu_fd_sc_mcu7t5v0__fill_1
XTAP_TAPCELL_ROW_97_1418 VDD VSS gf180mcu_fd_sc_mcu7t5v0__filltie
Xinput101 tl_d_esram_i[3] _2119_/B2 VDD VDD VSS VSS gf180mcu_fd_sc_mcu7t5v0__dlyd_1
XTAP_TAPCELL_ROW_8_355 VDD VSS gf180mcu_fd_sc_mcu7t5v0__filltie
Xinput112 tl_d_esram_i[4] _2123_/B2 VDD VDD VSS VSS gf180mcu_fd_sc_mcu7t5v0__dlyd_1
Xinput123 tl_d_esram_i[5] _2126_/B2 VDD VDD VSS VSS gf180mcu_fd_sc_mcu7t5v0__dlyd_1
Xinput134 tl_d_rom_i[0] _1078_/I VDD VDD VSS VSS gf180mcu_fd_sc_mcu7t5v0__dlyd_1
Xinput145 tl_d_rom_i[1] _2112_/A1 VDD VDD VSS VSS gf180mcu_fd_sc_mcu7t5v0__dlyd_1
XFILLER_88_384 VDD VDD VSS VSS gf180mcu_fd_sc_mcu7t5v0__fill_1
XFILLER_76_524 VDD VDD VSS VSS gf180mcu_fd_sc_mcu7t5v0__fill_1
Xinput156 tl_d_rom_i[2] _2116_/A1 VDD VDD VSS VSS gf180mcu_fd_sc_mcu7t5v0__dlyd_1
Xinput167 tl_d_rom_i[3] _2119_/A1 VDD VDD VSS VSS gf180mcu_fd_sc_mcu7t5v0__dlyd_1
Xinput178 tl_d_rom_i[4] _2123_/A1 VDD VDD VSS VSS gf180mcu_fd_sc_mcu7t5v0__dlyd_1
Xinput189 tl_d_rom_i[5] _2126_/A1 VDD VDD VSS VSS gf180mcu_fd_sc_mcu7t5v0__dlyd_1
Xload_slew1211 _2355_/A3 _2363_/A3 VDD VDD VSS VSS gf180mcu_fd_sc_mcu7t5v0__clkbuf_4
Xload_slew1222 _2373_/A1 _2369_/A1 VDD VDD VSS VSS gf180mcu_fd_sc_mcu7t5v0__buf_3
Xload_slew1244 _2587_/RN _2594_/RN VDD VDD VSS VSS gf180mcu_fd_sc_mcu7t5v0__clkbuf_4
XTAP_TAPCELL_ROW_106_1525 VDD VSS gf180mcu_fd_sc_mcu7t5v0__filltie
XPHY_EDGE_ROW_113_Right_113 VDD VSS gf180mcu_fd_sc_mcu7t5v0__endcap
XFILLER_13_863 VDD VDD VSS VSS gf180mcu_fd_sc_mcu7t5v0__fill_2
XFILLER_40_682 VDD VDD VSS VSS gf180mcu_fd_sc_mcu7t5v0__fillcap_32
Xoutput608 _2701_/Z tl_d_esram_o[0] VDD VDD VSS VSS gf180mcu_fd_sc_mcu7t5v0__dlyd_1
X_1550_ _1868_/B2 _1550_/A2 _1550_/Z VDD VDD VSS VSS gf180mcu_fd_sc_mcu7t5v0__or2_1
XTAP_TAPCELL_ROW_117_1665 VDD VSS gf180mcu_fd_sc_mcu7t5v0__filltie
XFILLER_8_399 VDD VDD VSS VSS gf180mcu_fd_sc_mcu7t5v0__fill_2
Xoutput619 _1875_/ZN tl_d_esram_o[10] VDD VDD VSS VSS gf180mcu_fd_sc_mcu7t5v0__dlyd_1
X_1481_ _2199_/A2 _2365_/A2 _1481_/Z VDD VDD VSS VSS gf180mcu_fd_sc_mcu7t5v0__and2_1
X_2102_ _2067_/B _2549_/Q _2227_/A1 _2102_/B2 _2103_/B VDD VDD VSS VSS gf180mcu_fd_sc_mcu7t5v0__oai22_1
XFILLER_94_321 VDD VDD VSS VSS gf180mcu_fd_sc_mcu7t5v0__fill_2
XFILLER_94_365 VDD VDD VSS VSS gf180mcu_fd_sc_mcu7t5v0__fillcap_8
XFILLER_82_527 VDD VDD VSS VSS gf180mcu_fd_sc_mcu7t5v0__fillcap_8
XFILLER_54_229 VDD VDD VSS VSS gf180mcu_fd_sc_mcu7t5v0__fill_1
X_2033_ _2033_/I _2033_/ZN VDD VDD VSS VSS gf180mcu_fd_sc_mcu7t5v0__clkinv_1
XFILLER_62_251 VDD VDD VSS VSS gf180mcu_fd_sc_mcu7t5v0__fill_1
XFILLER_50_457 VDD VDD VSS VSS gf180mcu_fd_sc_mcu7t5v0__fillcap_4
XTAP_TAPCELL_ROW_33_655 VDD VSS gf180mcu_fd_sc_mcu7t5v0__filltie
XTAP_TAPCELL_ROW_61_986 VDD VSS gf180mcu_fd_sc_mcu7t5v0__filltie
XFILLER_30_181 VDD VDD VSS VSS gf180mcu_fd_sc_mcu7t5v0__fill_1
X_1817_ _1817_/I _1817_/ZN VDD VDD VSS VSS gf180mcu_fd_sc_mcu7t5v0__clkinv_1
X_1748_ _1938_/A1 _1768_/A2 _1762_/B1 _1938_/B2 _1749_/I VDD VDD VSS VSS gf180mcu_fd_sc_mcu7t5v0__aoi22_1
X_1679_ _1679_/I _1679_/ZN VDD VDD VSS VSS gf180mcu_fd_sc_mcu7t5v0__clkinv_1
XTAP_TAPCELL_ROW_92_1359 VDD VSS gf180mcu_fd_sc_mcu7t5v0__filltie
XFILLER_58_524 VDD VDD VSS VSS gf180mcu_fd_sc_mcu7t5v0__fill_1
XTAP_TAPCELL_ROW_5_314 VDD VSS gf180mcu_fd_sc_mcu7t5v0__filltie
XFILLER_45_207 VDD VDD VSS VSS gf180mcu_fd_sc_mcu7t5v0__fill_2
XFILLER_54_730 VDD VDD VSS VSS gf180mcu_fd_sc_mcu7t5v0__fillcap_4
XFILLER_85_398 VDD VDD VSS VSS gf180mcu_fd_sc_mcu7t5v0__fillcap_4
XTAP_TAPCELL_ROW_101_1466 VDD VSS gf180mcu_fd_sc_mcu7t5v0__filltie
XPHY_EDGE_ROW_39_Left_158 VDD VSS gf180mcu_fd_sc_mcu7t5v0__endcap
XPHY_EDGE_ROW_2_Left_121 VDD VSS gf180mcu_fd_sc_mcu7t5v0__endcap
XTAP_TAPCELL_ROW_112_1595 VDD VSS gf180mcu_fd_sc_mcu7t5v0__filltie
XFILLER_64_527 VDD VDD VSS VSS gf180mcu_fd_sc_mcu7t5v0__fillcap_4
Xload_slew1052 _2471_/S _2478_/S VDD VDD VSS VSS gf180mcu_fd_sc_mcu7t5v0__buf_2
XFILLER_76_387 VDD VDD VSS VSS gf180mcu_fd_sc_mcu7t5v0__fillcap_16
Xload_slew1074 _1964_/A2 _1982_/A2 VDD VDD VSS VSS gf180mcu_fd_sc_mcu7t5v0__buf_4
Xload_slew1085 _1503_/A1 _1487_/A1 VDD VDD VSS VSS gf180mcu_fd_sc_mcu7t5v0__buf_4
XPHY_EDGE_ROW_48_Left_167 VDD VSS gf180mcu_fd_sc_mcu7t5v0__endcap
XFILLER_44_262 VDD VDD VSS VSS gf180mcu_fd_sc_mcu7t5v0__fillcap_32
XTAP_TAPCELL_ROW_67_1063 VDD VSS gf180mcu_fd_sc_mcu7t5v0__filltie
XFILLER_32_446 VDD VDD VSS VSS gf180mcu_fd_sc_mcu7t5v0__fillcap_8
XFILLER_32_457 VDD VDD VSS VSS gf180mcu_fd_sc_mcu7t5v0__fillcap_64
X_2720_ _2720_/I _2720_/Z VDD VDD VSS VSS gf180mcu_fd_sc_mcu7t5v0__buf_1
XTAP_TAPCELL_ROW_30_614 VDD VSS gf180mcu_fd_sc_mcu7t5v0__filltie
X_2651_ _2723_/I _2651_/Z VDD VDD VSS VSS gf180mcu_fd_sc_mcu7t5v0__buf_1
XFILLER_9_675 VDD VDD VSS VSS gf180mcu_fd_sc_mcu7t5v0__fill_1
X_1602_ _2743_/I _2707_/I _1601_/Z _1602_/Z VDD VDD VSS VSS gf180mcu_fd_sc_mcu7t5v0__xor3_1
XPHY_EDGE_ROW_57_Left_176 VDD VSS gf180mcu_fd_sc_mcu7t5v0__endcap
X_2582_ _2582_/D _2582_/RN _2596_/CLK _2582_/Q VDD VDD VSS VSS gf180mcu_fd_sc_mcu7t5v0__dffrnq_1
XTAP_TAPCELL_ROW_10_382 VDD VSS gf180mcu_fd_sc_mcu7t5v0__filltie
XTAP_TAPCELL_ROW_10_371 VDD VSS gf180mcu_fd_sc_mcu7t5v0__filltie
X_1533_ _1954_/B2 _1533_/A2 _1533_/Z VDD VDD VSS VSS gf180mcu_fd_sc_mcu7t5v0__or2_1
XTAP_TAPCELL_ROW_78_1192 VDD VSS gf180mcu_fd_sc_mcu7t5v0__filltie
X_1464_ _1464_/A1 _1464_/A2 _2357_/A2 VDD VDD VSS VSS gf180mcu_fd_sc_mcu7t5v0__nand2_1
XFILLER_87_619 VDD VDD VSS VSS gf180mcu_fd_sc_mcu7t5v0__fillcap_8
X_1395_ _1467_/A1 _1393_/Z _1395_/B _1396_/B1 VDD VDD VSS VSS gf180mcu_fd_sc_mcu7t5v0__oai21_1
XPHY_EDGE_ROW_66_Left_185 VDD VSS gf180mcu_fd_sc_mcu7t5v0__endcap
XFILLER_94_151 VDD VDD VSS VSS gf180mcu_fd_sc_mcu7t5v0__fill_2
XTAP_TAPCELL_ROW_38_714 VDD VSS gf180mcu_fd_sc_mcu7t5v0__filltie
XFILLER_83_858 VDD VDD VSS VSS gf180mcu_fd_sc_mcu7t5v0__fillcap_8
XFILLER_82_313 VDD VDD VSS VSS gf180mcu_fd_sc_mcu7t5v0__fill_2
X_2016_ _2395_/I0 _2022_/A2 _2022_/B1 _2756_/I _2017_/I VDD VDD VSS VSS gf180mcu_fd_sc_mcu7t5v0__aoi22_1
XFILLER_51_766 VDD VDD VSS VSS gf180mcu_fd_sc_mcu7t5v0__fillcap_4
XTAP_TAPCELL_ROW_18_471 VDD VSS gf180mcu_fd_sc_mcu7t5v0__filltie
XFILLER_50_243 VDD VDD VSS VSS gf180mcu_fd_sc_mcu7t5v0__fill_2
XPHY_EDGE_ROW_75_Left_194 VDD VSS gf180mcu_fd_sc_mcu7t5v0__endcap
Xoutput961 _2180_/ZN tl_h_d_o[48] VDD VDD VSS VSS gf180mcu_fd_sc_mcu7t5v0__dlyd_1
Xoutput972 _2237_/ZN tl_h_d_o[58] VDD VDD VSS VSS gf180mcu_fd_sc_mcu7t5v0__dlyd_1
Xoutput950 _1439_/ZN tl_h_d_o[38] VDD VDD VSS VSS gf180mcu_fd_sc_mcu7t5v0__dlyd_1
Xoutput983 _2138_/ZN tl_h_d_o[8] VDD VDD VSS VSS gf180mcu_fd_sc_mcu7t5v0__dlyd_1
Xoutput994 _2264_/ZN tl_h_i_o[18] VDD VDD VSS VSS gf180mcu_fd_sc_mcu7t5v0__dlyd_1
XFILLER_58_321 VDD VDD VSS VSS gf180mcu_fd_sc_mcu7t5v0__fill_1
XFILLER_46_527 VDD VDD VSS VSS gf180mcu_fd_sc_mcu7t5v0__fillcap_4
XFILLER_58_387 VDD VDD VSS VSS gf180mcu_fd_sc_mcu7t5v0__fillcap_32
XFILLER_85_162 VDD VDD VSS VSS gf180mcu_fd_sc_mcu7t5v0__fillcap_16
XFILLER_61_508 VDD VDD VSS VSS gf180mcu_fd_sc_mcu7t5v0__fill_2
XFILLER_14_457 VDD VDD VSS VSS gf180mcu_fd_sc_mcu7t5v0__fillcap_64
XFILLER_41_298 VDD VDD VSS VSS gf180mcu_fd_sc_mcu7t5v0__fillcap_4
XTAP_TAPCELL_ROW_114_1624 VDD VSS gf180mcu_fd_sc_mcu7t5v0__filltie
XFILLER_68_107 VDD VDD VSS VSS gf180mcu_fd_sc_mcu7t5v0__fillcap_32
X_1180_ _1190_/A1 _1190_/A2 _1190_/C _1209_/A1 VDD VDD VSS VSS gf180mcu_fd_sc_mcu7t5v0__aoi21_1
XFILLER_65_858 VDD VDD VSS VSS gf180mcu_fd_sc_mcu7t5v0__fillcap_8
XFILLER_77_696 VDD VDD VSS VSS gf180mcu_fd_sc_mcu7t5v0__fillcap_4
XFILLER_76_173 VDD VDD VSS VSS gf180mcu_fd_sc_mcu7t5v0__fill_2
XFILLER_33_766 VDD VDD VSS VSS gf180mcu_fd_sc_mcu7t5v0__fillcap_4
XTAP_TAPCELL_ROW_15_441 VDD VSS gf180mcu_fd_sc_mcu7t5v0__filltie
XFILLER_32_287 VDD VDD VSS VSS gf180mcu_fd_sc_mcu7t5v0__fillcap_4
XTAP_TAPCELL_ROW_43_772 VDD VSS gf180mcu_fd_sc_mcu7t5v0__filltie
XFILLER_118_348 VDD VDD VSS VSS gf180mcu_fd_sc_mcu7t5v0__fill_2
X_2703_ _2703_/I _2703_/Z VDD VDD VSS VSS gf180mcu_fd_sc_mcu7t5v0__buf_1
X_2634_ _2706_/I _2634_/Z VDD VDD VSS VSS gf180mcu_fd_sc_mcu7t5v0__buf_1
X_2565_ _2565_/D _2567_/RN clkload2/I _2565_/Q VDD VDD VSS VSS gf180mcu_fd_sc_mcu7t5v0__dffrnq_1
X_1516_ _1920_/B2 _1550_/A2 _1516_/Z VDD VDD VSS VSS gf180mcu_fd_sc_mcu7t5v0__or2_1
X_2496_ _2507_/B _2494_/Z _2496_/B _2591_/D VDD VDD VSS VSS gf180mcu_fd_sc_mcu7t5v0__oai21_1
X_1447_ _1503_/A1 _1447_/A2 _1447_/ZN VDD VDD VSS VSS gf180mcu_fd_sc_mcu7t5v0__nor2_1
XFILLER_68_663 VDD VDD VSS VSS gf180mcu_fd_sc_mcu7t5v0__fill_2
X_1378_ input92/Z _1490_/A2 _2363_/A3 _1379_/B VDD VDD VSS VSS gf180mcu_fd_sc_mcu7t5v0__nand3_1
XFILLER_83_600 VDD VDD VSS VSS gf180mcu_fd_sc_mcu7t5v0__fillcap_16
XFILLER_28_527 VDD VDD VSS VSS gf180mcu_fd_sc_mcu7t5v0__fillcap_32
XFILLER_68_685 VDD VDD VSS VSS gf180mcu_fd_sc_mcu7t5v0__fill_1
XFILLER_55_335 VDD VDD VSS VSS gf180mcu_fd_sc_mcu7t5v0__fillcap_8
XFILLER_36_571 VDD VDD VSS VSS gf180mcu_fd_sc_mcu7t5v0__fillcap_16
XFILLER_55_379 VDD VDD VSS VSS gf180mcu_fd_sc_mcu7t5v0__fill_1
XFILLER_23_232 VDD VDD VSS VSS gf180mcu_fd_sc_mcu7t5v0__fill_1
XFILLER_11_416 VDD VDD VSS VSS gf180mcu_fd_sc_mcu7t5v0__fillcap_4
XFILLER_23_298 VDD VDD VSS VSS gf180mcu_fd_sc_mcu7t5v0__fillcap_8
XPHY_EDGE_ROW_83_Left_202 VDD VSS gf180mcu_fd_sc_mcu7t5v0__endcap
Xoutput780 _1791_/ZN tl_d_rom_o[63] VDD VDD VSS VSS gf180mcu_fd_sc_mcu7t5v0__dlyd_1
XPHY_EDGE_ROW_92_Left_211 VDD VSS gf180mcu_fd_sc_mcu7t5v0__endcap
XFILLER_48_10 VDD VDD VSS VSS gf180mcu_fd_sc_mcu7t5v0__fillcap_4
XFILLER_48_21 VDD VDD VSS VSS gf180mcu_fd_sc_mcu7t5v0__fillcap_8
Xoutput791 _1811_/ZN tl_d_rom_o[73] VDD VDD VSS VSS gf180mcu_fd_sc_mcu7t5v0__dlyd_1
XFILLER_46_302 VDD VDD VSS VSS gf180mcu_fd_sc_mcu7t5v0__fill_1
XFILLER_59_696 VDD VDD VSS VSS gf180mcu_fd_sc_mcu7t5v0__fillcap_4
XFILLER_64_75 VDD VDD VSS VSS gf180mcu_fd_sc_mcu7t5v0__fill_1
XTAP_TAPCELL_ROW_64_1022 VDD VSS gf180mcu_fd_sc_mcu7t5v0__filltie
XTAP_TAPCELL_ROW_29_599 VDD VSS gf180mcu_fd_sc_mcu7t5v0__filltie
XFILLER_15_766 VDD VDD VSS VSS gf180mcu_fd_sc_mcu7t5v0__fillcap_4
XFILLER_14_276 VDD VDD VSS VSS gf180mcu_fd_sc_mcu7t5v0__fillcap_4
XTAP_TAPCELL_ROW_12_400 VDD VSS gf180mcu_fd_sc_mcu7t5v0__filltie
XTAP_TAPCELL_ROW_40_742 VDD VSS gf180mcu_fd_sc_mcu7t5v0__filltie
XTAP_TAPCELL_ROW_40_731 VDD VSS gf180mcu_fd_sc_mcu7t5v0__filltie
XTAP_TAPCELL_ROW_75_1162 VDD VSS gf180mcu_fd_sc_mcu7t5v0__filltie
XTAP_TAPCELL_ROW_75_1151 VDD VSS gf180mcu_fd_sc_mcu7t5v0__filltie
X_2350_ _2374_/A1 _2350_/A2 _2352_/A1 VDD VDD VSS VSS gf180mcu_fd_sc_mcu7t5v0__nand2_1
X_2281_ _2293_/A1 _2281_/A2 _2282_/A2 VDD VDD VSS VSS gf180mcu_fd_sc_mcu7t5v0__nand2_1
X_1301_ _1301_/I _1302_/B1 VDD VDD VSS VSS gf180mcu_fd_sc_mcu7t5v0__clkinv_1
X_1232_ _1232_/A1 _1232_/A2 _2701_/I VDD VDD VSS VSS gf180mcu_fd_sc_mcu7t5v0__nand2_1
XFILLER_77_482 VDD VDD VSS VSS gf180mcu_fd_sc_mcu7t5v0__fillcap_8
XFILLER_37_346 VDD VDD VSS VSS gf180mcu_fd_sc_mcu7t5v0__fillcap_4
X_1163_ _1164_/A1 _1164_/A2 _1164_/A3 _1164_/A4 _1174_/A3 VDD VDD VSS VSS gf180mcu_fd_sc_mcu7t5v0__nor4_1
XTAP_TAPCELL_ROW_48_831 VDD VSS gf180mcu_fd_sc_mcu7t5v0__filltie
X_1094_ _1094_/I _2168_/A1 VDD VDD VSS VSS gf180mcu_fd_sc_mcu7t5v0__clkinv_1
XTAP_TAPCELL_ROW_86_1291 VDD VSS gf180mcu_fd_sc_mcu7t5v0__filltie
XFILLER_92_496 VDD VDD VSS VSS gf180mcu_fd_sc_mcu7t5v0__fill_1
XFILLER_100_18 VDD VDD VSS VSS gf180mcu_fd_sc_mcu7t5v0__fill_1
XFILLER_60_382 VDD VDD VSS VSS gf180mcu_fd_sc_mcu7t5v0__fill_2
X_1996_ _1996_/A1 _2022_/A2 _1998_/B1 _2730_/I _1997_/I VDD VDD VSS VSS gf180mcu_fd_sc_mcu7t5v0__aoi22_1
X_2548_ _2548_/D _2587_/RN clkload4/I _2548_/Q VDD VDD VSS VSS gf180mcu_fd_sc_mcu7t5v0__dffrnq_1
XFILLER_88_703 VDD VDD VSS VSS gf180mcu_fd_sc_mcu7t5v0__fill_1
XFILLER_102_524 VDD VDD VSS VSS gf180mcu_fd_sc_mcu7t5v0__fill_1
X_2479_ _2705_/I _2774_/I _2527_/A2 VDD VDD VSS VSS gf180mcu_fd_sc_mcu7t5v0__nand2_1
XFILLER_87_257 VDD VDD VSS VSS gf180mcu_fd_sc_mcu7t5v0__fill_2
XFILLER_28_313 VDD VDD VSS VSS gf180mcu_fd_sc_mcu7t5v0__fill_2
XFILLER_29_858 VDD VDD VSS VSS gf180mcu_fd_sc_mcu7t5v0__fillcap_8
XFILLER_83_496 VDD VDD VSS VSS gf180mcu_fd_sc_mcu7t5v0__fill_2
XTAP_TAPCELL_ROW_26_569 VDD VSS gf180mcu_fd_sc_mcu7t5v0__filltie
Xclkload0 clkload0/I clkload0/ZN VDD VDD VSS VSS gf180mcu_fd_sc_mcu7t5v0__inv_3
XFILLER_3_489 VDD VDD VSS VSS gf180mcu_fd_sc_mcu7t5v0__fill_1
Xfanout1202 fanout1206/Z _2331_/A3 VDD VDD VSS VSS gf180mcu_fd_sc_mcu7t5v0__dlyd_1
Xfanout1224 _1126_/ZN _2251_/A3 VDD VDD VSS VSS gf180mcu_fd_sc_mcu7t5v0__dlyd_1
Xfanout1246 input1/Z _2600_/RN VDD VDD VSS VSS gf180mcu_fd_sc_mcu7t5v0__dlyd_1
XTAP_TAPCELL_ROW_70_1092 VDD VSS gf180mcu_fd_sc_mcu7t5v0__filltie
XFILLER_93_227 VDD VDD VSS VSS gf180mcu_fd_sc_mcu7t5v0__fill_1
XFILLER_19_346 VDD VDD VSS VSS gf180mcu_fd_sc_mcu7t5v0__fillcap_4
XFILLER_47_644 VDD VDD VSS VSS gf180mcu_fd_sc_mcu7t5v0__fillcap_32
XTAP_TAPCELL_ROW_45_801 VDD VSS gf180mcu_fd_sc_mcu7t5v0__filltie
XTAP_TAPCELL_ROW_109_1567 VDD VSS gf180mcu_fd_sc_mcu7t5v0__filltie
XFILLER_27_390 VDD VDD VSS VSS gf180mcu_fd_sc_mcu7t5v0__fill_1
XFILLER_30_511 VDD VDD VSS VSS gf180mcu_fd_sc_mcu7t5v0__fill_2
X_1850_ _2389_/I0 _1854_/A2 _1850_/B1 _2769_/I _1851_/I VDD VDD VSS VSS gf180mcu_fd_sc_mcu7t5v0__aoi22_1
X_1781_ _1781_/I _1781_/ZN VDD VDD VSS VSS gf180mcu_fd_sc_mcu7t5v0__clkinv_1
X_2402_ _2402_/I0 _2558_/Q _2402_/S _2558_/D VDD VDD VSS VSS gf180mcu_fd_sc_mcu7t5v0__mux2_2
XFILLER_34_2 VDD VDD VSS VSS gf180mcu_fd_sc_mcu7t5v0__fill_2
X_2333_ _2333_/A1 _2333_/A2 _2334_/A2 VDD VDD VSS VSS gf180mcu_fd_sc_mcu7t5v0__nand2_1
XFILLER_97_544 VDD VDD VSS VSS gf180mcu_fd_sc_mcu7t5v0__fill_2
X_2264_ _2264_/A1 _2264_/A2 _2296_/B _2264_/ZN VDD VDD VSS VSS gf180mcu_fd_sc_mcu7t5v0__aoi21_1
XFILLER_69_279 VDD VDD VSS VSS gf180mcu_fd_sc_mcu7t5v0__fill_1
X_2195_ _1116_/B _2195_/A2 _2195_/A3 _2196_/C VDD VDD VSS VSS gf180mcu_fd_sc_mcu7t5v0__nand3_1
X_1215_ _1215_/A1 _2231_/C _1218_/A1 VDD VDD VSS VSS gf180mcu_fd_sc_mcu7t5v0__nand2_1
XFILLER_65_474 VDD VDD VSS VSS gf180mcu_fd_sc_mcu7t5v0__fill_2
X_1146_ _1146_/A1 _1146_/A2 _2568_/Q _1146_/C _1149_/C VDD VDD VSS VSS gf180mcu_fd_sc_mcu7t5v0__aoi211_1
XFILLER_25_349 VDD VDD VSS VSS gf180mcu_fd_sc_mcu7t5v0__fill_1
X_1077_ _1077_/I _2534_/A1 VDD VDD VSS VSS gf180mcu_fd_sc_mcu7t5v0__clkinv_1
XTAP_TAPCELL_ROW_23_528 VDD VSS gf180mcu_fd_sc_mcu7t5v0__filltie
XFILLER_80_499 VDD VDD VSS VSS gf180mcu_fd_sc_mcu7t5v0__fillcap_16
X_1979_ _1979_/I _1979_/ZN VDD VDD VSS VSS gf180mcu_fd_sc_mcu7t5v0__clkinv_1
XFILLER_106_104 VDD VDD VSS VSS gf180mcu_fd_sc_mcu7t5v0__fill_1
Xinput305 tl_h_d_i[32] _1918_/B2 VDD VDD VSS VSS gf180mcu_fd_sc_mcu7t5v0__dlyd_1
Xinput316 tl_h_d_i[42] _1938_/B2 VDD VDD VSS VSS gf180mcu_fd_sc_mcu7t5v0__dlyd_1
Xinput327 tl_h_d_i[52] _1958_/B2 VDD VDD VSS VSS gf180mcu_fd_sc_mcu7t5v0__dlyd_1
XFILLER_102_387 VDD VDD VSS VSS gf180mcu_fd_sc_mcu7t5v0__fillcap_8
Xinput338 tl_h_d_i[62] _2721_/I VDD VDD VSS VSS gf180mcu_fd_sc_mcu7t5v0__clkbuf_2
Xinput349 tl_h_d_i[72] _2731_/I VDD VDD VSS VSS gf180mcu_fd_sc_mcu7t5v0__clkbuf_2
XFILLER_76_728 VDD VDD VSS VSS gf180mcu_fd_sc_mcu7t5v0__fill_1
XTAP_TAPCELL_ROW_59_959 VDD VSS gf180mcu_fd_sc_mcu7t5v0__filltie
XTAP_TAPCELL_ROW_3_297 VDD VSS gf180mcu_fd_sc_mcu7t5v0__filltie
XFILLER_83_282 VDD VDD VSS VSS gf180mcu_fd_sc_mcu7t5v0__fillcap_16
XFILLER_71_422 VDD VDD VSS VSS gf180mcu_fd_sc_mcu7t5v0__fillcap_8
XFILLER_40_831 VDD VDD VSS VSS gf180mcu_fd_sc_mcu7t5v0__fill_1
XFILLER_6_16 VDD VDD VSS VSS gf180mcu_fd_sc_mcu7t5v0__fill_1
XANTENNA_9 _1463_/ZN VDD VDD VSS VSS gf180mcu_fd_sc_mcu7t5v0__antenna
XPHY_EDGE_ROW_20_Left_139 VDD VSS gf180mcu_fd_sc_mcu7t5v0__endcap
XTAP_TAPCELL_ROW_72_1121 VDD VSS gf180mcu_fd_sc_mcu7t5v0__filltie
Xfanout1065 _1184_/ZN _2030_/B1 VDD VDD VSS VSS gf180mcu_fd_sc_mcu7t5v0__dlyd_1
Xfanout1098 _1830_/A2 _1854_/A2 VDD VDD VSS VSS gf180mcu_fd_sc_mcu7t5v0__dlyd_1
XFILLER_74_260 VDD VDD VSS VSS gf180mcu_fd_sc_mcu7t5v0__fillcap_8
XFILLER_90_731 VDD VDD VSS VSS gf180mcu_fd_sc_mcu7t5v0__fillcap_4
XFILLER_62_444 VDD VDD VSS VSS gf180mcu_fd_sc_mcu7t5v0__fill_2
XTAP_TAPCELL_ROW_83_1250 VDD VSS gf180mcu_fd_sc_mcu7t5v0__filltie
XFILLER_31_842 VDD VDD VSS VSS gf180mcu_fd_sc_mcu7t5v0__fillcap_16
X_1902_ _1902_/A1 _2534_/A2 _2537_/A2 _2715_/I _1903_/I VDD VDD VSS VSS gf180mcu_fd_sc_mcu7t5v0__aoi22_1
X_1833_ _1833_/I _1833_/ZN VDD VDD VSS VSS gf180mcu_fd_sc_mcu7t5v0__clkinv_1
X_1764_ _1954_/A1 _1818_/A2 _1838_/B1 _1954_/B2 _1765_/I VDD VDD VSS VSS gf180mcu_fd_sc_mcu7t5v0__aoi22_1
X_1695_ _1695_/I _1695_/ZN VDD VDD VSS VSS gf180mcu_fd_sc_mcu7t5v0__clkinv_1
XTAP_TAPCELL_ROW_94_1390 VDD VSS gf180mcu_fd_sc_mcu7t5v0__filltie
XFILLER_98_831 VDD VDD VSS VSS gf180mcu_fd_sc_mcu7t5v0__fill_1
XFILLER_97_352 VDD VDD VSS VSS gf180mcu_fd_sc_mcu7t5v0__fillcap_32
X_2316_ _2316_/A1 _2316_/A2 _2360_/B _2316_/ZN VDD VDD VSS VSS gf180mcu_fd_sc_mcu7t5v0__aoi21_1
XFILLER_85_514 VDD VDD VSS VSS gf180mcu_fd_sc_mcu7t5v0__fillcap_32
X_2247_ input59/Z _2247_/A2 _2248_/A2 VDD VDD VSS VSS gf180mcu_fd_sc_mcu7t5v0__nor2_1
XTAP_TAPCELL_ROW_56_929 VDD VSS gf180mcu_fd_sc_mcu7t5v0__filltie
XFILLER_53_422 VDD VDD VSS VSS gf180mcu_fd_sc_mcu7t5v0__fillcap_64
XFILLER_65_282 VDD VDD VSS VSS gf180mcu_fd_sc_mcu7t5v0__fillcap_16
X_2178_ _2178_/A1 _2238_/A2 _2238_/B1 _2178_/B2 _2178_/C _2180_/A1 VDD VDD VSS VSS
+ gf180mcu_fd_sc_mcu7t5v0__aoi221_1
XTAP_TAPCELL_ROW_0_245 VDD VSS gf180mcu_fd_sc_mcu7t5v0__filltie
X_1129_ _2749_/I _2748_/I _2752_/I _2755_/I _1141_/A1 VDD VDD VSS VSS gf180mcu_fd_sc_mcu7t5v0__nor4_1
XTAP_TAPCELL_ROW_0_256 VDD VSS gf180mcu_fd_sc_mcu7t5v0__filltie
XFILLER_41_628 VDD VDD VSS VSS gf180mcu_fd_sc_mcu7t5v0__fill_2
XTAP_TAPCELL_ROW_36_686 VDD VSS gf180mcu_fd_sc_mcu7t5v0__filltie
XFILLER_80_274 VDD VDD VSS VSS gf180mcu_fd_sc_mcu7t5v0__fill_1
XFILLER_22_831 VDD VDD VSS VSS gf180mcu_fd_sc_mcu7t5v0__fill_1
XFILLER_21_352 VDD VDD VSS VSS gf180mcu_fd_sc_mcu7t5v0__fillcap_8
XTAP_TAPCELL_ROW_97_1419 VDD VSS gf180mcu_fd_sc_mcu7t5v0__filltie
XFILLER_89_842 VDD VDD VSS VSS gf180mcu_fd_sc_mcu7t5v0__fillcap_16
Xinput102 tl_d_esram_i[40] _2351_/A1 VDD VDD VSS VSS gf180mcu_fd_sc_mcu7t5v0__dlyd_1
XTAP_TAPCELL_ROW_8_356 VDD VSS gf180mcu_fd_sc_mcu7t5v0__filltie
Xinput113 tl_d_esram_i[50] _2184_/A1 VDD VDD VSS VSS gf180mcu_fd_sc_mcu7t5v0__dlyd_1
Xinput124 tl_d_esram_i[60] _2242_/B2 VDD VDD VSS VSS gf180mcu_fd_sc_mcu7t5v0__dlyd_1
Xinput135 tl_d_rom_i[10] _2148_/A1 VDD VDD VSS VSS gf180mcu_fd_sc_mcu7t5v0__dlyd_1
Xinput146 tl_d_rom_i[20] _1288_/A1 VDD VDD VSS VSS gf180mcu_fd_sc_mcu7t5v0__dlyd_1
Xinput157 tl_d_rom_i[30] _1368_/A1 VDD VDD VSS VSS gf180mcu_fd_sc_mcu7t5v0__dlyd_1
Xinput168 tl_d_rom_i[40] _1448_/A1 VDD VDD VSS VSS gf180mcu_fd_sc_mcu7t5v0__dlyd_1
XFILLER_57_772 VDD VDD VSS VSS gf180mcu_fd_sc_mcu7t5v0__fillcap_32
Xinput179 tl_d_rom_i[50] _2181_/A1 VDD VDD VSS VSS gf180mcu_fd_sc_mcu7t5v0__dlyd_1
Xload_slew1223 fanout1221/Z _2373_/A1 VDD VDD VSS VSS gf180mcu_fd_sc_mcu7t5v0__clkbuf_4
Xload_slew1234 _2771_/I _2699_/I VDD VDD VSS VSS gf180mcu_fd_sc_mcu7t5v0__buf_4
XFILLER_29_474 VDD VDD VSS VSS gf180mcu_fd_sc_mcu7t5v0__fillcap_16
Xload_slew1245 _2586_/RN _2587_/RN VDD VDD VSS VSS gf180mcu_fd_sc_mcu7t5v0__buf_4
XTAP_TAPCELL_ROW_106_1526 VDD VSS gf180mcu_fd_sc_mcu7t5v0__filltie
XFILLER_84_591 VDD VDD VSS VSS gf180mcu_fd_sc_mcu7t5v0__fillcap_4
XPHY_EDGE_ROW_19_Right_19 VDD VSS gf180mcu_fd_sc_mcu7t5v0__endcap
XFILLER_13_842 VDD VDD VSS VSS gf180mcu_fd_sc_mcu7t5v0__fillcap_4
XFILLER_40_661 VDD VDD VSS VSS gf180mcu_fd_sc_mcu7t5v0__fillcap_4
XFILLER_9_846 VDD VDD VSS VSS gf180mcu_fd_sc_mcu7t5v0__fill_1
Xoutput609 _2021_/ZN tl_d_esram_o[100] VDD VDD VSS VSS gf180mcu_fd_sc_mcu7t5v0__dlyd_1
XTAP_TAPCELL_ROW_117_1655 VDD VSS gf180mcu_fd_sc_mcu7t5v0__filltie
XTAP_TAPCELL_ROW_117_1666 VDD VSS gf180mcu_fd_sc_mcu7t5v0__filltie
XPHY_EDGE_ROW_28_Right_28 VDD VSS gf180mcu_fd_sc_mcu7t5v0__endcap
X_1480_ _1480_/A1 _1496_/A2 _2365_/A2 VDD VDD VSS VSS gf180mcu_fd_sc_mcu7t5v0__nand2_1
XFILLER_79_352 VDD VDD VSS VSS gf180mcu_fd_sc_mcu7t5v0__fillcap_16
XFILLER_39_205 VDD VDD VSS VSS gf180mcu_fd_sc_mcu7t5v0__fillcap_4
XFILLER_0_790 VDD VDD VSS VSS gf180mcu_fd_sc_mcu7t5v0__fillcap_16
XFILLER_39_238 VDD VDD VSS VSS gf180mcu_fd_sc_mcu7t5v0__fill_1
XFILLER_67_558 VDD VDD VSS VSS gf180mcu_fd_sc_mcu7t5v0__fill_2
X_2101_ _1066_/I _2558_/Q _2101_/Z VDD VDD VSS VSS gf180mcu_fd_sc_mcu7t5v0__and2_1
X_2032_ _2394_/I0 _2044_/A2 _2038_/B1 _2765_/I _2033_/I VDD VDD VSS VSS gf180mcu_fd_sc_mcu7t5v0__aoi22_1
XFILLER_94_377 VDD VDD VSS VSS gf180mcu_fd_sc_mcu7t5v0__fill_1
XFILLER_35_422 VDD VDD VSS VSS gf180mcu_fd_sc_mcu7t5v0__fillcap_64
XFILLER_47_282 VDD VDD VSS VSS gf180mcu_fd_sc_mcu7t5v0__fillcap_8
XPHY_EDGE_ROW_37_Right_37 VDD VSS gf180mcu_fd_sc_mcu7t5v0__endcap
XFILLER_63_764 VDD VDD VSS VSS gf180mcu_fd_sc_mcu7t5v0__fillcap_4
XTAP_TAPCELL_ROW_61_987 VDD VSS gf180mcu_fd_sc_mcu7t5v0__filltie
XTAP_TAPCELL_ROW_33_656 VDD VSS gf180mcu_fd_sc_mcu7t5v0__filltie
X_1816_ _2006_/A1 _1818_/A2 _1838_/B1 _2735_/I _1817_/I VDD VDD VSS VSS gf180mcu_fd_sc_mcu7t5v0__aoi22_1
XPHY_EDGE_ROW_46_Right_46 VDD VSS gf180mcu_fd_sc_mcu7t5v0__endcap
X_1747_ _1747_/I _1747_/ZN VDD VDD VSS VSS gf180mcu_fd_sc_mcu7t5v0__clkinv_1
X_1678_ _1868_/A1 _1720_/A2 _1720_/B1 _1868_/B2 _1679_/I VDD VDD VSS VSS gf180mcu_fd_sc_mcu7t5v0__aoi22_1
XFILLER_58_514 VDD VDD VSS VSS gf180mcu_fd_sc_mcu7t5v0__fillcap_8
XTAP_TAPCELL_ROW_5_315 VDD VSS gf180mcu_fd_sc_mcu7t5v0__filltie
XFILLER_86_823 VDD VDD VSS VSS gf180mcu_fd_sc_mcu7t5v0__fillcap_8
XFILLER_58_569 VDD VDD VSS VSS gf180mcu_fd_sc_mcu7t5v0__fillcap_16
XPHY_EDGE_ROW_55_Right_55 VDD VSS gf180mcu_fd_sc_mcu7t5v0__endcap
XFILLER_38_271 VDD VDD VSS VSS gf180mcu_fd_sc_mcu7t5v0__fill_1
XFILLER_53_241 VDD VDD VSS VSS gf180mcu_fd_sc_mcu7t5v0__fillcap_4
XFILLER_22_661 VDD VDD VSS VSS gf180mcu_fd_sc_mcu7t5v0__fillcap_4
XFILLER_42_12 VDD VDD VSS VSS gf180mcu_fd_sc_mcu7t5v0__fill_1
XFILLER_10_823 VDD VDD VSS VSS gf180mcu_fd_sc_mcu7t5v0__fillcap_8
XTAP_TAPCELL_ROW_101_1467 VDD VSS gf180mcu_fd_sc_mcu7t5v0__filltie
XPHY_EDGE_ROW_64_Right_64 VDD VSS gf180mcu_fd_sc_mcu7t5v0__endcap
XFILLER_49_547 VDD VDD VSS VSS gf180mcu_fd_sc_mcu7t5v0__fillcap_8
XTAP_TAPCELL_ROW_112_1596 VDD VSS gf180mcu_fd_sc_mcu7t5v0__filltie
XPHY_EDGE_ROW_73_Right_73 VDD VSS gf180mcu_fd_sc_mcu7t5v0__endcap
XFILLER_88_182 VDD VDD VSS VSS gf180mcu_fd_sc_mcu7t5v0__fillcap_32
XFILLER_76_333 VDD VDD VSS VSS gf180mcu_fd_sc_mcu7t5v0__fillcap_4
XFILLER_17_422 VDD VDD VSS VSS gf180mcu_fd_sc_mcu7t5v0__fillcap_64
XFILLER_29_282 VDD VDD VSS VSS gf180mcu_fd_sc_mcu7t5v0__fill_2
Xload_slew1053 _2476_/S _2471_/S VDD VDD VSS VSS gf180mcu_fd_sc_mcu7t5v0__buf_4
Xload_slew1064 _2022_/B1 _2014_/B1 VDD VDD VSS VSS gf180mcu_fd_sc_mcu7t5v0__buf_4
XPHY_EDGE_ROW_103_Left_222 VDD VSS gf180mcu_fd_sc_mcu7t5v0__endcap
Xload_slew1097 _1836_/A2 _1818_/A2 VDD VDD VSS VSS gf180mcu_fd_sc_mcu7t5v0__clkbuf_4
XTAP_TAPCELL_ROW_67_1064 VDD VSS gf180mcu_fd_sc_mcu7t5v0__filltie
XFILLER_72_583 VDD VDD VSS VSS gf180mcu_fd_sc_mcu7t5v0__fillcap_8
XFILLER_44_296 VDD VDD VSS VSS gf180mcu_fd_sc_mcu7t5v0__fill_1
XTAP_TAPCELL_ROW_80_1220 VDD VSS gf180mcu_fd_sc_mcu7t5v0__filltie
XPHY_EDGE_ROW_82_Right_82 VDD VSS gf180mcu_fd_sc_mcu7t5v0__endcap
XTAP_TAPCELL_ROW_30_615 VDD VSS gf180mcu_fd_sc_mcu7t5v0__filltie
XFILLER_9_632 VDD VDD VSS VSS gf180mcu_fd_sc_mcu7t5v0__fillcap_4
X_2650_ _2722_/I _2650_/Z VDD VDD VSS VSS gf180mcu_fd_sc_mcu7t5v0__buf_1
X_1601_ _2741_/I _2723_/I _2724_/I _1601_/Z VDD VDD VSS VSS gf180mcu_fd_sc_mcu7t5v0__xor3_1
XFILLER_9_698 VDD VDD VSS VSS gf180mcu_fd_sc_mcu7t5v0__fill_2
X_2581_ _2581_/D _2582_/RN _2596_/CLK _2581_/Q VDD VDD VSS VSS gf180mcu_fd_sc_mcu7t5v0__dffrnq_1
XTAP_TAPCELL_ROW_10_372 VDD VSS gf180mcu_fd_sc_mcu7t5v0__filltie
XPHY_EDGE_ROW_112_Left_231 VDD VSS gf180mcu_fd_sc_mcu7t5v0__endcap
X_1532_ _1952_/B2 _1533_/A2 _1532_/Z VDD VDD VSS VSS gf180mcu_fd_sc_mcu7t5v0__or2_1
XTAP_TAPCELL_ROW_78_1193 VDD VSS gf180mcu_fd_sc_mcu7t5v0__filltie
X_1463_ _1487_/A1 _1463_/A2 _1463_/ZN VDD VDD VSS VSS gf180mcu_fd_sc_mcu7t5v0__nor2_1
XPHY_EDGE_ROW_91_Right_91 VDD VSS gf180mcu_fd_sc_mcu7t5v0__endcap
XFILLER_68_823 VDD VDD VSS VSS gf180mcu_fd_sc_mcu7t5v0__fillcap_8
XFILLER_68_801 VDD VDD VSS VSS gf180mcu_fd_sc_mcu7t5v0__fillcap_4
X_1394_ input94/Z _2116_/B1 _2331_/A3 _1395_/B VDD VDD VSS VSS gf180mcu_fd_sc_mcu7t5v0__nand3_1
XFILLER_55_517 VDD VDD VSS VSS gf180mcu_fd_sc_mcu7t5v0__fill_1
XTAP_TAPCELL_ROW_38_715 VDD VSS gf180mcu_fd_sc_mcu7t5v0__filltie
XFILLER_82_325 VDD VDD VSS VSS gf180mcu_fd_sc_mcu7t5v0__fillcap_16
XFILLER_36_731 VDD VDD VSS VSS gf180mcu_fd_sc_mcu7t5v0__fillcap_4
X_2015_ _2015_/I _2015_/ZN VDD VDD VSS VSS gf180mcu_fd_sc_mcu7t5v0__clkinv_1
XFILLER_51_734 VDD VDD VSS VSS gf180mcu_fd_sc_mcu7t5v0__fillcap_16
XTAP_TAPCELL_ROW_18_472 VDD VSS gf180mcu_fd_sc_mcu7t5v0__filltie
Xoutput951 _1447_/ZN tl_h_d_o[39] VDD VDD VSS VSS gf180mcu_fd_sc_mcu7t5v0__dlyd_1
Xoutput962 _2186_/ZN tl_h_d_o[49] VDD VDD VSS VSS gf180mcu_fd_sc_mcu7t5v0__dlyd_1
Xoutput973 _2240_/ZN tl_h_d_o[59] VDD VDD VSS VSS gf180mcu_fd_sc_mcu7t5v0__dlyd_1
Xoutput940 _1367_/ZN tl_h_d_o[29] VDD VDD VSS VSS gf180mcu_fd_sc_mcu7t5v0__dlyd_1
Xoutput984 _2147_/ZN tl_h_d_o[9] VDD VDD VSS VSS gf180mcu_fd_sc_mcu7t5v0__dlyd_1
Xoutput995 _2268_/ZN tl_h_i_o[19] VDD VDD VSS VSS gf180mcu_fd_sc_mcu7t5v0__dlyd_1
XFILLER_100_452 VDD VDD VSS VSS gf180mcu_fd_sc_mcu7t5v0__fill_2
XFILLER_10_664 VDD VDD VSS VSS gf180mcu_fd_sc_mcu7t5v0__fill_1
XTAP_TAPCELL_ROW_114_1625 VDD VSS gf180mcu_fd_sc_mcu7t5v0__filltie
XFILLER_2_841 VDD VDD VSS VSS gf180mcu_fd_sc_mcu7t5v0__fillcap_16
XFILLER_96_439 VDD VDD VSS VSS gf180mcu_fd_sc_mcu7t5v0__fill_2
XFILLER_49_344 VDD VDD VSS VSS gf180mcu_fd_sc_mcu7t5v0__fillcap_4
XFILLER_65_804 VDD VDD VSS VSS gf180mcu_fd_sc_mcu7t5v0__fill_2
XFILLER_92_601 VDD VDD VSS VSS gf180mcu_fd_sc_mcu7t5v0__fill_2
XFILLER_77_664 VDD VDD VSS VSS gf180mcu_fd_sc_mcu7t5v0__fillcap_16
XFILLER_64_303 VDD VDD VSS VSS gf180mcu_fd_sc_mcu7t5v0__fillcap_8
XFILLER_18_731 VDD VDD VSS VSS gf180mcu_fd_sc_mcu7t5v0__fillcap_4
XFILLER_80_807 VDD VDD VSS VSS gf180mcu_fd_sc_mcu7t5v0__fillcap_16
XFILLER_92_678 VDD VDD VSS VSS gf180mcu_fd_sc_mcu7t5v0__fill_1
XFILLER_32_233 VDD VDD VSS VSS gf180mcu_fd_sc_mcu7t5v0__fill_2
XTAP_TAPCELL_ROW_15_442 VDD VSS gf180mcu_fd_sc_mcu7t5v0__filltie
XTAP_TAPCELL_ROW_15_431 VDD VSS gf180mcu_fd_sc_mcu7t5v0__filltie
XFILLER_60_597 VDD VDD VSS VSS gf180mcu_fd_sc_mcu7t5v0__fillcap_64
XTAP_TAPCELL_ROW_43_773 VDD VSS gf180mcu_fd_sc_mcu7t5v0__filltie
X_2702_ _2702_/I _2702_/Z VDD VDD VSS VSS gf180mcu_fd_sc_mcu7t5v0__buf_1
X_2633_ _2705_/I _2633_/Z VDD VDD VSS VSS gf180mcu_fd_sc_mcu7t5v0__buf_1
X_2564_ _2564_/D _2583_/RN clkload3/I _2564_/Q VDD VDD VSS VSS gf180mcu_fd_sc_mcu7t5v0__dffrnq_1
X_1515_ _1918_/B2 _1550_/A2 _1515_/Z VDD VDD VSS VSS gf180mcu_fd_sc_mcu7t5v0__or2_1
X_2495_ _2591_/Q _2507_/B _2496_/B VDD VDD VSS VSS gf180mcu_fd_sc_mcu7t5v0__nand2_1
XFILLER_68_631 VDD VDD VSS VSS gf180mcu_fd_sc_mcu7t5v0__fillcap_32
X_1446_ _1446_/A1 _1510_/A2 _1446_/B1 _1217_/C _1447_/A2 VDD VDD VSS VSS gf180mcu_fd_sc_mcu7t5v0__aoi22_1
XFILLER_99_288 VDD VDD VSS VSS gf180mcu_fd_sc_mcu7t5v0__fill_1
X_1377_ _1393_/A1 _2313_/A2 _1377_/Z VDD VDD VSS VSS gf180mcu_fd_sc_mcu7t5v0__and2_1
XFILLER_55_314 VDD VDD VSS VSS gf180mcu_fd_sc_mcu7t5v0__fillcap_16
XFILLER_55_347 VDD VDD VSS VSS gf180mcu_fd_sc_mcu7t5v0__fill_2
XFILLER_82_177 VDD VDD VSS VSS gf180mcu_fd_sc_mcu7t5v0__fillcap_4
XFILLER_70_317 VDD VDD VSS VSS gf180mcu_fd_sc_mcu7t5v0__fillcap_16
Xoutput781 _1793_/ZN tl_d_rom_o[64] VDD VDD VSS VSS gf180mcu_fd_sc_mcu7t5v0__dlyd_1
Xoutput770 _1773_/ZN tl_d_rom_o[54] VDD VDD VSS VSS gf180mcu_fd_sc_mcu7t5v0__dlyd_1
XFILLER_48_33 VDD VDD VSS VSS gf180mcu_fd_sc_mcu7t5v0__fill_2
Xoutput792 _1813_/ZN tl_d_rom_o[74] VDD VDD VSS VSS gf180mcu_fd_sc_mcu7t5v0__dlyd_1
XFILLER_62_807 VDD VDD VSS VSS gf180mcu_fd_sc_mcu7t5v0__fillcap_16
XFILLER_74_667 VDD VDD VSS VSS gf180mcu_fd_sc_mcu7t5v0__fillcap_8
XFILLER_73_144 VDD VDD VSS VSS gf180mcu_fd_sc_mcu7t5v0__fill_1
XFILLER_73_166 VDD VDD VSS VSS gf180mcu_fd_sc_mcu7t5v0__fill_1
XTAP_TAPCELL_ROW_64_1023 VDD VSS gf180mcu_fd_sc_mcu7t5v0__filltie
XFILLER_30_737 VDD VDD VSS VSS gf180mcu_fd_sc_mcu7t5v0__fillcap_64
XFILLER_42_597 VDD VDD VSS VSS gf180mcu_fd_sc_mcu7t5v0__fillcap_4
XTAP_TAPCELL_ROW_12_401 VDD VSS gf180mcu_fd_sc_mcu7t5v0__filltie
XTAP_TAPCELL_ROW_40_732 VDD VSS gf180mcu_fd_sc_mcu7t5v0__filltie
XPHY_EDGE_ROW_108_Right_108 VDD VSS gf180mcu_fd_sc_mcu7t5v0__endcap
XTAP_TAPCELL_ROW_75_1152 VDD VSS gf180mcu_fd_sc_mcu7t5v0__filltie
X_2280_ _2280_/A1 _2280_/A2 _2348_/B _2280_/ZN VDD VDD VSS VSS gf180mcu_fd_sc_mcu7t5v0__aoi21_1
X_1300_ input15/Z _1396_/A2 _1300_/B1 _1476_/B2 _1301_/I VDD VDD VSS VSS gf180mcu_fd_sc_mcu7t5v0__aoi22_1
X_1231_ _2403_/A1 _1231_/A2 _1232_/A2 VDD VDD VSS VSS gf180mcu_fd_sc_mcu7t5v0__nand2_1
XFILLER_49_174 VDD VDD VSS VSS gf180mcu_fd_sc_mcu7t5v0__fillcap_4
X_1162_ _1162_/A1 _1162_/A2 _1162_/A3 _1162_/A4 _1167_/A2 VDD VDD VSS VSS gf180mcu_fd_sc_mcu7t5v0__nor4_1
XTAP_TAPCELL_ROW_48_832 VDD VSS gf180mcu_fd_sc_mcu7t5v0__filltie
XFILLER_52_317 VDD VDD VSS VSS gf180mcu_fd_sc_mcu7t5v0__fillcap_16
XFILLER_64_177 VDD VDD VSS VSS gf180mcu_fd_sc_mcu7t5v0__fillcap_8
X_1093_ _1093_/I _2155_/A1 VDD VDD VSS VSS gf180mcu_fd_sc_mcu7t5v0__clkinv_1
XFILLER_92_464 VDD VDD VSS VSS gf180mcu_fd_sc_mcu7t5v0__fillcap_32
XTAP_TAPCELL_ROW_86_1292 VDD VSS gf180mcu_fd_sc_mcu7t5v0__filltie
XFILLER_20_247 VDD VDD VSS VSS gf180mcu_fd_sc_mcu7t5v0__fillcap_64
X_1995_ _1995_/I _1995_/ZN VDD VDD VSS VSS gf180mcu_fd_sc_mcu7t5v0__clkinv_1
X_2547_ _2547_/D _2550_/RN clkload1/I _2547_/Q VDD VDD VSS VSS gf180mcu_fd_sc_mcu7t5v0__dffsnq_1
XFILLER_88_726 VDD VDD VSS VSS gf180mcu_fd_sc_mcu7t5v0__fillcap_8
XFILLER_87_203 VDD VDD VSS VSS gf180mcu_fd_sc_mcu7t5v0__fillcap_4
X_2478_ _2763_/I _2588_/Q _2478_/S _2588_/D VDD VDD VSS VSS gf180mcu_fd_sc_mcu7t5v0__mux2_2
X_1429_ _1429_/I _1430_/B1 VDD VDD VSS VSS gf180mcu_fd_sc_mcu7t5v0__clkinv_1
XFILLER_44_807 VDD VDD VSS VSS gf180mcu_fd_sc_mcu7t5v0__fillcap_16
XFILLER_56_667 VDD VDD VSS VSS gf180mcu_fd_sc_mcu7t5v0__fillcap_64
XFILLER_83_475 VDD VDD VSS VSS gf180mcu_fd_sc_mcu7t5v0__fillcap_8
XFILLER_24_520 VDD VDD VSS VSS gf180mcu_fd_sc_mcu7t5v0__fillcap_4
XFILLER_34_24 VDD VDD VSS VSS gf180mcu_fd_sc_mcu7t5v0__fill_1
XFILLER_24_597 VDD VDD VSS VSS gf180mcu_fd_sc_mcu7t5v0__fillcap_64
Xclkload1 clkload1/I clkload1/ZN VDD VDD VSS VSS gf180mcu_fd_sc_mcu7t5v0__inv_4
XFILLER_50_34 VDD VDD VSS VSS gf180mcu_fd_sc_mcu7t5v0__fill_1
XFILLER_106_831 VDD VDD VSS VSS gf180mcu_fd_sc_mcu7t5v0__fill_1
Xfanout1214 _1464_/A2 _1504_/A2 VDD VDD VSS VSS gf180mcu_fd_sc_mcu7t5v0__dlyd_1
XFILLER_47_601 VDD VDD VSS VSS gf180mcu_fd_sc_mcu7t5v0__fillcap_16
XFILLER_93_217 VDD VDD VSS VSS gf180mcu_fd_sc_mcu7t5v0__fill_1
XTAP_TAPCELL_ROW_70_1093 VDD VSS gf180mcu_fd_sc_mcu7t5v0__filltie
XTAP_TAPCELL_ROW_45_802 VDD VSS gf180mcu_fd_sc_mcu7t5v0__filltie
XTAP_TAPCELL_ROW_109_1568 VDD VSS gf180mcu_fd_sc_mcu7t5v0__filltie
XFILLER_34_317 VDD VDD VSS VSS gf180mcu_fd_sc_mcu7t5v0__fillcap_64
XFILLER_46_177 VDD VDD VSS VSS gf180mcu_fd_sc_mcu7t5v0__fillcap_64
XFILLER_43_851 VDD VDD VSS VSS gf180mcu_fd_sc_mcu7t5v0__fillcap_8
XFILLER_61_158 VDD VDD VSS VSS gf180mcu_fd_sc_mcu7t5v0__fillcap_8
XTAP_TAPCELL_ROW_53_890 VDD VSS gf180mcu_fd_sc_mcu7t5v0__filltie
X_1780_ _1970_/A1 _1822_/A2 _1812_/B1 _1970_/B2 _1781_/I VDD VDD VSS VSS gf180mcu_fd_sc_mcu7t5v0__aoi22_1
X_2401_ _2401_/I0 _2557_/Q _2401_/S _2557_/D VDD VDD VSS VSS gf180mcu_fd_sc_mcu7t5v0__mux2_2
XFILLER_112_845 VDD VDD VSS VSS gf180mcu_fd_sc_mcu7t5v0__fill_1
X_2332_ _2332_/A1 _2332_/A2 _2376_/B _2332_/ZN VDD VDD VSS VSS gf180mcu_fd_sc_mcu7t5v0__aoi21_1
XFILLER_69_236 VDD VDD VSS VSS gf180mcu_fd_sc_mcu7t5v0__fillcap_4
X_2263_ input77/Z _2323_/A2 _2295_/A3 _2264_/A2 VDD VDD VSS VSS gf180mcu_fd_sc_mcu7t5v0__nand3_1
X_2194_ _2583_/Q _2140_/B _2195_/A3 VDD VDD VSS VSS gf180mcu_fd_sc_mcu7t5v0__nand2_1
X_1214_ _1230_/A1 _1081_/I _2246_/B1 _1216_/A3 VDD VDD VSS VSS gf180mcu_fd_sc_mcu7t5v0__nand3_1
XTAP_TAPCELL_ROW_88_1310 VDD VSS gf180mcu_fd_sc_mcu7t5v0__filltie
XFILLER_26_807 VDD VDD VSS VSS gf180mcu_fd_sc_mcu7t5v0__fillcap_16
XFILLER_38_667 VDD VDD VSS VSS gf180mcu_fd_sc_mcu7t5v0__fillcap_64
X_1145_ _1135_/Z _1138_/Z _1145_/B _2454_/A1 VDD VDD VSS VSS gf180mcu_fd_sc_mcu7t5v0__oai21_1
XFILLER_92_261 VDD VDD VSS VSS gf180mcu_fd_sc_mcu7t5v0__fillcap_4
XFILLER_52_114 VDD VDD VSS VSS gf180mcu_fd_sc_mcu7t5v0__fill_1
XFILLER_53_648 VDD VDD VSS VSS gf180mcu_fd_sc_mcu7t5v0__fillcap_8
XFILLER_92_294 VDD VDD VSS VSS gf180mcu_fd_sc_mcu7t5v0__fillcap_8
X_1076_ _1076_/I _1222_/A1 VDD VDD VSS VSS gf180mcu_fd_sc_mcu7t5v0__clkinv_1
XFILLER_80_467 VDD VDD VSS VSS gf180mcu_fd_sc_mcu7t5v0__fillcap_32
XTAP_TAPCELL_ROW_23_529 VDD VSS gf180mcu_fd_sc_mcu7t5v0__filltie
XFILLER_21_556 VDD VDD VSS VSS gf180mcu_fd_sc_mcu7t5v0__fillcap_4
XFILLER_33_394 VDD VDD VSS VSS gf180mcu_fd_sc_mcu7t5v0__fill_2
X_1978_ _1978_/A1 _2030_/A2 _2014_/B1 _2721_/I _1979_/I VDD VDD VSS VSS gf180mcu_fd_sc_mcu7t5v0__aoi22_1
XTAP_TAPCELL_ROW_99_1450 VDD VSS gf180mcu_fd_sc_mcu7t5v0__filltie
Xinput306 tl_h_d_i[33] _1920_/B2 VDD VDD VSS VSS gf180mcu_fd_sc_mcu7t5v0__dlyd_1
Xinput317 tl_h_d_i[43] _1940_/B2 VDD VDD VSS VSS gf180mcu_fd_sc_mcu7t5v0__dlyd_1
XFILLER_76_718 VDD VDD VSS VSS gf180mcu_fd_sc_mcu7t5v0__fillcap_8
XFILLER_29_612 VDD VDD VSS VSS gf180mcu_fd_sc_mcu7t5v0__fillcap_16
Xinput328 tl_h_d_i[53] _1960_/B2 VDD VDD VSS VSS gf180mcu_fd_sc_mcu7t5v0__dlyd_1
Xinput339 tl_h_d_i[63] _2722_/I VDD VDD VSS VSS gf180mcu_fd_sc_mcu7t5v0__clkbuf_2
XFILLER_75_206 VDD VDD VSS VSS gf180mcu_fd_sc_mcu7t5v0__fillcap_4
XFILLER_102_399 VDD VDD VSS VSS gf180mcu_fd_sc_mcu7t5v0__fill_2
XFILLER_56_442 VDD VDD VSS VSS gf180mcu_fd_sc_mcu7t5v0__fillcap_8
XTAP_TAPCELL_ROW_3_287 VDD VSS gf180mcu_fd_sc_mcu7t5v0__filltie
XFILLER_16_317 VDD VDD VSS VSS gf180mcu_fd_sc_mcu7t5v0__fillcap_64
XFILLER_56_497 VDD VDD VSS VSS gf180mcu_fd_sc_mcu7t5v0__fill_2
XTAP_TAPCELL_ROW_3_298 VDD VSS gf180mcu_fd_sc_mcu7t5v0__filltie
XFILLER_71_412 VDD VDD VSS VSS gf180mcu_fd_sc_mcu7t5v0__fillcap_8
XFILLER_44_659 VDD VDD VSS VSS gf180mcu_fd_sc_mcu7t5v0__fillcap_4
XFILLER_71_489 VDD VDD VSS VSS gf180mcu_fd_sc_mcu7t5v0__fill_1
XTAP_TAPCELL_ROW_50_860 VDD VSS gf180mcu_fd_sc_mcu7t5v0__filltie
XTAP_TAPCELL_ROW_72_1122 VDD VSS gf180mcu_fd_sc_mcu7t5v0__filltie
XFILLER_79_556 VDD VDD VSS VSS gf180mcu_fd_sc_mcu7t5v0__fillcap_4
XFILLER_39_409 VDD VDD VSS VSS gf180mcu_fd_sc_mcu7t5v0__fillcap_4
Xfanout1055 _2537_/A2 _1930_/B1 VDD VDD VSS VSS gf180mcu_fd_sc_mcu7t5v0__dlyd_1
Xfanout1077 _1183_/ZN _1976_/A2 VDD VDD VSS VSS gf180mcu_fd_sc_mcu7t5v0__dlyd_1
Xfanout1088 _1830_/A2 _1732_/A2 VDD VDD VSS VSS gf180mcu_fd_sc_mcu7t5v0__dlyd_1
Xfanout1099 _1194_/ZN _1830_/A2 VDD VDD VSS VSS gf180mcu_fd_sc_mcu7t5v0__dlyd_1
Xwire1183 _2343_/A2 _2291_/A2 VDD VDD VSS VSS gf180mcu_fd_sc_mcu7t5v0__clkbuf_4
XFILLER_62_412 VDD VDD VSS VSS gf180mcu_fd_sc_mcu7t5v0__fillcap_32
XTAP_TAPCELL_ROW_83_1251 VDD VSS gf180mcu_fd_sc_mcu7t5v0__filltie
X_1901_ _1901_/I _1901_/ZN VDD VDD VSS VSS gf180mcu_fd_sc_mcu7t5v0__clkinv_1
X_1832_ _2398_/I0 _1836_/A2 _2533_/A2 _2759_/I _1833_/I VDD VDD VSS VSS gf180mcu_fd_sc_mcu7t5v0__aoi22_1
XFILLER_30_375 VDD VDD VSS VSS gf180mcu_fd_sc_mcu7t5v0__fillcap_8
X_1763_ _1763_/I _1763_/ZN VDD VDD VSS VSS gf180mcu_fd_sc_mcu7t5v0__clkinv_1
X_1694_ _2385_/I0 _1732_/A2 _1722_/B1 _1694_/B2 _1695_/I VDD VDD VSS VSS gf180mcu_fd_sc_mcu7t5v0__aoi22_1
XTAP_TAPCELL_ROW_94_1380 VDD VSS gf180mcu_fd_sc_mcu7t5v0__filltie
X_2315_ input92/Z _2315_/A2 _2363_/A3 _2316_/A2 VDD VDD VSS VSS gf180mcu_fd_sc_mcu7t5v0__nand3_1
X_2246_ _2246_/A1 _2246_/A2 _2246_/B1 _2246_/B2 _2246_/C _2248_/A1 VDD VDD VSS VSS
+ gf180mcu_fd_sc_mcu7t5v0__aoi221_1
X_2177_ _2177_/A1 _2224_/C _2180_/B VDD VDD VSS VSS gf180mcu_fd_sc_mcu7t5v0__nand2_1
X_1128_ _1257_/A1 _2347_/A2 _2377_/A1 _1251_/A1 _1066_/I _2076_/A2 _2255_/A1 VDD VDD
+ VSS VSS gf180mcu_fd_sc_mcu7t5v0__aoi222_1
XTAP_TAPCELL_ROW_0_257 VDD VSS gf180mcu_fd_sc_mcu7t5v0__filltie
XTAP_TAPCELL_ROW_0_246 VDD VSS gf180mcu_fd_sc_mcu7t5v0__filltie
XFILLER_80_220 VDD VDD VSS VSS gf180mcu_fd_sc_mcu7t5v0__fill_1
X_1059_ _2741_/I _1142_/A2 VDD VDD VSS VSS gf180mcu_fd_sc_mcu7t5v0__clkinv_1
XTAP_TAPCELL_ROW_36_687 VDD VSS gf180mcu_fd_sc_mcu7t5v0__filltie
XFILLER_107_403 VDD VDD VSS VSS gf180mcu_fd_sc_mcu7t5v0__fillcap_8
XTAP_TAPCELL_ROW_8_357 VDD VSS gf180mcu_fd_sc_mcu7t5v0__filltie
Xinput103 tl_d_esram_i[41] _2355_/A1 VDD VDD VSS VSS gf180mcu_fd_sc_mcu7t5v0__dlyd_1
Xinput114 tl_d_esram_i[51] _2190_/A1 VDD VDD VSS VSS gf180mcu_fd_sc_mcu7t5v0__dlyd_1
Xinput125 tl_d_esram_i[61] _2246_/B2 VDD VDD VSS VSS gf180mcu_fd_sc_mcu7t5v0__dlyd_1
Xinput136 tl_d_rom_i[11] _2153_/A1 VDD VDD VSS VSS gf180mcu_fd_sc_mcu7t5v0__dlyd_1
Xinput147 tl_d_rom_i[21] _1296_/A1 VDD VDD VSS VSS gf180mcu_fd_sc_mcu7t5v0__dlyd_1
Xinput158 tl_d_rom_i[31] _1376_/A1 VDD VDD VSS VSS gf180mcu_fd_sc_mcu7t5v0__dlyd_1
Xinput169 tl_d_rom_i[41] _1456_/A1 VDD VDD VSS VSS gf180mcu_fd_sc_mcu7t5v0__dlyd_1
Xload_slew1213 _1432_/A2 _1496_/A2 VDD VDD VSS VSS gf180mcu_fd_sc_mcu7t5v0__clkbuf_4
Xload_slew1235 _2770_/I _2698_/I VDD VDD VSS VSS gf180mcu_fd_sc_mcu7t5v0__buf_4
XFILLER_17_626 VDD VDD VSS VSS gf180mcu_fd_sc_mcu7t5v0__fillcap_4
XTAP_TAPCELL_ROW_106_1527 VDD VSS gf180mcu_fd_sc_mcu7t5v0__filltie
XFILLER_72_732 VDD VDD VSS VSS gf180mcu_fd_sc_mcu7t5v0__fill_2
XFILLER_44_445 VDD VDD VSS VSS gf180mcu_fd_sc_mcu7t5v0__fillcap_8
XFILLER_72_10 VDD VDD VSS VSS gf180mcu_fd_sc_mcu7t5v0__fillcap_4
XFILLER_44_489 VDD VDD VSS VSS gf180mcu_fd_sc_mcu7t5v0__fillcap_16
XFILLER_13_865 VDD VDD VSS VSS gf180mcu_fd_sc_mcu7t5v0__fill_1
XTAP_TAPCELL_ROW_117_1656 VDD VSS gf180mcu_fd_sc_mcu7t5v0__filltie
XFILLER_99_629 VDD VDD VSS VSS gf180mcu_fd_sc_mcu7t5v0__fill_1
XFILLER_0_780 VDD VDD VSS VSS gf180mcu_fd_sc_mcu7t5v0__fill_2
XFILLER_39_228 VDD VDD VSS VSS gf180mcu_fd_sc_mcu7t5v0__fillcap_8
X_2100_ _2100_/I _2100_/ZN VDD VDD VSS VSS gf180mcu_fd_sc_mcu7t5v0__clkinv_1
XFILLER_94_323 VDD VDD VSS VSS gf180mcu_fd_sc_mcu7t5v0__fill_1
XFILLER_54_209 VDD VDD VSS VSS gf180mcu_fd_sc_mcu7t5v0__fillcap_16
X_2031_ _2031_/I _2031_/ZN VDD VDD VSS VSS gf180mcu_fd_sc_mcu7t5v0__clkinv_1
XFILLER_15_180 VDD VDD VSS VSS gf180mcu_fd_sc_mcu7t5v0__fillcap_16
XTAP_TAPCELL_ROW_61_988 VDD VSS gf180mcu_fd_sc_mcu7t5v0__filltie
XTAP_TAPCELL_ROW_33_657 VDD VSS gf180mcu_fd_sc_mcu7t5v0__filltie
X_1815_ _1815_/I _1815_/ZN VDD VDD VSS VSS gf180mcu_fd_sc_mcu7t5v0__clkinv_1
X_1746_ _1936_/A1 _1768_/A2 _1768_/B1 _1936_/B2 _1747_/I VDD VDD VSS VSS gf180mcu_fd_sc_mcu7t5v0__aoi22_1
X_1677_ _1677_/I _1677_/ZN VDD VDD VSS VSS gf180mcu_fd_sc_mcu7t5v0__clkinv_1
XTAP_TAPCELL_ROW_5_316 VDD VSS gf180mcu_fd_sc_mcu7t5v0__filltie
XFILLER_45_209 VDD VDD VSS VSS gf180mcu_fd_sc_mcu7t5v0__fill_1
XFILLER_26_14 VDD VDD VSS VSS gf180mcu_fd_sc_mcu7t5v0__fill_2
X_2229_ _2229_/A1 _1217_/C _2232_/A1 VDD VDD VSS VSS gf180mcu_fd_sc_mcu7t5v0__nor2_1
XFILLER_53_220 VDD VDD VSS VSS gf180mcu_fd_sc_mcu7t5v0__fillcap_4
XFILLER_66_592 VDD VDD VSS VSS gf180mcu_fd_sc_mcu7t5v0__fill_2
XFILLER_41_415 VDD VDD VSS VSS gf180mcu_fd_sc_mcu7t5v0__fillcap_4
XFILLER_81_562 VDD VDD VSS VSS gf180mcu_fd_sc_mcu7t5v0__fillcap_8
XFILLER_81_551 VDD VDD VSS VSS gf180mcu_fd_sc_mcu7t5v0__fill_1
XFILLER_41_426 VDD VDD VSS VSS gf180mcu_fd_sc_mcu7t5v0__fill_2
XFILLER_41_459 VDD VDD VSS VSS gf180mcu_fd_sc_mcu7t5v0__fillcap_8
XTAP_TAPCELL_ROW_101_1468 VDD VSS gf180mcu_fd_sc_mcu7t5v0__filltie
XFILLER_76_301 VDD VDD VSS VSS gf180mcu_fd_sc_mcu7t5v0__fillcap_4
XTAP_TAPCELL_ROW_112_1597 VDD VSS gf180mcu_fd_sc_mcu7t5v0__filltie
XFILLER_49_559 VDD VDD VSS VSS gf180mcu_fd_sc_mcu7t5v0__fill_1
Xload_slew1054 _2462_/S _2476_/S VDD VDD VSS VSS gf180mcu_fd_sc_mcu7t5v0__buf_4
Xload_slew1076 fanout1075/Z _2022_/A2 VDD VDD VSS VSS gf180mcu_fd_sc_mcu7t5v0__clkbuf_4
XFILLER_32_415 VDD VDD VSS VSS gf180mcu_fd_sc_mcu7t5v0__fillcap_4
Xload_slew1087 _1407_/A1 _1399_/A1 VDD VDD VSS VSS gf180mcu_fd_sc_mcu7t5v0__buf_4
XTAP_TAPCELL_ROW_67_1065 VDD VSS gf180mcu_fd_sc_mcu7t5v0__filltie
XFILLER_72_551 VDD VDD VSS VSS gf180mcu_fd_sc_mcu7t5v0__fillcap_32
XTAP_TAPCELL_ROW_80_1221 VDD VSS gf180mcu_fd_sc_mcu7t5v0__filltie
XFILLER_9_611 VDD VDD VSS VSS gf180mcu_fd_sc_mcu7t5v0__fill_1
XTAP_TAPCELL_ROW_30_616 VDD VSS gf180mcu_fd_sc_mcu7t5v0__filltie
XFILLER_9_622 VDD VDD VSS VSS gf180mcu_fd_sc_mcu7t5v0__fill_2
X_1600_ _1878_/B2 _1599_/Z _1600_/S _1600_/Z VDD VDD VSS VSS gf180mcu_fd_sc_mcu7t5v0__mux2_2
X_2580_ _2580_/D _2580_/RN clkload1/I _2580_/Q VDD VDD VSS VSS gf180mcu_fd_sc_mcu7t5v0__dffrnq_1
XTAP_TAPCELL_ROW_10_373 VDD VSS gf180mcu_fd_sc_mcu7t5v0__filltie
X_1531_ _1950_/B2 _1533_/A2 _1531_/Z VDD VDD VSS VSS gf180mcu_fd_sc_mcu7t5v0__or2_1
XTAP_TAPCELL_ROW_78_1194 VDD VSS gf180mcu_fd_sc_mcu7t5v0__filltie
XFILLER_99_426 VDD VDD VSS VSS gf180mcu_fd_sc_mcu7t5v0__fill_2
XFILLER_99_404 VDD VDD VSS VSS gf180mcu_fd_sc_mcu7t5v0__fillcap_16
X_1462_ _1462_/A1 _1486_/A2 _1462_/B1 _2208_/B _1463_/A2 VDD VDD VSS VSS gf180mcu_fd_sc_mcu7t5v0__aoi22_1
XTAP_TAPCELL_ROW_91_1350 VDD VSS gf180mcu_fd_sc_mcu7t5v0__filltie
X_1393_ _1393_/A1 _2321_/A2 _1393_/Z VDD VDD VSS VSS gf180mcu_fd_sc_mcu7t5v0__and2_1
XFILLER_95_632 VDD VDD VSS VSS gf180mcu_fd_sc_mcu7t5v0__fill_2
XFILLER_55_507 VDD VDD VSS VSS gf180mcu_fd_sc_mcu7t5v0__fillcap_8
XFILLER_27_209 VDD VDD VSS VSS gf180mcu_fd_sc_mcu7t5v0__fill_1
XFILLER_48_570 VDD VDD VSS VSS gf180mcu_fd_sc_mcu7t5v0__fillcap_16
XTAP_TAPCELL_ROW_38_716 VDD VSS gf180mcu_fd_sc_mcu7t5v0__filltie
X_2014_ _2014_/A1 _2022_/A2 _2014_/B1 _2739_/I _2015_/I VDD VDD VSS VSS gf180mcu_fd_sc_mcu7t5v0__aoi22_1
XFILLER_51_702 VDD VDD VSS VSS gf180mcu_fd_sc_mcu7t5v0__fillcap_32
XFILLER_63_551 VDD VDD VSS VSS gf180mcu_fd_sc_mcu7t5v0__fillcap_8
XFILLER_63_562 VDD VDD VSS VSS gf180mcu_fd_sc_mcu7t5v0__fillcap_4
XFILLER_91_860 VDD VDD VSS VSS gf180mcu_fd_sc_mcu7t5v0__fillcap_4
XFILLER_35_275 VDD VDD VSS VSS gf180mcu_fd_sc_mcu7t5v0__fillcap_4
XTAP_TAPCELL_ROW_18_473 VDD VSS gf180mcu_fd_sc_mcu7t5v0__filltie
XFILLER_31_492 VDD VDD VSS VSS gf180mcu_fd_sc_mcu7t5v0__fillcap_16
Xoutput930 _2114_/ZN tl_h_d_o[1] VDD VDD VSS VSS gf180mcu_fd_sc_mcu7t5v0__dlyd_1
X_1729_ _1729_/I _1729_/ZN VDD VDD VSS VSS gf180mcu_fd_sc_mcu7t5v0__clkinv_1
Xoutput952 _2121_/ZN tl_h_d_o[3] VDD VDD VSS VSS gf180mcu_fd_sc_mcu7t5v0__dlyd_1
Xoutput963 _2125_/ZN tl_h_d_o[4] VDD VDD VSS VSS gf180mcu_fd_sc_mcu7t5v0__dlyd_1
Xoutput941 _2118_/ZN tl_h_d_o[2] VDD VDD VSS VSS gf180mcu_fd_sc_mcu7t5v0__dlyd_1
Xoutput974 _2128_/ZN tl_h_d_o[5] VDD VDD VSS VSS gf180mcu_fd_sc_mcu7t5v0__dlyd_1
Xoutput985 _2775_/Z tl_h_i_o[0] VDD VDD VSS VSS gf180mcu_fd_sc_mcu7t5v0__dlyd_1
Xoutput996 _2047_/ZN tl_h_i_o[1] VDD VDD VSS VSS gf180mcu_fd_sc_mcu7t5v0__dlyd_1
XFILLER_58_312 VDD VDD VSS VSS gf180mcu_fd_sc_mcu7t5v0__fill_2
XFILLER_26_242 VDD VDD VSS VSS gf180mcu_fd_sc_mcu7t5v0__fill_2
XFILLER_41_212 VDD VDD VSS VSS gf180mcu_fd_sc_mcu7t5v0__fillcap_16
XTAP_TAPCELL_ROW_114_1626 VDD VSS gf180mcu_fd_sc_mcu7t5v0__filltie
XFILLER_1_352 VDD VDD VSS VSS gf180mcu_fd_sc_mcu7t5v0__fillcap_16
XFILLER_89_492 VDD VDD VSS VSS gf180mcu_fd_sc_mcu7t5v0__fillcap_8
XFILLER_77_632 VDD VDD VSS VSS gf180mcu_fd_sc_mcu7t5v0__fillcap_32
XFILLER_77_610 VDD VDD VSS VSS gf180mcu_fd_sc_mcu7t5v0__fillcap_8
XFILLER_92_613 VDD VDD VSS VSS gf180mcu_fd_sc_mcu7t5v0__fillcap_16
XFILLER_33_702 VDD VDD VSS VSS gf180mcu_fd_sc_mcu7t5v0__fillcap_64
XFILLER_45_540 VDD VDD VSS VSS gf180mcu_fd_sc_mcu7t5v0__fill_1
XFILLER_45_562 VDD VDD VSS VSS gf180mcu_fd_sc_mcu7t5v0__fillcap_64
XTAP_TAPCELL_ROW_15_432 VDD VSS gf180mcu_fd_sc_mcu7t5v0__filltie
XTAP_TAPCELL_ROW_43_774 VDD VSS gf180mcu_fd_sc_mcu7t5v0__filltie
XFILLER_13_492 VDD VDD VSS VSS gf180mcu_fd_sc_mcu7t5v0__fillcap_64
X_2701_ _2701_/I _2701_/Z VDD VDD VSS VSS gf180mcu_fd_sc_mcu7t5v0__buf_1
XFILLER_118_339 VDD VDD VSS VSS gf180mcu_fd_sc_mcu7t5v0__fill_1
X_2563_ _2563_/D _2583_/RN clkload3/I _2563_/Q VDD VDD VSS VSS gf180mcu_fd_sc_mcu7t5v0__dffrnq_1
X_1514_ _1916_/B2 _1550_/A2 _1514_/Z VDD VDD VSS VSS gf180mcu_fd_sc_mcu7t5v0__or2_1
X_2494_ _2491_/Z _2497_/A2 _2494_/Z VDD VDD VSS VSS gf180mcu_fd_sc_mcu7t5v0__xor2_1
XFILLER_68_621 VDD VDD VSS VSS gf180mcu_fd_sc_mcu7t5v0__fill_1
X_1445_ _1445_/I _1446_/B1 VDD VDD VSS VSS gf180mcu_fd_sc_mcu7t5v0__clkinv_1
XFILLER_114_18 VDD VDD VSS VSS gf180mcu_fd_sc_mcu7t5v0__fill_2
XFILLER_67_142 VDD VDD VSS VSS gf180mcu_fd_sc_mcu7t5v0__fillcap_64
X_1376_ _1376_/A1 _1496_/A2 _2313_/A2 VDD VDD VSS VSS gf180mcu_fd_sc_mcu7t5v0__nand2_1
XFILLER_83_624 VDD VDD VSS VSS gf180mcu_fd_sc_mcu7t5v0__fillcap_4
XFILLER_82_156 VDD VDD VSS VSS gf180mcu_fd_sc_mcu7t5v0__fillcap_4
XFILLER_23_267 VDD VDD VSS VSS gf180mcu_fd_sc_mcu7t5v0__fillcap_8
Xoutput771 _1775_/ZN tl_d_rom_o[55] VDD VDD VSS VSS gf180mcu_fd_sc_mcu7t5v0__dlyd_1
Xoutput760 _1755_/ZN tl_d_rom_o[45] VDD VDD VSS VSS gf180mcu_fd_sc_mcu7t5v0__dlyd_1
XFILLER_59_632 VDD VDD VSS VSS gf180mcu_fd_sc_mcu7t5v0__fillcap_64
Xoutput793 _1815_/ZN tl_d_rom_o[75] VDD VDD VSS VSS gf180mcu_fd_sc_mcu7t5v0__dlyd_1
Xoutput782 _1795_/ZN tl_d_rom_o[65] VDD VDD VSS VSS gf180mcu_fd_sc_mcu7t5v0__dlyd_1
XFILLER_86_451 VDD VDD VSS VSS gf180mcu_fd_sc_mcu7t5v0__fillcap_4
XFILLER_58_197 VDD VDD VSS VSS gf180mcu_fd_sc_mcu7t5v0__fill_1
XFILLER_15_702 VDD VDD VSS VSS gf180mcu_fd_sc_mcu7t5v0__fillcap_64
XFILLER_27_562 VDD VDD VSS VSS gf180mcu_fd_sc_mcu7t5v0__fillcap_64
XFILLER_64_22 VDD VDD VSS VSS gf180mcu_fd_sc_mcu7t5v0__fillcap_8
XFILLER_74_679 VDD VDD VSS VSS gf180mcu_fd_sc_mcu7t5v0__fill_2
XFILLER_54_381 VDD VDD VSS VSS gf180mcu_fd_sc_mcu7t5v0__fillcap_4
XTAP_TAPCELL_ROW_64_1024 VDD VSS gf180mcu_fd_sc_mcu7t5v0__filltie
XTAP_TAPCELL_ROW_12_402 VDD VSS gf180mcu_fd_sc_mcu7t5v0__filltie
XTAP_TAPCELL_ROW_40_733 VDD VSS gf180mcu_fd_sc_mcu7t5v0__filltie
XTAP_TAPCELL_ROW_75_1153 VDD VSS gf180mcu_fd_sc_mcu7t5v0__filltie
XFILLER_69_407 VDD VDD VSS VSS gf180mcu_fd_sc_mcu7t5v0__fillcap_8
XFILLER_49_131 VDD VDD VSS VSS gf180mcu_fd_sc_mcu7t5v0__fillcap_8
X_1230_ _1230_/A1 _1081_/I _2705_/I _1232_/A1 VDD VDD VSS VSS gf180mcu_fd_sc_mcu7t5v0__nand3_1
XFILLER_49_142 VDD VDD VSS VSS gf180mcu_fd_sc_mcu7t5v0__fillcap_32
X_1161_ _1161_/A1 _1161_/A2 _1161_/A3 _1167_/A1 VDD VDD VSS VSS gf180mcu_fd_sc_mcu7t5v0__nor3_1
XFILLER_64_123 VDD VDD VSS VSS gf180mcu_fd_sc_mcu7t5v0__fillcap_4
XTAP_TAPCELL_ROW_48_833 VDD VSS gf180mcu_fd_sc_mcu7t5v0__filltie
X_1092_ _1092_/I _2152_/A1 VDD VDD VSS VSS gf180mcu_fd_sc_mcu7t5v0__clkinv_1
XFILLER_64_189 VDD VDD VSS VSS gf180mcu_fd_sc_mcu7t5v0__fill_2
XTAP_TAPCELL_ROW_86_1293 VDD VSS gf180mcu_fd_sc_mcu7t5v0__filltie
XTAP_TAPCELL_ROW_28_590 VDD VSS gf180mcu_fd_sc_mcu7t5v0__filltie
XFILLER_60_384 VDD VDD VSS VSS gf180mcu_fd_sc_mcu7t5v0__fill_1
XFILLER_60_395 VDD VDD VSS VSS gf180mcu_fd_sc_mcu7t5v0__fillcap_4
X_1994_ _1994_/A1 _2030_/A2 _2014_/B1 _2729_/I _1995_/I VDD VDD VSS VSS gf180mcu_fd_sc_mcu7t5v0__aoi22_1
XFILLER_9_282 VDD VDD VSS VSS gf180mcu_fd_sc_mcu7t5v0__fillcap_16
X_2546_ _2546_/D _2580_/RN clkload1/I _2546_/Q VDD VDD VSS VSS gf180mcu_fd_sc_mcu7t5v0__dffrnq_1
X_2477_ _2762_/I _2587_/Q _2477_/S _2587_/D VDD VDD VSS VSS gf180mcu_fd_sc_mcu7t5v0__mux2_2
X_1428_ input32/Z _1500_/A2 _1428_/B1 _2247_/A2 _1429_/I VDD VDD VSS VSS gf180mcu_fd_sc_mcu7t5v0__aoi22_1
XFILLER_87_237 VDD VDD VSS VSS gf180mcu_fd_sc_mcu7t5v0__fillcap_16
XFILLER_56_613 VDD VDD VSS VSS gf180mcu_fd_sc_mcu7t5v0__fillcap_4
X_1359_ _1399_/A1 _1359_/A2 _1359_/ZN VDD VDD VSS VSS gf180mcu_fd_sc_mcu7t5v0__nor2_1
XFILLER_83_498 VDD VDD VSS VSS gf180mcu_fd_sc_mcu7t5v0__fill_1
XFILLER_83_487 VDD VDD VSS VSS gf180mcu_fd_sc_mcu7t5v0__fill_2
XFILLER_70_115 VDD VDD VSS VSS gf180mcu_fd_sc_mcu7t5v0__fillcap_16
XFILLER_51_362 VDD VDD VSS VSS gf180mcu_fd_sc_mcu7t5v0__fillcap_8
Xclkload2 clkload2/I clkload2/ZN VDD VDD VSS VSS gf180mcu_fd_sc_mcu7t5v0__inv_4
Xfanout1204 fanout1206/Z wire1205/I VDD VDD VSS VSS gf180mcu_fd_sc_mcu7t5v0__dlyd_1
Xoutput590 _2671_/Z tl_d_dmem_o[84] VDD VDD VSS VSS gf180mcu_fd_sc_mcu7t5v0__dlyd_1
Xfanout1237 _2588_/RN _2582_/RN VDD VDD VSS VSS gf180mcu_fd_sc_mcu7t5v0__dlyd_1
XFILLER_78_259 VDD VDD VSS VSS gf180mcu_fd_sc_mcu7t5v0__fill_2
XTAP_TAPCELL_ROW_70_1094 VDD VSS gf180mcu_fd_sc_mcu7t5v0__filltie
XTAP_TAPCELL_ROW_109_1569 VDD VSS gf180mcu_fd_sc_mcu7t5v0__filltie
XFILLER_61_126 VDD VDD VSS VSS gf180mcu_fd_sc_mcu7t5v0__fillcap_8
XFILLER_43_863 VDD VDD VSS VSS gf180mcu_fd_sc_mcu7t5v0__fill_2
XFILLER_91_42 VDD VDD VSS VSS gf180mcu_fd_sc_mcu7t5v0__fillcap_16
XTAP_TAPCELL_ROW_25_560 VDD VSS gf180mcu_fd_sc_mcu7t5v0__filltie
XTAP_TAPCELL_ROW_53_891 VDD VSS gf180mcu_fd_sc_mcu7t5v0__filltie
XFILLER_10_281 VDD VDD VSS VSS gf180mcu_fd_sc_mcu7t5v0__fillcap_16
X_2400_ _2400_/I0 _2556_/Q _2401_/S _2556_/D VDD VDD VSS VSS gf180mcu_fd_sc_mcu7t5v0__mux2_2
X_2331_ input96/Z _2347_/A2 _2331_/A3 _2332_/A2 VDD VDD VSS VSS gf180mcu_fd_sc_mcu7t5v0__nand3_1
XFILLER_97_524 VDD VDD VSS VSS gf180mcu_fd_sc_mcu7t5v0__fillcap_16
X_2262_ _2282_/A1 _2262_/A2 _2264_/A1 VDD VDD VSS VSS gf180mcu_fd_sc_mcu7t5v0__nand2_1
XFILLER_97_557 VDD VDD VSS VSS gf180mcu_fd_sc_mcu7t5v0__fill_2
XFILLER_97_546 VDD VDD VSS VSS gf180mcu_fd_sc_mcu7t5v0__fill_1
X_1213_ _2578_/Q _2199_/A2 _1213_/B _1213_/C _1216_/A2 VDD VDD VSS VSS gf180mcu_fd_sc_mcu7t5v0__oai211_1
X_2193_ _2193_/A1 _2218_/A2 _2195_/A2 VDD VDD VSS VSS gf180mcu_fd_sc_mcu7t5v0__nand2_1
XTAP_TAPCELL_ROW_88_1311 VDD VSS gf180mcu_fd_sc_mcu7t5v0__filltie
XFILLER_65_454 VDD VDD VSS VSS gf180mcu_fd_sc_mcu7t5v0__fillcap_16
X_1144_ _2569_/Q _2456_/A1 _1144_/Z VDD VDD VSS VSS gf180mcu_fd_sc_mcu7t5v0__xor2_1
XFILLER_65_476 VDD VDD VSS VSS gf180mcu_fd_sc_mcu7t5v0__fill_1
XFILLER_65_487 VDD VDD VSS VSS gf180mcu_fd_sc_mcu7t5v0__fill_2
X_1075_ _2600_/Q _2535_/A1 VDD VDD VSS VSS gf180mcu_fd_sc_mcu7t5v0__clkinv_1
XFILLER_80_457 VDD VDD VSS VSS gf180mcu_fd_sc_mcu7t5v0__fillcap_4
X_1977_ _1977_/I _1977_/ZN VDD VDD VSS VSS gf180mcu_fd_sc_mcu7t5v0__clkinv_1
XTAP_TAPCELL_ROW_99_1440 VDD VSS gf180mcu_fd_sc_mcu7t5v0__filltie
X_2529_ _2507_/B _2529_/A2 _2529_/A3 _2530_/A2 VDD VDD VSS VSS gf180mcu_fd_sc_mcu7t5v0__nor3_1
XFILLER_0_439 VDD VDD VSS VSS gf180mcu_fd_sc_mcu7t5v0__fill_2
Xinput307 tl_h_d_i[34] _1922_/B2 VDD VDD VSS VSS gf180mcu_fd_sc_mcu7t5v0__dlyd_1
Xinput318 tl_h_d_i[44] _1942_/B2 VDD VDD VSS VSS gf180mcu_fd_sc_mcu7t5v0__dlyd_1
XFILLER_102_378 VDD VDD VSS VSS gf180mcu_fd_sc_mcu7t5v0__fillcap_4
Xinput329 tl_h_d_i[54] _1962_/B2 VDD VDD VSS VSS gf180mcu_fd_sc_mcu7t5v0__dlyd_1
XFILLER_84_730 VDD VDD VSS VSS gf180mcu_fd_sc_mcu7t5v0__fillcap_4
XFILLER_28_156 VDD VDD VSS VSS gf180mcu_fd_sc_mcu7t5v0__fill_2
XFILLER_56_454 VDD VDD VSS VSS gf180mcu_fd_sc_mcu7t5v0__fill_1
XFILLER_56_465 VDD VDD VSS VSS gf180mcu_fd_sc_mcu7t5v0__fillcap_32
XTAP_TAPCELL_ROW_3_288 VDD VSS gf180mcu_fd_sc_mcu7t5v0__filltie
XFILLER_83_273 VDD VDD VSS VSS gf180mcu_fd_sc_mcu7t5v0__fillcap_4
XFILLER_71_446 VDD VDD VSS VSS gf180mcu_fd_sc_mcu7t5v0__fillcap_4
XFILLER_24_373 VDD VDD VSS VSS gf180mcu_fd_sc_mcu7t5v0__fillcap_8
XFILLER_24_395 VDD VDD VSS VSS gf180mcu_fd_sc_mcu7t5v0__fillcap_4
XTAP_TAPCELL_ROW_104_1499 VDD VSS gf180mcu_fd_sc_mcu7t5v0__filltie
XTAP_TAPCELL_ROW_50_861 VDD VSS gf180mcu_fd_sc_mcu7t5v0__filltie
XFILLER_61_78 VDD VDD VSS VSS gf180mcu_fd_sc_mcu7t5v0__fillcap_32
Xclkbuf_3_6__f_clk_i clkbuf_0_clk_i/Z _2596_/CLK VDD VDD VSS VSS gf180mcu_fd_sc_mcu7t5v0__clkbuf_16
XTAP_TAPCELL_ROW_72_1123 VDD VSS gf180mcu_fd_sc_mcu7t5v0__filltie
XFILLER_79_524 VDD VDD VSS VSS gf180mcu_fd_sc_mcu7t5v0__fillcap_32
XFILLER_94_527 VDD VDD VSS VSS gf180mcu_fd_sc_mcu7t5v0__fill_1
XTAP_TAPCELL_ROW_58_950 VDD VSS gf180mcu_fd_sc_mcu7t5v0__filltie
XFILLER_90_700 VDD VDD VSS VSS gf180mcu_fd_sc_mcu7t5v0__fill_2
XFILLER_62_446 VDD VDD VSS VSS gf180mcu_fd_sc_mcu7t5v0__fill_1
XTAP_TAPCELL_ROW_83_1252 VDD VSS gf180mcu_fd_sc_mcu7t5v0__filltie
X_1900_ _1900_/A1 _1900_/A2 _1900_/B1 _2714_/I _1901_/I VDD VDD VSS VSS gf180mcu_fd_sc_mcu7t5v0__aoi22_1
X_1831_ _1831_/I _1831_/ZN VDD VDD VSS VSS gf180mcu_fd_sc_mcu7t5v0__clkinv_1
XFILLER_30_387 VDD VDD VSS VSS gf180mcu_fd_sc_mcu7t5v0__fillcap_8
X_1762_ _1952_/A1 _1772_/A2 _1762_/B1 _1952_/B2 _1763_/I VDD VDD VSS VSS gf180mcu_fd_sc_mcu7t5v0__aoi22_1
X_1693_ _1693_/I _1693_/ZN VDD VDD VSS VSS gf180mcu_fd_sc_mcu7t5v0__clkinv_1
XTAP_TAPCELL_ROW_94_1381 VDD VSS gf180mcu_fd_sc_mcu7t5v0__filltie
X_2314_ _2378_/A1 _2314_/A2 _2316_/A1 VDD VDD VSS VSS gf180mcu_fd_sc_mcu7t5v0__nand2_1
X_2245_ _2245_/A1 _2236_/B _2248_/B VDD VDD VSS VSS gf180mcu_fd_sc_mcu7t5v0__nand2_1
X_2176_ _2236_/A2 _2176_/A2 _2176_/B _2176_/C _2176_/ZN VDD VDD VSS VSS gf180mcu_fd_sc_mcu7t5v0__oai211_1
X_1127_ _2382_/A1 _2067_/B _2102_/B2 VDD VDD VSS VSS gf180mcu_fd_sc_mcu7t5v0__nand2_1
XFILLER_93_593 VDD VDD VSS VSS gf180mcu_fd_sc_mcu7t5v0__fillcap_4
XFILLER_93_571 VDD VDD VSS VSS gf180mcu_fd_sc_mcu7t5v0__fillcap_8
XTAP_TAPCELL_ROW_0_258 VDD VSS gf180mcu_fd_sc_mcu7t5v0__filltie
XTAP_TAPCELL_ROW_0_247 VDD VSS gf180mcu_fd_sc_mcu7t5v0__filltie
XFILLER_81_766 VDD VDD VSS VSS gf180mcu_fd_sc_mcu7t5v0__fillcap_4
X_1058_ _1058_/I _1191_/A1 VDD VDD VSS VSS gf180mcu_fd_sc_mcu7t5v0__clkinv_1
XTAP_TAPCELL_ROW_36_688 VDD VSS gf180mcu_fd_sc_mcu7t5v0__filltie
XPHY_EDGE_ROW_1_Right_1 VDD VSS gf180mcu_fd_sc_mcu7t5v0__endcap
XTAP_TAPCELL_ROW_8_358 VDD VSS gf180mcu_fd_sc_mcu7t5v0__filltie
XTAP_TAPCELL_ROW_8_347 VDD VSS gf180mcu_fd_sc_mcu7t5v0__filltie
Xinput104 tl_d_esram_i[42] _2359_/A1 VDD VDD VSS VSS gf180mcu_fd_sc_mcu7t5v0__dlyd_1
Xinput115 tl_d_esram_i[52] _2196_/A1 VDD VDD VSS VSS gf180mcu_fd_sc_mcu7t5v0__dlyd_1
Xinput126 tl_d_esram_i[62] _1062_/I VDD VDD VSS VSS gf180mcu_fd_sc_mcu7t5v0__dlyd_1
XFILLER_88_354 VDD VDD VSS VSS gf180mcu_fd_sc_mcu7t5v0__fillcap_16
XFILLER_76_505 VDD VDD VSS VSS gf180mcu_fd_sc_mcu7t5v0__fill_2
Xinput137 tl_d_rom_i[12] _2157_/A1 VDD VDD VSS VSS gf180mcu_fd_sc_mcu7t5v0__dlyd_1
Xinput148 tl_d_rom_i[22] _1304_/A1 VDD VDD VSS VSS gf180mcu_fd_sc_mcu7t5v0__dlyd_1
Xinput159 tl_d_rom_i[32] _1384_/A1 VDD VDD VSS VSS gf180mcu_fd_sc_mcu7t5v0__dlyd_1
XFILLER_88_387 VDD VDD VSS VSS gf180mcu_fd_sc_mcu7t5v0__fillcap_32
XFILLER_76_527 VDD VDD VSS VSS gf180mcu_fd_sc_mcu7t5v0__fillcap_64
XFILLER_29_454 VDD VDD VSS VSS gf180mcu_fd_sc_mcu7t5v0__fill_1
XFILLER_56_34 VDD VDD VSS VSS gf180mcu_fd_sc_mcu7t5v0__fill_1
Xload_slew1203 _2331_/A3 _2379_/A3 VDD VDD VSS VSS gf180mcu_fd_sc_mcu7t5v0__buf_3
Xload_slew1225 _2345_/A1 _2377_/A1 VDD VDD VSS VSS gf180mcu_fd_sc_mcu7t5v0__buf_3
Xload_slew1236 _2769_/I _2697_/I VDD VDD VSS VSS gf180mcu_fd_sc_mcu7t5v0__buf_4
XTAP_TAPCELL_ROW_55_920 VDD VSS gf180mcu_fd_sc_mcu7t5v0__filltie
XFILLER_44_457 VDD VDD VSS VSS gf180mcu_fd_sc_mcu7t5v0__fillcap_32
XTAP_TAPCELL_ROW_106_1528 VDD VSS gf180mcu_fd_sc_mcu7t5v0__filltie
XFILLER_71_276 VDD VDD VSS VSS gf180mcu_fd_sc_mcu7t5v0__fillcap_4
XFILLER_12_387 VDD VDD VSS VSS gf180mcu_fd_sc_mcu7t5v0__fillcap_64
XFILLER_9_859 VDD VDD VSS VSS gf180mcu_fd_sc_mcu7t5v0__fillcap_4
XTAP_TAPCELL_ROW_117_1657 VDD VSS gf180mcu_fd_sc_mcu7t5v0__filltie
X_2030_ _2393_/I0 _2030_/A2 _2030_/B1 _2764_/I _2031_/I VDD VDD VSS VSS gf180mcu_fd_sc_mcu7t5v0__aoi22_1
XFILLER_82_508 VDD VDD VSS VSS gf180mcu_fd_sc_mcu7t5v0__fillcap_16
XFILLER_90_541 VDD VDD VSS VSS gf180mcu_fd_sc_mcu7t5v0__fill_1
XFILLER_50_438 VDD VDD VSS VSS gf180mcu_fd_sc_mcu7t5v0__fill_2
XTAP_TAPCELL_ROW_33_658 VDD VSS gf180mcu_fd_sc_mcu7t5v0__filltie
XTAP_TAPCELL_ROW_33_647 VDD VSS gf180mcu_fd_sc_mcu7t5v0__filltie
XFILLER_31_696 VDD VDD VSS VSS gf180mcu_fd_sc_mcu7t5v0__fillcap_4
XTAP_TAPCELL_ROW_61_989 VDD VSS gf180mcu_fd_sc_mcu7t5v0__filltie
X_1814_ _2004_/A1 _1836_/A2 _1814_/B1 _2734_/I _1815_/I VDD VDD VSS VSS gf180mcu_fd_sc_mcu7t5v0__aoi22_1
XTAP_TAPCELL_ROW_96_1410 VDD VSS gf180mcu_fd_sc_mcu7t5v0__filltie
X_1745_ _1745_/I _1745_/ZN VDD VDD VSS VSS gf180mcu_fd_sc_mcu7t5v0__clkinv_1
X_1676_ _1866_/A1 _1720_/A2 _1720_/B1 _1086_/I _1677_/I VDD VDD VSS VSS gf180mcu_fd_sc_mcu7t5v0__aoi22_1
XTAP_TAPCELL_ROW_5_317 VDD VSS gf180mcu_fd_sc_mcu7t5v0__filltie
XFILLER_58_527 VDD VDD VSS VSS gf180mcu_fd_sc_mcu7t5v0__fillcap_16
XFILLER_85_302 VDD VDD VSS VSS gf180mcu_fd_sc_mcu7t5v0__fillcap_4
XFILLER_54_722 VDD VDD VSS VSS gf180mcu_fd_sc_mcu7t5v0__fillcap_8
X_2228_ _2157_/B _2157_/C _2228_/A3 _2231_/B1 VDD VDD VSS VSS gf180mcu_fd_sc_mcu7t5v0__nand3_1
XFILLER_26_435 VDD VDD VSS VSS gf180mcu_fd_sc_mcu7t5v0__fillcap_16
X_2159_ _2170_/C _2159_/A2 _2159_/A3 _2160_/B VDD VDD VSS VSS gf180mcu_fd_sc_mcu7t5v0__nand3_1
XFILLER_26_457 VDD VDD VSS VSS gf180mcu_fd_sc_mcu7t5v0__fillcap_4
XFILLER_81_574 VDD VDD VSS VSS gf180mcu_fd_sc_mcu7t5v0__fillcap_32
XFILLER_53_298 VDD VDD VSS VSS gf180mcu_fd_sc_mcu7t5v0__fill_1
XTAP_TAPCELL_ROW_101_1469 VDD VSS gf180mcu_fd_sc_mcu7t5v0__filltie
XFILLER_6_807 VDD VDD VSS VSS gf180mcu_fd_sc_mcu7t5v0__fillcap_16
XTAP_TAPCELL_ROW_112_1598 VDD VSS gf180mcu_fd_sc_mcu7t5v0__filltie
XFILLER_77_858 VDD VDD VSS VSS gf180mcu_fd_sc_mcu7t5v0__fillcap_8
XFILLER_29_273 VDD VDD VSS VSS gf180mcu_fd_sc_mcu7t5v0__fill_2
XFILLER_57_571 VDD VDD VSS VSS gf180mcu_fd_sc_mcu7t5v0__fillcap_32
Xload_slew1066 _2030_/B1 _2038_/B1 VDD VDD VSS VSS gf180mcu_fd_sc_mcu7t5v0__buf_2
XFILLER_45_766 VDD VDD VSS VSS gf180mcu_fd_sc_mcu7t5v0__fillcap_4
XTAP_TAPCELL_ROW_67_1066 VDD VSS gf180mcu_fd_sc_mcu7t5v0__filltie
XTAP_TAPCELL_ROW_67_1055 VDD VSS gf180mcu_fd_sc_mcu7t5v0__filltie
XTAP_TAPCELL_ROW_80_1211 VDD VSS gf180mcu_fd_sc_mcu7t5v0__filltie
XTAP_TAPCELL_ROW_80_1222 VDD VSS gf180mcu_fd_sc_mcu7t5v0__filltie
XPHY_EDGE_ROW_17_Left_136 VDD VSS gf180mcu_fd_sc_mcu7t5v0__endcap
XFILLER_13_696 VDD VDD VSS VSS gf180mcu_fd_sc_mcu7t5v0__fillcap_4
XTAP_TAPCELL_ROW_30_617 VDD VSS gf180mcu_fd_sc_mcu7t5v0__filltie
XTAP_TAPCELL_ROW_10_374 VDD VSS gf180mcu_fd_sc_mcu7t5v0__filltie
X_1530_ _1948_/B2 _1533_/A2 _1530_/Z VDD VDD VSS VSS gf180mcu_fd_sc_mcu7t5v0__or2_1
XTAP_TAPCELL_ROW_78_1195 VDD VSS gf180mcu_fd_sc_mcu7t5v0__filltie
X_1461_ _1461_/I _1462_/B1 VDD VDD VSS VSS gf180mcu_fd_sc_mcu7t5v0__clkinv_1
XPHY_EDGE_ROW_26_Left_145 VDD VSS gf180mcu_fd_sc_mcu7t5v0__endcap
X_1392_ _1392_/A1 _1496_/A2 _2321_/A2 VDD VDD VSS VSS gf180mcu_fd_sc_mcu7t5v0__nand2_1
XTAP_TAPCELL_ROW_91_1351 VDD VSS gf180mcu_fd_sc_mcu7t5v0__filltie
XFILLER_95_600 VDD VDD VSS VSS gf180mcu_fd_sc_mcu7t5v0__fill_2
XFILLER_67_368 VDD VDD VSS VSS gf180mcu_fd_sc_mcu7t5v0__fillcap_4
Xinput490 tl_h_i_i[97] _2395_/I0 VDD VDD VSS VSS gf180mcu_fd_sc_mcu7t5v0__dlyd_1
XTAP_TAPCELL_ROW_38_717 VDD VSS gf180mcu_fd_sc_mcu7t5v0__filltie
X_2013_ _2013_/I _2013_/ZN VDD VDD VSS VSS gf180mcu_fd_sc_mcu7t5v0__clkinv_1
XFILLER_82_349 VDD VDD VSS VSS gf180mcu_fd_sc_mcu7t5v0__fill_2
XFILLER_35_265 VDD VDD VSS VSS gf180mcu_fd_sc_mcu7t5v0__fill_1
XFILLER_63_585 VDD VDD VSS VSS gf180mcu_fd_sc_mcu7t5v0__fillcap_32
XTAP_TAPCELL_ROW_18_474 VDD VSS gf180mcu_fd_sc_mcu7t5v0__filltie
XPHY_EDGE_ROW_35_Left_154 VDD VSS gf180mcu_fd_sc_mcu7t5v0__endcap
XFILLER_50_235 VDD VDD VSS VSS gf180mcu_fd_sc_mcu7t5v0__fillcap_8
XFILLER_51_758 VDD VDD VSS VSS gf180mcu_fd_sc_mcu7t5v0__fillcap_8
Xoutput920 _2152_/ZN tl_h_d_o[10] VDD VDD VSS VSS gf180mcu_fd_sc_mcu7t5v0__dlyd_1
X_1728_ _1918_/A1 _1728_/A2 _1772_/B1 _1918_/B2 _1729_/I VDD VDD VSS VSS gf180mcu_fd_sc_mcu7t5v0__aoi22_1
XPHY_EDGE_ROW_44_Left_163 VDD VSS gf180mcu_fd_sc_mcu7t5v0__endcap
Xoutput953 _1455_/ZN tl_h_d_o[40] VDD VDD VSS VSS gf180mcu_fd_sc_mcu7t5v0__dlyd_1
Xoutput964 _2192_/ZN tl_h_d_o[50] VDD VDD VSS VSS gf180mcu_fd_sc_mcu7t5v0__dlyd_1
Xoutput942 _1375_/ZN tl_h_d_o[30] VDD VDD VSS VSS gf180mcu_fd_sc_mcu7t5v0__dlyd_1
Xoutput931 _1295_/ZN tl_h_d_o[20] VDD VDD VSS VSS gf180mcu_fd_sc_mcu7t5v0__dlyd_1
X_1659_ _1870_/B2 _1564_/Z _1662_/S _1659_/Z VDD VDD VSS VSS gf180mcu_fd_sc_mcu7t5v0__mux2_2
Xoutput975 _2244_/ZN tl_h_d_o[60] VDD VDD VSS VSS gf180mcu_fd_sc_mcu7t5v0__dlyd_1
Xoutput986 _2068_/ZN tl_h_i_o[10] VDD VDD VSS VSS gf180mcu_fd_sc_mcu7t5v0__dlyd_1
Xoutput997 _2272_/ZN tl_h_i_o[20] VDD VDD VSS VSS gf180mcu_fd_sc_mcu7t5v0__dlyd_1
XFILLER_100_454 VDD VDD VSS VSS gf180mcu_fd_sc_mcu7t5v0__fill_1
XFILLER_100_465 VDD VDD VSS VSS gf180mcu_fd_sc_mcu7t5v0__fill_2
XFILLER_100_487 VDD VDD VSS VSS gf180mcu_fd_sc_mcu7t5v0__fillcap_4
XFILLER_73_349 VDD VDD VSS VSS gf180mcu_fd_sc_mcu7t5v0__fill_1
XFILLER_27_766 VDD VDD VSS VSS gf180mcu_fd_sc_mcu7t5v0__fillcap_4
XPHY_EDGE_ROW_53_Left_172 VDD VSS gf180mcu_fd_sc_mcu7t5v0__endcap
XFILLER_10_699 VDD VDD VSS VSS gf180mcu_fd_sc_mcu7t5v0__fillcap_8
XPHY_EDGE_ROW_62_Left_181 VDD VSS gf180mcu_fd_sc_mcu7t5v0__endcap
XTAP_TAPCELL_ROW_114_1627 VDD VSS gf180mcu_fd_sc_mcu7t5v0__filltie
XFILLER_78_32 VDD VDD VSS VSS gf180mcu_fd_sc_mcu7t5v0__fill_2
XFILLER_2_865 VDD VDD VSS VSS gf180mcu_fd_sc_mcu7t5v0__fill_1
XFILLER_96_419 VDD VDD VSS VSS gf180mcu_fd_sc_mcu7t5v0__fillcap_16
XFILLER_49_368 VDD VDD VSS VSS gf180mcu_fd_sc_mcu7t5v0__fill_1
XPHY_EDGE_ROW_71_Left_190 VDD VSS gf180mcu_fd_sc_mcu7t5v0__endcap
XFILLER_92_603 VDD VDD VSS VSS gf180mcu_fd_sc_mcu7t5v0__fill_1
XFILLER_64_349 VDD VDD VSS VSS gf180mcu_fd_sc_mcu7t5v0__fillcap_16
XFILLER_17_276 VDD VDD VSS VSS gf180mcu_fd_sc_mcu7t5v0__fillcap_4
XTAP_TAPCELL_ROW_15_433 VDD VSS gf180mcu_fd_sc_mcu7t5v0__filltie
XFILLER_32_279 VDD VDD VSS VSS gf180mcu_fd_sc_mcu7t5v0__fillcap_8
XTAP_TAPCELL_ROW_43_775 VDD VSS gf180mcu_fd_sc_mcu7t5v0__filltie
X_2700_ _2700_/I _2700_/Z VDD VDD VSS VSS gf180mcu_fd_sc_mcu7t5v0__buf_1
XFILLER_9_486 VDD VDD VSS VSS gf180mcu_fd_sc_mcu7t5v0__fillcap_4
X_2562_ _2562_/D _2567_/RN clkload2/I _2562_/Q VDD VDD VSS VSS gf180mcu_fd_sc_mcu7t5v0__dffrnq_1
X_1513_ _1914_/B2 _1550_/A2 _1513_/Z VDD VDD VSS VSS gf180mcu_fd_sc_mcu7t5v0__or2_1
X_2493_ _2493_/A1 _2493_/A2 _2493_/B _2497_/A2 VDD VDD VSS VSS gf180mcu_fd_sc_mcu7t5v0__oai21_1
X_1444_ input34/Z _1468_/A2 _1444_/B1 _1444_/B2 _1445_/I VDD VDD VSS VSS gf180mcu_fd_sc_mcu7t5v0__aoi22_1
X_1375_ _1407_/A1 _1375_/A2 _1375_/ZN VDD VDD VSS VSS gf180mcu_fd_sc_mcu7t5v0__nor2_1
XFILLER_95_430 VDD VDD VSS VSS gf180mcu_fd_sc_mcu7t5v0__fillcap_4
XFILLER_55_349 VDD VDD VSS VSS gf180mcu_fd_sc_mcu7t5v0__fill_1
XFILLER_24_769 VDD VDD VSS VSS gf180mcu_fd_sc_mcu7t5v0__fill_2
XFILLER_51_544 VDD VDD VSS VSS gf180mcu_fd_sc_mcu7t5v0__fill_1
XFILLER_23_279 VDD VDD VSS VSS gf180mcu_fd_sc_mcu7t5v0__fill_1
XFILLER_31_290 VDD VDD VSS VSS gf180mcu_fd_sc_mcu7t5v0__fill_1
Xoutput772 _1777_/ZN tl_d_rom_o[56] VDD VDD VSS VSS gf180mcu_fd_sc_mcu7t5v0__dlyd_1
Xoutput761 _1757_/ZN tl_d_rom_o[46] VDD VDD VSS VSS gf180mcu_fd_sc_mcu7t5v0__dlyd_1
Xoutput750 _1737_/ZN tl_d_rom_o[36] VDD VDD VSS VSS gf180mcu_fd_sc_mcu7t5v0__dlyd_1
Xoutput794 _1817_/ZN tl_d_rom_o[76] VDD VDD VSS VSS gf180mcu_fd_sc_mcu7t5v0__dlyd_1
Xoutput783 _1797_/ZN tl_d_rom_o[66] VDD VDD VSS VSS gf180mcu_fd_sc_mcu7t5v0__dlyd_1
XFILLER_98_290 VDD VDD VSS VSS gf180mcu_fd_sc_mcu7t5v0__fill_1
XFILLER_64_34 VDD VDD VSS VSS gf180mcu_fd_sc_mcu7t5v0__fill_1
XFILLER_42_522 VDD VDD VSS VSS gf180mcu_fd_sc_mcu7t5v0__fill_2
XFILLER_82_691 VDD VDD VSS VSS gf180mcu_fd_sc_mcu7t5v0__fill_2
XFILLER_70_831 VDD VDD VSS VSS gf180mcu_fd_sc_mcu7t5v0__fill_1
XTAP_TAPCELL_ROW_64_1025 VDD VSS gf180mcu_fd_sc_mcu7t5v0__filltie
XFILLER_14_268 VDD VDD VSS VSS gf180mcu_fd_sc_mcu7t5v0__fillcap_8
XFILLER_42_577 VDD VDD VSS VSS gf180mcu_fd_sc_mcu7t5v0__fill_1
XTAP_TAPCELL_ROW_40_734 VDD VSS gf180mcu_fd_sc_mcu7t5v0__filltie
XTAP_TAPCELL_ROW_12_403 VDD VSS gf180mcu_fd_sc_mcu7t5v0__filltie
XTAP_TAPCELL_ROW_20_491 VDD VSS gf180mcu_fd_sc_mcu7t5v0__filltie
XFILLER_6_467 VDD VDD VSS VSS gf180mcu_fd_sc_mcu7t5v0__fill_2
XTAP_TAPCELL_ROW_75_1154 VDD VSS gf180mcu_fd_sc_mcu7t5v0__filltie
XFILLER_69_419 VDD VDD VSS VSS gf180mcu_fd_sc_mcu7t5v0__fill_1
XFILLER_65_614 VDD VDD VSS VSS gf180mcu_fd_sc_mcu7t5v0__fillcap_4
X_1160_ _1158_/Z _1200_/A1 _1183_/A1 VDD VDD VSS VSS gf180mcu_fd_sc_mcu7t5v0__nor2_1
XFILLER_77_463 VDD VDD VSS VSS gf180mcu_fd_sc_mcu7t5v0__fillcap_4
XTAP_TAPCELL_ROW_48_834 VDD VSS gf180mcu_fd_sc_mcu7t5v0__filltie
XFILLER_64_135 VDD VDD VSS VSS gf180mcu_fd_sc_mcu7t5v0__fill_2
XFILLER_64_146 VDD VDD VSS VSS gf180mcu_fd_sc_mcu7t5v0__fillcap_16
X_1091_ _1091_/I _2135_/A1 VDD VDD VSS VSS gf180mcu_fd_sc_mcu7t5v0__clkinv_1
XFILLER_80_639 VDD VDD VSS VSS gf180mcu_fd_sc_mcu7t5v0__fillcap_16
XFILLER_61_864 VDD VDD VSS VSS gf180mcu_fd_sc_mcu7t5v0__fill_2
XTAP_TAPCELL_ROW_86_1294 VDD VSS gf180mcu_fd_sc_mcu7t5v0__filltie
XTAP_TAPCELL_ROW_86_1283 VDD VSS gf180mcu_fd_sc_mcu7t5v0__filltie
XTAP_TAPCELL_ROW_28_591 VDD VSS gf180mcu_fd_sc_mcu7t5v0__filltie
XFILLER_60_374 VDD VDD VSS VSS gf180mcu_fd_sc_mcu7t5v0__fillcap_8
X_1993_ _1993_/I _1993_/ZN VDD VDD VSS VSS gf180mcu_fd_sc_mcu7t5v0__clkinv_1
X_2545_ _2545_/D _2580_/RN clkload1/I _2545_/Q VDD VDD VSS VSS gf180mcu_fd_sc_mcu7t5v0__dffrnq_1
XFILLER_102_516 VDD VDD VSS VSS gf180mcu_fd_sc_mcu7t5v0__fillcap_8
XFILLER_102_527 VDD VDD VSS VSS gf180mcu_fd_sc_mcu7t5v0__fillcap_4
X_2476_ _2761_/I _2586_/Q _2476_/S _2586_/D VDD VDD VSS VSS gf180mcu_fd_sc_mcu7t5v0__mux2_2
X_1427_ _1499_/A1 _1425_/Z _1427_/B _1428_/B1 VDD VDD VSS VSS gf180mcu_fd_sc_mcu7t5v0__oai21_1
XFILLER_28_305 VDD VDD VSS VSS gf180mcu_fd_sc_mcu7t5v0__fillcap_8
X_1358_ _1358_/A1 _1398_/A2 _1358_/B1 _2160_/C _1359_/A2 VDD VDD VSS VSS gf180mcu_fd_sc_mcu7t5v0__aoi22_1
XFILLER_95_282 VDD VDD VSS VSS gf180mcu_fd_sc_mcu7t5v0__fillcap_32
XFILLER_83_422 VDD VDD VSS VSS gf180mcu_fd_sc_mcu7t5v0__fill_1
X_1289_ _1393_/A1 _2269_/A2 _1289_/Z VDD VDD VSS VSS gf180mcu_fd_sc_mcu7t5v0__and2_1
XFILLER_52_831 VDD VDD VSS VSS gf180mcu_fd_sc_mcu7t5v0__fill_1
XFILLER_51_374 VDD VDD VSS VSS gf180mcu_fd_sc_mcu7t5v0__fill_1
Xclkload3 clkload3/I clkload3/ZN VDD VDD VSS VSS gf180mcu_fd_sc_mcu7t5v0__inv_4
XFILLER_3_448 VDD VDD VSS VSS gf180mcu_fd_sc_mcu7t5v0__fill_1
Xoutput580 _2662_/Z tl_d_dmem_o[75] VDD VDD VSS VSS gf180mcu_fd_sc_mcu7t5v0__dlyd_1
Xfanout1216 fanout1221/Z _2317_/A1 VDD VDD VSS VSS gf180mcu_fd_sc_mcu7t5v0__dlyd_1
Xoutput591 _2672_/Z tl_d_dmem_o[85] VDD VDD VSS VSS gf180mcu_fd_sc_mcu7t5v0__dlyd_1
XFILLER_78_238 VDD VDD VSS VSS gf180mcu_fd_sc_mcu7t5v0__fillcap_4
XFILLER_87_750 VDD VDD VSS VSS gf180mcu_fd_sc_mcu7t5v0__fillcap_4
XFILLER_19_338 VDD VDD VSS VSS gf180mcu_fd_sc_mcu7t5v0__fillcap_8
XFILLER_47_625 VDD VDD VSS VSS gf180mcu_fd_sc_mcu7t5v0__fillcap_4
XTAP_TAPCELL_ROW_70_1095 VDD VSS gf180mcu_fd_sc_mcu7t5v0__filltie
XTAP_TAPCELL_ROW_109_1559 VDD VSS gf180mcu_fd_sc_mcu7t5v0__filltie
XFILLER_43_842 VDD VDD VSS VSS gf180mcu_fd_sc_mcu7t5v0__fillcap_4
XFILLER_61_138 VDD VDD VSS VSS gf180mcu_fd_sc_mcu7t5v0__fill_2
XFILLER_30_547 VDD VDD VSS VSS gf180mcu_fd_sc_mcu7t5v0__fill_2
XTAP_TAPCELL_ROW_53_892 VDD VSS gf180mcu_fd_sc_mcu7t5v0__filltie
XTAP_TAPCELL_ROW_25_561 VDD VSS gf180mcu_fd_sc_mcu7t5v0__filltie
XFILLER_70_694 VDD VDD VSS VSS gf180mcu_fd_sc_mcu7t5v0__fillcap_32
X_2330_ _2374_/A1 _2330_/A2 _2332_/A1 VDD VDD VSS VSS gf180mcu_fd_sc_mcu7t5v0__nand2_1
X_2261_ _2293_/A1 _2261_/A2 _2262_/A2 VDD VDD VSS VSS gf180mcu_fd_sc_mcu7t5v0__nand2_1
X_1212_ _2199_/A2 _1228_/A2 _1213_/C VDD VDD VSS VSS gf180mcu_fd_sc_mcu7t5v0__nand2_1
XFILLER_65_422 VDD VDD VSS VSS gf180mcu_fd_sc_mcu7t5v0__fillcap_32
X_2192_ _2192_/A1 _2224_/C _2192_/B1 _2192_/B2 _2192_/ZN VDD VDD VSS VSS gf180mcu_fd_sc_mcu7t5v0__aoi22_1
XTAP_TAPCELL_ROW_88_1312 VDD VSS gf180mcu_fd_sc_mcu7t5v0__filltie
X_1143_ _2741_/I _1145_/B _1143_/A3 _1143_/A4 _2456_/A1 VDD VDD VSS VSS gf180mcu_fd_sc_mcu7t5v0__nand4_1
XFILLER_53_628 VDD VDD VSS VSS gf180mcu_fd_sc_mcu7t5v0__fill_2
X_1074_ _2563_/Q _2439_/A2 VDD VDD VSS VSS gf180mcu_fd_sc_mcu7t5v0__clkinv_1
XPHY_EDGE_ROW_9_Left_128 VDD VSS gf180mcu_fd_sc_mcu7t5v0__endcap
XFILLER_34_831 VDD VDD VSS VSS gf180mcu_fd_sc_mcu7t5v0__fill_1
XFILLER_60_171 VDD VDD VSS VSS gf180mcu_fd_sc_mcu7t5v0__fillcap_4
XFILLER_60_193 VDD VDD VSS VSS gf180mcu_fd_sc_mcu7t5v0__fillcap_8
X_1976_ _1976_/A1 _1976_/A2 _2030_/B1 _2720_/I _1977_/I VDD VDD VSS VSS gf180mcu_fd_sc_mcu7t5v0__aoi22_1
XTAP_TAPCELL_ROW_99_1441 VDD VSS gf180mcu_fd_sc_mcu7t5v0__filltie
XFILLER_0_418 VDD VDD VSS VSS gf180mcu_fd_sc_mcu7t5v0__fill_2
X_2528_ _2528_/I _2529_/A3 VDD VDD VSS VSS gf180mcu_fd_sc_mcu7t5v0__clkinv_1
Xinput308 tl_h_d_i[35] _1924_/B2 VDD VDD VSS VSS gf180mcu_fd_sc_mcu7t5v0__dlyd_1
Xinput319 tl_h_d_i[45] _1944_/B2 VDD VDD VSS VSS gf180mcu_fd_sc_mcu7t5v0__dlyd_1
X_2459_ _2706_/I _2571_/Q _2462_/S _2571_/D VDD VDD VSS VSS gf180mcu_fd_sc_mcu7t5v0__mux2_2
XFILLER_69_772 VDD VDD VSS VSS gf180mcu_fd_sc_mcu7t5v0__fillcap_32
XFILLER_28_168 VDD VDD VSS VSS gf180mcu_fd_sc_mcu7t5v0__fillcap_4
XFILLER_44_617 VDD VDD VSS VSS gf180mcu_fd_sc_mcu7t5v0__fill_2
XFILLER_56_499 VDD VDD VSS VSS gf180mcu_fd_sc_mcu7t5v0__fill_1
XTAP_TAPCELL_ROW_3_289 VDD VSS gf180mcu_fd_sc_mcu7t5v0__filltie
XFILLER_25_842 VDD VDD VSS VSS gf180mcu_fd_sc_mcu7t5v0__fillcap_16
XFILLER_71_469 VDD VDD VSS VSS gf180mcu_fd_sc_mcu7t5v0__fillcap_16
XFILLER_40_823 VDD VDD VSS VSS gf180mcu_fd_sc_mcu7t5v0__fillcap_8
XTAP_TAPCELL_ROW_50_851 VDD VSS gf180mcu_fd_sc_mcu7t5v0__filltie
XTAP_TAPCELL_ROW_22_520 VDD VSS gf180mcu_fd_sc_mcu7t5v0__filltie
XTAP_TAPCELL_ROW_50_862 VDD VSS gf180mcu_fd_sc_mcu7t5v0__filltie
XFILLER_20_591 VDD VDD VSS VSS gf180mcu_fd_sc_mcu7t5v0__fillcap_4
XTAP_TAPCELL_ROW_72_1124 VDD VSS gf180mcu_fd_sc_mcu7t5v0__filltie
XFILLER_59_282 VDD VDD VSS VSS gf180mcu_fd_sc_mcu7t5v0__fill_2
Xfanout1057 _2537_/A2 _1958_/B1 VDD VDD VSS VSS gf180mcu_fd_sc_mcu7t5v0__dlyd_1
Xfanout1068 _1938_/A2 _2534_/A2 VDD VDD VSS VSS gf180mcu_fd_sc_mcu7t5v0__dlyd_1
Xfanout1079 _1183_/ZN _2044_/A2 VDD VDD VSS VSS gf180mcu_fd_sc_mcu7t5v0__dlyd_1
XTAP_TAPCELL_ROW_58_951 VDD VSS gf180mcu_fd_sc_mcu7t5v0__filltie
XFILLER_74_241 VDD VDD VSS VSS gf180mcu_fd_sc_mcu7t5v0__fillcap_4
XFILLER_35_628 VDD VDD VSS VSS gf180mcu_fd_sc_mcu7t5v0__fill_2
XFILLER_62_403 VDD VDD VSS VSS gf180mcu_fd_sc_mcu7t5v0__fillcap_4
XFILLER_16_831 VDD VDD VSS VSS gf180mcu_fd_sc_mcu7t5v0__fill_1
XFILLER_15_352 VDD VDD VSS VSS gf180mcu_fd_sc_mcu7t5v0__fillcap_64
XTAP_TAPCELL_ROW_83_1253 VDD VSS gf180mcu_fd_sc_mcu7t5v0__filltie
XFILLER_30_333 VDD VDD VSS VSS gf180mcu_fd_sc_mcu7t5v0__fillcap_8
X_1830_ _2397_/I0 _1830_/A2 _2533_/A2 _2758_/I _1831_/I VDD VDD VSS VSS gf180mcu_fd_sc_mcu7t5v0__aoi22_1
X_1761_ _1761_/I _1761_/ZN VDD VDD VSS VSS gf180mcu_fd_sc_mcu7t5v0__clkinv_1
X_1692_ _1882_/A1 _1728_/A2 _1722_/B1 _1882_/B2 _1693_/I VDD VDD VSS VSS gf180mcu_fd_sc_mcu7t5v0__aoi22_1
XTAP_TAPCELL_ROW_94_1382 VDD VSS gf180mcu_fd_sc_mcu7t5v0__filltie
XFILLER_98_823 VDD VDD VSS VSS gf180mcu_fd_sc_mcu7t5v0__fillcap_8
XFILLER_32_2 VDD VDD VSS VSS gf180mcu_fd_sc_mcu7t5v0__fill_1
X_2313_ _2333_/A1 _2313_/A2 _2314_/A2 VDD VDD VSS VSS gf180mcu_fd_sc_mcu7t5v0__nand2_1
XFILLER_97_311 VDD VDD VSS VSS gf180mcu_fd_sc_mcu7t5v0__fillcap_32
X_2244_ _2244_/A1 _2244_/A2 _2244_/B _2244_/ZN VDD VDD VSS VSS gf180mcu_fd_sc_mcu7t5v0__oai21_1
XFILLER_65_241 VDD VDD VSS VSS gf180mcu_fd_sc_mcu7t5v0__fillcap_4
X_2175_ _2175_/A1 _2236_/B _2176_/B VDD VDD VSS VSS gf180mcu_fd_sc_mcu7t5v0__nand2_1
X_1126_ _2539_/Q _1066_/I _1126_/ZN VDD VDD VSS VSS gf180mcu_fd_sc_mcu7t5v0__nor2_1
XFILLER_93_583 VDD VDD VSS VSS gf180mcu_fd_sc_mcu7t5v0__fill_1
XTAP_TAPCELL_ROW_0_259 VDD VSS gf180mcu_fd_sc_mcu7t5v0__filltie
XTAP_TAPCELL_ROW_0_248 VDD VSS gf180mcu_fd_sc_mcu7t5v0__filltie
XFILLER_22_801 VDD VDD VSS VSS gf180mcu_fd_sc_mcu7t5v0__fillcap_4
XFILLER_80_244 VDD VDD VSS VSS gf180mcu_fd_sc_mcu7t5v0__fill_1
XFILLER_22_823 VDD VDD VSS VSS gf180mcu_fd_sc_mcu7t5v0__fillcap_8
XTAP_TAPCELL_ROW_36_689 VDD VSS gf180mcu_fd_sc_mcu7t5v0__filltie
XFILLER_33_193 VDD VDD VSS VSS gf180mcu_fd_sc_mcu7t5v0__fill_2
X_1959_ _1959_/I _1959_/ZN VDD VDD VSS VSS gf180mcu_fd_sc_mcu7t5v0__clkinv_1
XTAP_TAPCELL_ROW_8_348 VDD VSS gf180mcu_fd_sc_mcu7t5v0__filltie
XFILLER_88_333 VDD VDD VSS VSS gf180mcu_fd_sc_mcu7t5v0__fillcap_4
Xinput105 tl_d_esram_i[43] _2363_/A1 VDD VDD VSS VSS gf180mcu_fd_sc_mcu7t5v0__dlyd_1
Xinput116 tl_d_esram_i[53] _2202_/A1 VDD VDD VSS VSS gf180mcu_fd_sc_mcu7t5v0__dlyd_1
Xinput127 tl_d_esram_i[63] _1257_/A2 VDD VDD VSS VSS gf180mcu_fd_sc_mcu7t5v0__dlyd_1
XFILLER_29_422 VDD VDD VSS VSS gf180mcu_fd_sc_mcu7t5v0__fillcap_32
Xinput138 tl_d_rom_i[13] _2163_/A1 VDD VDD VSS VSS gf180mcu_fd_sc_mcu7t5v0__dlyd_1
Xinput149 tl_d_rom_i[23] _1312_/A1 VDD VDD VSS VSS gf180mcu_fd_sc_mcu7t5v0__dlyd_1
Xload_slew1215 _1504_/A2 _1368_/A2 VDD VDD VSS VSS gf180mcu_fd_sc_mcu7t5v0__buf_4
Xload_slew1226 _2251_/A3 _2345_/A1 VDD VDD VSS VSS gf180mcu_fd_sc_mcu7t5v0__buf_4
Xload_slew1248 _2600_/RN _2601_/RN VDD VDD VSS VSS gf180mcu_fd_sc_mcu7t5v0__buf_4
XTAP_TAPCELL_ROW_55_921 VDD VSS gf180mcu_fd_sc_mcu7t5v0__filltie
XTAP_TAPCELL_ROW_106_1529 VDD VSS gf180mcu_fd_sc_mcu7t5v0__filltie
XFILLER_72_734 VDD VDD VSS VSS gf180mcu_fd_sc_mcu7t5v0__fill_1
XFILLER_72_34 VDD VDD VSS VSS gf180mcu_fd_sc_mcu7t5v0__fill_1
XTAP_TAPCELL_ROW_117_1658 VDD VSS gf180mcu_fd_sc_mcu7t5v0__filltie
XFILLER_106_493 VDD VDD VSS VSS gf180mcu_fd_sc_mcu7t5v0__fillcap_4
XFILLER_94_358 VDD VDD VSS VSS gf180mcu_fd_sc_mcu7t5v0__fill_2
XFILLER_16_661 VDD VDD VSS VSS gf180mcu_fd_sc_mcu7t5v0__fillcap_4
XFILLER_90_597 VDD VDD VSS VSS gf180mcu_fd_sc_mcu7t5v0__fillcap_32
XTAP_TAPCELL_ROW_33_648 VDD VSS gf180mcu_fd_sc_mcu7t5v0__filltie
XPHY_EDGE_ROW_99_Left_218 VDD VSS gf180mcu_fd_sc_mcu7t5v0__endcap
X_1813_ _1813_/I _1813_/ZN VDD VDD VSS VSS gf180mcu_fd_sc_mcu7t5v0__clkinv_1
X_1744_ _1934_/A1 _1772_/A2 _1762_/B1 _1934_/B2 _1745_/I VDD VDD VSS VSS gf180mcu_fd_sc_mcu7t5v0__aoi22_1
XTAP_TAPCELL_ROW_96_1411 VDD VSS gf180mcu_fd_sc_mcu7t5v0__filltie
X_1675_ _1675_/I _1675_/ZN VDD VDD VSS VSS gf180mcu_fd_sc_mcu7t5v0__clkinv_1
XPHY_EDGE_ROW_15_Right_15 VDD VSS gf180mcu_fd_sc_mcu7t5v0__endcap
XTAP_TAPCELL_ROW_5_318 VDD VSS gf180mcu_fd_sc_mcu7t5v0__filltie
X_2227_ _2227_/A1 _2233_/A2 _2228_/A3 VDD VDD VSS VSS gf180mcu_fd_sc_mcu7t5v0__nand2_1
XFILLER_85_347 VDD VDD VSS VSS gf180mcu_fd_sc_mcu7t5v0__fill_2
XFILLER_26_403 VDD VDD VSS VSS gf180mcu_fd_sc_mcu7t5v0__fillcap_32
XFILLER_38_241 VDD VDD VSS VSS gf180mcu_fd_sc_mcu7t5v0__fillcap_4
XFILLER_38_263 VDD VDD VSS VSS gf180mcu_fd_sc_mcu7t5v0__fillcap_8
XFILLER_54_734 VDD VDD VSS VSS gf180mcu_fd_sc_mcu7t5v0__fill_1
XFILLER_66_594 VDD VDD VSS VSS gf180mcu_fd_sc_mcu7t5v0__fill_1
X_2158_ input71/Z _2158_/A2 _2159_/A3 VDD VDD VSS VSS gf180mcu_fd_sc_mcu7t5v0__nand2_1
X_2089_ _1066_/I _2553_/Q _2196_/A1 _2347_/A2 _2090_/A2 VDD VDD VSS VSS gf180mcu_fd_sc_mcu7t5v0__aoi22_1
X_1109_ _2458_/A1 _1109_/A2 _2153_/A2 VDD VDD VSS VSS gf180mcu_fd_sc_mcu7t5v0__nand2_1
XPHY_EDGE_ROW_24_Right_24 VDD VSS gf180mcu_fd_sc_mcu7t5v0__endcap
XPHY_EDGE_ROW_33_Right_33 VDD VSS gf180mcu_fd_sc_mcu7t5v0__endcap
XFILLER_89_664 VDD VDD VSS VSS gf180mcu_fd_sc_mcu7t5v0__fillcap_16
XTAP_TAPCELL_ROW_112_1599 VDD VSS gf180mcu_fd_sc_mcu7t5v0__filltie
XFILLER_92_807 VDD VDD VSS VSS gf180mcu_fd_sc_mcu7t5v0__fillcap_16
XFILLER_76_358 VDD VDD VSS VSS gf180mcu_fd_sc_mcu7t5v0__fillcap_4
XFILLER_29_241 VDD VDD VSS VSS gf180mcu_fd_sc_mcu7t5v0__fillcap_32
XFILLER_91_306 VDD VDD VSS VSS gf180mcu_fd_sc_mcu7t5v0__fill_1
Xload_slew1056 _1930_/B1 _1914_/B1 VDD VDD VSS VSS gf180mcu_fd_sc_mcu7t5v0__buf_4
Xload_slew1067 _1184_/ZN _2044_/B1 VDD VDD VSS VSS gf180mcu_fd_sc_mcu7t5v0__buf_2
XPHY_EDGE_ROW_42_Right_42 VDD VSS gf180mcu_fd_sc_mcu7t5v0__endcap
XFILLER_84_391 VDD VDD VSS VSS gf180mcu_fd_sc_mcu7t5v0__fill_1
XFILLER_84_380 VDD VDD VSS VSS gf180mcu_fd_sc_mcu7t5v0__fillcap_4
Xload_slew1078 _1976_/A2 _2030_/A2 VDD VDD VSS VSS gf180mcu_fd_sc_mcu7t5v0__buf_4
Xload_slew1089 _1732_/A2 _1728_/A2 VDD VDD VSS VSS gf180mcu_fd_sc_mcu7t5v0__buf_4
XTAP_TAPCELL_ROW_67_1056 VDD VSS gf180mcu_fd_sc_mcu7t5v0__filltie
XFILLER_60_737 VDD VDD VSS VSS gf180mcu_fd_sc_mcu7t5v0__fillcap_64
XTAP_TAPCELL_ROW_80_1212 VDD VSS gf180mcu_fd_sc_mcu7t5v0__filltie
XTAP_TAPCELL_ROW_30_618 VDD VSS gf180mcu_fd_sc_mcu7t5v0__filltie
XPHY_EDGE_ROW_51_Right_51 VDD VSS gf180mcu_fd_sc_mcu7t5v0__endcap
XTAP_TAPCELL_ROW_10_375 VDD VSS gf180mcu_fd_sc_mcu7t5v0__filltie
XTAP_TAPCELL_ROW_78_1196 VDD VSS gf180mcu_fd_sc_mcu7t5v0__filltie
X_1460_ input37/Z _1500_/A2 _1460_/B1 _2247_/A2 _1461_/I VDD VDD VSS VSS gf180mcu_fd_sc_mcu7t5v0__aoi22_1
X_1391_ _1503_/A1 _1391_/A2 _1391_/ZN VDD VDD VSS VSS gf180mcu_fd_sc_mcu7t5v0__nor2_1
XTAP_TAPCELL_ROW_91_1352 VDD VSS gf180mcu_fd_sc_mcu7t5v0__filltie
XFILLER_67_314 VDD VDD VSS VSS gf180mcu_fd_sc_mcu7t5v0__fill_1
XFILLER_95_634 VDD VDD VSS VSS gf180mcu_fd_sc_mcu7t5v0__fill_1
Xinput480 tl_h_i_i[88] _1165_/A3 VDD VDD VSS VSS gf180mcu_fd_sc_mcu7t5v0__dlyd_1
Xinput491 tl_h_i_i[98] _2396_/I0 VDD VDD VSS VSS gf180mcu_fd_sc_mcu7t5v0__dlyd_1
XTAP_TAPCELL_ROW_38_718 VDD VSS gf180mcu_fd_sc_mcu7t5v0__filltie
XTAP_TAPCELL_ROW_38_707 VDD VSS gf180mcu_fd_sc_mcu7t5v0__filltie
XPHY_EDGE_ROW_60_Right_60 VDD VSS gf180mcu_fd_sc_mcu7t5v0__endcap
XFILLER_94_166 VDD VDD VSS VSS gf180mcu_fd_sc_mcu7t5v0__fill_1
XFILLER_48_594 VDD VDD VSS VSS gf180mcu_fd_sc_mcu7t5v0__fill_1
X_2012_ _2012_/A1 _2022_/A2 _2022_/B1 _2738_/I _2013_/I VDD VDD VSS VSS gf180mcu_fd_sc_mcu7t5v0__aoi22_1
XTAP_TAPCELL_ROW_18_475 VDD VSS gf180mcu_fd_sc_mcu7t5v0__filltie
XFILLER_50_247 VDD VDD VSS VSS gf180mcu_fd_sc_mcu7t5v0__fillcap_64
XFILLER_31_483 VDD VDD VSS VSS gf180mcu_fd_sc_mcu7t5v0__fillcap_4
X_2776_ _2776_/I _2776_/Z VDD VDD VSS VSS gf180mcu_fd_sc_mcu7t5v0__buf_1
Xoutput921 _2155_/ZN tl_h_d_o[11] VDD VDD VSS VSS gf180mcu_fd_sc_mcu7t5v0__dlyd_1
Xoutput910 _2751_/Z tl_d_uart_o[92] VDD VDD VSS VSS gf180mcu_fd_sc_mcu7t5v0__dlyd_1
X_1727_ _1727_/I _1727_/ZN VDD VDD VSS VSS gf180mcu_fd_sc_mcu7t5v0__clkinv_1
XPHY_EDGE_ROW_103_Right_103 VDD VSS gf180mcu_fd_sc_mcu7t5v0__endcap
Xoutput954 _1463_/ZN tl_h_d_o[41] VDD VDD VSS VSS gf180mcu_fd_sc_mcu7t5v0__dlyd_1
Xoutput943 _1383_/ZN tl_h_d_o[31] VDD VDD VSS VSS gf180mcu_fd_sc_mcu7t5v0__dlyd_1
Xoutput932 _1303_/ZN tl_h_d_o[21] VDD VDD VSS VSS gf180mcu_fd_sc_mcu7t5v0__dlyd_1
X_1658_ _1868_/B2 _1665_/S _1658_/Z VDD VDD VSS VSS gf180mcu_fd_sc_mcu7t5v0__or2_1
XFILLER_59_804 VDD VDD VSS VSS gf180mcu_fd_sc_mcu7t5v0__fill_2
Xoutput965 _2198_/ZN tl_h_d_o[51] VDD VDD VSS VSS gf180mcu_fd_sc_mcu7t5v0__dlyd_1
Xoutput976 _2248_/ZN tl_h_d_o[61] VDD VDD VSS VSS gf180mcu_fd_sc_mcu7t5v0__dlyd_1
Xoutput987 _2070_/ZN tl_h_i_o[11] VDD VDD VSS VSS gf180mcu_fd_sc_mcu7t5v0__dlyd_1
XFILLER_58_314 VDD VDD VSS VSS gf180mcu_fd_sc_mcu7t5v0__fill_1
Xoutput998 _2276_/ZN tl_h_i_o[21] VDD VDD VSS VSS gf180mcu_fd_sc_mcu7t5v0__dlyd_1
X_1589_ _2749_/I _2751_/I _1614_/A3 VDD VDD VSS VSS gf180mcu_fd_sc_mcu7t5v0__xnor2_1
XFILLER_100_444 VDD VDD VSS VSS gf180mcu_fd_sc_mcu7t5v0__fillcap_8
XFILLER_86_667 VDD VDD VSS VSS gf180mcu_fd_sc_mcu7t5v0__fillcap_16
XFILLER_74_807 VDD VDD VSS VSS gf180mcu_fd_sc_mcu7t5v0__fillcap_16
XFILLER_26_244 VDD VDD VSS VSS gf180mcu_fd_sc_mcu7t5v0__fill_1
XFILLER_41_203 VDD VDD VSS VSS gf180mcu_fd_sc_mcu7t5v0__fillcap_4
XFILLER_42_737 VDD VDD VSS VSS gf180mcu_fd_sc_mcu7t5v0__fillcap_64
XFILLER_10_667 VDD VDD VSS VSS gf180mcu_fd_sc_mcu7t5v0__fillcap_32
XTAP_TAPCELL_ROW_114_1628 VDD VSS gf180mcu_fd_sc_mcu7t5v0__filltie
XFILLER_103_282 VDD VDD VSS VSS gf180mcu_fd_sc_mcu7t5v0__fill_1
XFILLER_49_336 VDD VDD VSS VSS gf180mcu_fd_sc_mcu7t5v0__fillcap_8
XFILLER_64_317 VDD VDD VSS VSS gf180mcu_fd_sc_mcu7t5v0__fillcap_32
XFILLER_92_659 VDD VDD VSS VSS gf180mcu_fd_sc_mcu7t5v0__fillcap_4
XFILLER_76_177 VDD VDD VSS VSS gf180mcu_fd_sc_mcu7t5v0__fillcap_64
XFILLER_45_553 VDD VDD VSS VSS gf180mcu_fd_sc_mcu7t5v0__fillcap_4
XFILLER_32_225 VDD VDD VSS VSS gf180mcu_fd_sc_mcu7t5v0__fillcap_8
XFILLER_32_247 VDD VDD VSS VSS gf180mcu_fd_sc_mcu7t5v0__fillcap_32
XTAP_TAPCELL_ROW_15_434 VDD VSS gf180mcu_fd_sc_mcu7t5v0__filltie
XTAP_TAPCELL_ROW_43_776 VDD VSS gf180mcu_fd_sc_mcu7t5v0__filltie
X_2561_ _2561_/D _2567_/RN clkload2/I _2561_/Q VDD VDD VSS VSS gf180mcu_fd_sc_mcu7t5v0__dffrnq_1
X_2492_ _2589_/Q _2492_/A2 _2492_/B _2504_/A2 VDD VDD VSS VSS gf180mcu_fd_sc_mcu7t5v0__aoi21_1
X_1512_ _1912_/B2 _1550_/A2 _1512_/Z VDD VDD VSS VSS gf180mcu_fd_sc_mcu7t5v0__or2_1
X_1443_ _1499_/A1 _1441_/Z _1443_/B _1444_/B1 VDD VDD VSS VSS gf180mcu_fd_sc_mcu7t5v0__oai21_1
Xxbar_tlul_2to4_1270 tl_d_rom_o[90] VDD VDD VSS VSS gf180mcu_fd_sc_mcu7t5v0__tiel
X_1374_ _1374_/A1 _1406_/A2 _1374_/B1 _1390_/B2 _1375_/A2 VDD VDD VSS VSS gf180mcu_fd_sc_mcu7t5v0__aoi22_1
XFILLER_56_807 VDD VDD VSS VSS gf180mcu_fd_sc_mcu7t5v0__fillcap_16
XFILLER_68_667 VDD VDD VSS VSS gf180mcu_fd_sc_mcu7t5v0__fillcap_16
XFILLER_48_391 VDD VDD VSS VSS gf180mcu_fd_sc_mcu7t5v0__fill_2
XFILLER_24_737 VDD VDD VSS VSS gf180mcu_fd_sc_mcu7t5v0__fillcap_32
XFILLER_36_597 VDD VDD VSS VSS gf180mcu_fd_sc_mcu7t5v0__fill_2
XFILLER_118_864 VDD VDD VSS VSS gf180mcu_fd_sc_mcu7t5v0__fill_2
X_2759_ _2759_/I _2759_/Z VDD VDD VSS VSS gf180mcu_fd_sc_mcu7t5v0__buf_1
Xoutput762 _1759_/ZN tl_d_rom_o[47] VDD VDD VSS VSS gf180mcu_fd_sc_mcu7t5v0__dlyd_1
Xoutput751 _1739_/ZN tl_d_rom_o[37] VDD VDD VSS VSS gf180mcu_fd_sc_mcu7t5v0__dlyd_1
Xoutput740 _1719_/ZN tl_d_rom_o[27] VDD VDD VSS VSS gf180mcu_fd_sc_mcu7t5v0__dlyd_1
XFILLER_48_14 VDD VDD VSS VSS gf180mcu_fd_sc_mcu7t5v0__fill_2
XFILLER_59_623 VDD VDD VSS VSS gf180mcu_fd_sc_mcu7t5v0__fillcap_4
Xoutput795 _1819_/ZN tl_d_rom_o[77] VDD VDD VSS VSS gf180mcu_fd_sc_mcu7t5v0__dlyd_1
Xoutput784 _1799_/ZN tl_d_rom_o[67] VDD VDD VSS VSS gf180mcu_fd_sc_mcu7t5v0__dlyd_1
Xoutput773 _1779_/ZN tl_d_rom_o[57] VDD VDD VSS VSS gf180mcu_fd_sc_mcu7t5v0__dlyd_1
XFILLER_100_285 VDD VDD VSS VSS gf180mcu_fd_sc_mcu7t5v0__fill_2
XFILLER_46_317 VDD VDD VSS VSS gf180mcu_fd_sc_mcu7t5v0__fillcap_16
XFILLER_58_177 VDD VDD VSS VSS gf180mcu_fd_sc_mcu7t5v0__fillcap_16
XTAP_TAPCELL_ROW_64_1026 VDD VSS gf180mcu_fd_sc_mcu7t5v0__filltie
XTAP_TAPCELL_ROW_40_735 VDD VSS gf180mcu_fd_sc_mcu7t5v0__filltie
XTAP_TAPCELL_ROW_12_404 VDD VSS gf180mcu_fd_sc_mcu7t5v0__filltie
XFILLER_109_842 VDD VDD VSS VSS gf180mcu_fd_sc_mcu7t5v0__fillcap_4
XFILLER_109_864 VDD VDD VSS VSS gf180mcu_fd_sc_mcu7t5v0__fill_2
XTAP_TAPCELL_ROW_20_492 VDD VSS gf180mcu_fd_sc_mcu7t5v0__filltie
XFILLER_108_396 VDD VDD VSS VSS gf180mcu_fd_sc_mcu7t5v0__fillcap_16
XTAP_TAPCELL_ROW_75_1155 VDD VSS gf180mcu_fd_sc_mcu7t5v0__filltie
XFILLER_38_807 VDD VDD VSS VSS gf180mcu_fd_sc_mcu7t5v0__fillcap_16
XFILLER_77_442 VDD VDD VSS VSS gf180mcu_fd_sc_mcu7t5v0__fillcap_4
XFILLER_49_188 VDD VDD VSS VSS gf180mcu_fd_sc_mcu7t5v0__fillcap_4
XTAP_TAPCELL_ROW_48_835 VDD VSS gf180mcu_fd_sc_mcu7t5v0__filltie
X_1090_ _1090_/I _2128_/A1 VDD VDD VSS VSS gf180mcu_fd_sc_mcu7t5v0__clkinv_1
XFILLER_18_597 VDD VDD VSS VSS gf180mcu_fd_sc_mcu7t5v0__fillcap_64
XTAP_TAPCELL_ROW_86_1284 VDD VSS gf180mcu_fd_sc_mcu7t5v0__filltie
XTAP_TAPCELL_ROW_28_592 VDD VSS gf180mcu_fd_sc_mcu7t5v0__filltie
XFILLER_20_228 VDD VDD VSS VSS gf180mcu_fd_sc_mcu7t5v0__fillcap_16
X_1992_ _1992_/A1 _2030_/A2 _2030_/B1 _2728_/I _1993_/I VDD VDD VSS VSS gf180mcu_fd_sc_mcu7t5v0__aoi22_1
XFILLER_9_240 VDD VDD VSS VSS gf180mcu_fd_sc_mcu7t5v0__fill_1
X_2544_ _2544_/D _2558_/RN clkload0/I _2544_/Q VDD VDD VSS VSS gf180mcu_fd_sc_mcu7t5v0__dffsnq_1
X_2475_ _2760_/I _2585_/Q _2477_/S _2585_/D VDD VDD VSS VSS gf180mcu_fd_sc_mcu7t5v0__mux2_2
X_1426_ input98/Z _2158_/A2 _2379_/A3 _1427_/B VDD VDD VSS VSS gf180mcu_fd_sc_mcu7t5v0__nand3_1
XFILLER_87_228 VDD VDD VSS VSS gf180mcu_fd_sc_mcu7t5v0__fillcap_4
XFILLER_68_453 VDD VDD VSS VSS gf180mcu_fd_sc_mcu7t5v0__fill_2
X_1357_ _1357_/I _1358_/B1 VDD VDD VSS VSS gf180mcu_fd_sc_mcu7t5v0__clkinv_1
XFILLER_28_317 VDD VDD VSS VSS gf180mcu_fd_sc_mcu7t5v0__fillcap_64
XFILLER_56_659 VDD VDD VSS VSS gf180mcu_fd_sc_mcu7t5v0__fillcap_4
X_1288_ _1288_/A1 _1368_/A2 _2269_/A2 VDD VDD VSS VSS gf180mcu_fd_sc_mcu7t5v0__nand2_1
XFILLER_83_489 VDD VDD VSS VSS gf180mcu_fd_sc_mcu7t5v0__fill_1
XFILLER_71_618 VDD VDD VSS VSS gf180mcu_fd_sc_mcu7t5v0__fillcap_4
XFILLER_36_383 VDD VDD VSS VSS gf180mcu_fd_sc_mcu7t5v0__fill_2
XFILLER_70_139 VDD VDD VSS VSS gf180mcu_fd_sc_mcu7t5v0__fill_2
Xclkload4 clkload4/I clkload4/ZN VDD VDD VSS VSS gf180mcu_fd_sc_mcu7t5v0__inv_2
XFILLER_118_661 VDD VDD VSS VSS gf180mcu_fd_sc_mcu7t5v0__fill_2
Xoutput570 _2653_/Z tl_d_dmem_o[66] VDD VDD VSS VSS gf180mcu_fd_sc_mcu7t5v0__dlyd_1
Xoutput581 _2663_/Z tl_d_dmem_o[76] VDD VDD VSS VSS gf180mcu_fd_sc_mcu7t5v0__dlyd_1
Xfanout1206 _1257_/ZN fanout1206/Z VDD VDD VSS VSS gf180mcu_fd_sc_mcu7t5v0__dlyd_1
Xfanout1228 _2540_/Q _1066_/I VDD VDD VSS VSS gf180mcu_fd_sc_mcu7t5v0__dlyd_1
Xoutput592 _2673_/Z tl_d_dmem_o[86] VDD VDD VSS VSS gf180mcu_fd_sc_mcu7t5v0__dlyd_1
XFILLER_19_306 VDD VDD VSS VSS gf180mcu_fd_sc_mcu7t5v0__fillcap_32
XFILLER_59_486 VDD VDD VSS VSS gf180mcu_fd_sc_mcu7t5v0__fillcap_4
XTAP_TAPCELL_ROW_70_1096 VDD VSS gf180mcu_fd_sc_mcu7t5v0__filltie
XFILLER_74_489 VDD VDD VSS VSS gf180mcu_fd_sc_mcu7t5v0__fillcap_4
XFILLER_15_556 VDD VDD VSS VSS gf180mcu_fd_sc_mcu7t5v0__fillcap_4
XFILLER_43_865 VDD VDD VSS VSS gf180mcu_fd_sc_mcu7t5v0__fill_1
XTAP_TAPCELL_ROW_25_551 VDD VSS gf180mcu_fd_sc_mcu7t5v0__filltie
XTAP_TAPCELL_ROW_53_893 VDD VSS gf180mcu_fd_sc_mcu7t5v0__filltie
XTAP_TAPCELL_ROW_25_562 VDD VSS gf180mcu_fd_sc_mcu7t5v0__filltie
X_2260_ _2260_/A1 _2260_/A2 _2296_/B _2260_/ZN VDD VDD VSS VSS gf180mcu_fd_sc_mcu7t5v0__aoi21_1
XFILLER_97_559 VDD VDD VSS VSS gf180mcu_fd_sc_mcu7t5v0__fill_1
X_1211_ _1228_/B2 _1082_/I _1228_/A2 VDD VDD VSS VSS gf180mcu_fd_sc_mcu7t5v0__nand2_1
X_2191_ input47/Z _2236_/A2 _2236_/B _2192_/B2 VDD VDD VSS VSS gf180mcu_fd_sc_mcu7t5v0__aoi21_1
XTAP_TAPCELL_ROW_88_1313 VDD VSS gf180mcu_fd_sc_mcu7t5v0__filltie
XFILLER_77_261 VDD VDD VSS VSS gf180mcu_fd_sc_mcu7t5v0__fillcap_4
X_1142_ _2740_/I _1142_/A2 _2457_/A1 _1219_/A1 VDD VDD VSS VSS gf180mcu_fd_sc_mcu7t5v0__nor3_1
XFILLER_65_489 VDD VDD VSS VSS gf180mcu_fd_sc_mcu7t5v0__fill_1
X_1073_ _2562_/Q _2439_/A1 VDD VDD VSS VSS gf180mcu_fd_sc_mcu7t5v0__clkinv_1
XFILLER_52_128 VDD VDD VSS VSS gf180mcu_fd_sc_mcu7t5v0__fill_1
XFILLER_33_386 VDD VDD VSS VSS gf180mcu_fd_sc_mcu7t5v0__fillcap_8
X_1975_ _1975_/I _1975_/ZN VDD VDD VSS VSS gf180mcu_fd_sc_mcu7t5v0__clkinv_1
XTAP_TAPCELL_ROW_99_1442 VDD VSS gf180mcu_fd_sc_mcu7t5v0__filltie
X_2527_ _1151_/Z _2527_/A2 _2526_/B _2526_/C _2528_/I VDD VDD VSS VSS gf180mcu_fd_sc_mcu7t5v0__oai22_1
Xinput309 tl_h_d_i[36] _1926_/B2 VDD VDD VSS VSS gf180mcu_fd_sc_mcu7t5v0__dlyd_1
X_2458_ _2458_/A1 _2773_/I _2476_/S _2570_/D VDD VDD VSS VSS gf180mcu_fd_sc_mcu7t5v0__oai21_1
X_1409_ _1441_/A1 _2329_/A2 _1409_/Z VDD VDD VSS VSS gf180mcu_fd_sc_mcu7t5v0__and2_1
XPHY_EDGE_ROW_89_Right_89 VDD VSS gf180mcu_fd_sc_mcu7t5v0__endcap
XFILLER_68_261 VDD VDD VSS VSS gf180mcu_fd_sc_mcu7t5v0__fill_1
X_2389_ _2389_/I0 _2545_/Q _2394_/S _2545_/D VDD VDD VSS VSS gf180mcu_fd_sc_mcu7t5v0__mux2_2
XFILLER_28_158 VDD VDD VSS VSS gf180mcu_fd_sc_mcu7t5v0__fill_1
XFILLER_52_640 VDD VDD VSS VSS gf180mcu_fd_sc_mcu7t5v0__fillcap_16
XPHY_EDGE_ROW_98_Right_98 VDD VSS gf180mcu_fd_sc_mcu7t5v0__endcap
XFILLER_51_183 VDD VDD VSS VSS gf180mcu_fd_sc_mcu7t5v0__fill_2
XTAP_TAPCELL_ROW_50_852 VDD VSS gf180mcu_fd_sc_mcu7t5v0__filltie
XTAP_TAPCELL_ROW_22_521 VDD VSS gf180mcu_fd_sc_mcu7t5v0__filltie
XFILLER_118_491 VDD VDD VSS VSS gf180mcu_fd_sc_mcu7t5v0__fill_2
XTAP_TAPCELL_ROW_72_1125 VDD VSS gf180mcu_fd_sc_mcu7t5v0__filltie
XFILLER_59_250 VDD VDD VSS VSS gf180mcu_fd_sc_mcu7t5v0__fillcap_16
Xfanout1058 _2537_/A2 _1926_/B1 VDD VDD VSS VSS gf180mcu_fd_sc_mcu7t5v0__dlyd_1
Xwire1153 _1213_/B _1116_/B VDD VDD VSS VSS gf180mcu_fd_sc_mcu7t5v0__clkbuf_4
XTAP_TAPCELL_ROW_58_952 VDD VSS gf180mcu_fd_sc_mcu7t5v0__filltie
XFILLER_47_489 VDD VDD VSS VSS gf180mcu_fd_sc_mcu7t5v0__fill_1
XFILLER_90_702 VDD VDD VSS VSS gf180mcu_fd_sc_mcu7t5v0__fill_1
XFILLER_74_275 VDD VDD VSS VSS gf180mcu_fd_sc_mcu7t5v0__fillcap_16
XTAP_TAPCELL_ROW_83_1254 VDD VSS gf180mcu_fd_sc_mcu7t5v0__filltie
X_1760_ _1950_/A1 _1772_/A2 _1762_/B1 _1950_/B2 _1761_/I VDD VDD VSS VSS gf180mcu_fd_sc_mcu7t5v0__aoi22_1
X_1691_ _1691_/I _1691_/ZN VDD VDD VSS VSS gf180mcu_fd_sc_mcu7t5v0__clkinv_1
XTAP_TAPCELL_ROW_94_1383 VDD VSS gf180mcu_fd_sc_mcu7t5v0__filltie
X_2312_ _2312_/A1 _2312_/A2 _2348_/B _2312_/ZN VDD VDD VSS VSS gf180mcu_fd_sc_mcu7t5v0__aoi21_1
XFILLER_100_807 VDD VDD VSS VSS gf180mcu_fd_sc_mcu7t5v0__fillcap_16
XFILLER_25_2 VDD VDD VSS VSS gf180mcu_fd_sc_mcu7t5v0__fillcap_8
X_2243_ input58/Z _2247_/A2 _2244_/A2 VDD VDD VSS VSS gf180mcu_fd_sc_mcu7t5v0__nor2_1
X_2174_ _2174_/A1 _2238_/A2 _2238_/B1 input74/Z _2176_/A2 VDD VDD VSS VSS gf180mcu_fd_sc_mcu7t5v0__aoi22_1
XFILLER_78_592 VDD VDD VSS VSS gf180mcu_fd_sc_mcu7t5v0__fill_2
X_1125_ _2539_/Q _2067_/B _2064_/B VDD VDD VSS VSS gf180mcu_fd_sc_mcu7t5v0__nand2_1
XFILLER_81_702 VDD VDD VSS VSS gf180mcu_fd_sc_mcu7t5v0__fillcap_64
XTAP_TAPCELL_ROW_0_249 VDD VSS gf180mcu_fd_sc_mcu7t5v0__filltie
XTAP_TAPCELL_ROW_0_238 VDD VSS gf180mcu_fd_sc_mcu7t5v0__filltie
XFILLER_80_201 VDD VDD VSS VSS gf180mcu_fd_sc_mcu7t5v0__fillcap_8
XFILLER_21_323 VDD VDD VSS VSS gf180mcu_fd_sc_mcu7t5v0__fillcap_16
XFILLER_61_492 VDD VDD VSS VSS gf180mcu_fd_sc_mcu7t5v0__fillcap_16
XTAP_TAPCELL_ROW_103_1490 VDD VSS gf180mcu_fd_sc_mcu7t5v0__filltie
X_1958_ _1958_/A1 _1976_/A2 _1958_/B1 _1958_/B2 _1959_/I VDD VDD VSS VSS gf180mcu_fd_sc_mcu7t5v0__aoi22_1
X_1889_ _1889_/I _1889_/ZN VDD VDD VSS VSS gf180mcu_fd_sc_mcu7t5v0__clkinv_1
Xoutput1050 _2066_/ZN tl_h_i_o[9] VDD VDD VSS VSS gf180mcu_fd_sc_mcu7t5v0__dlyd_1
XTAP_TAPCELL_ROW_8_349 VDD VSS gf180mcu_fd_sc_mcu7t5v0__filltie
Xinput106 tl_d_esram_i[44] _2367_/A1 VDD VDD VSS VSS gf180mcu_fd_sc_mcu7t5v0__dlyd_1
Xinput117 tl_d_esram_i[54] _2209_/A1 VDD VDD VSS VSS gf180mcu_fd_sc_mcu7t5v0__dlyd_1
Xinput128 tl_d_esram_i[64] _1257_/A3 VDD VDD VSS VSS gf180mcu_fd_sc_mcu7t5v0__dlyd_1
Xinput139 tl_d_rom_i[14] _2169_/A1 VDD VDD VSS VSS gf180mcu_fd_sc_mcu7t5v0__dlyd_1
XFILLER_88_378 VDD VDD VSS VSS gf180mcu_fd_sc_mcu7t5v0__fillcap_4
Xload_slew1227 _2246_/A2 _2238_/A2 VDD VDD VSS VSS gf180mcu_fd_sc_mcu7t5v0__buf_4
Xload_slew1238 _2583_/RN _2567_/RN VDD VDD VSS VSS gf180mcu_fd_sc_mcu7t5v0__buf_3
Xload_slew1249 input1/Z _2588_/RN VDD VDD VSS VSS gf180mcu_fd_sc_mcu7t5v0__buf_4
XTAP_TAPCELL_ROW_55_911 VDD VSS gf180mcu_fd_sc_mcu7t5v0__filltie
XTAP_TAPCELL_ROW_55_922 VDD VSS gf180mcu_fd_sc_mcu7t5v0__filltie
XFILLER_71_212 VDD VDD VSS VSS gf180mcu_fd_sc_mcu7t5v0__fillcap_64
XFILLER_13_846 VDD VDD VSS VSS gf180mcu_fd_sc_mcu7t5v0__fill_1
XPHY_EDGE_ROW_117_Right_117 VDD VSS gf180mcu_fd_sc_mcu7t5v0__endcap
XTAP_TAPCELL_ROW_117_1659 VDD VSS gf180mcu_fd_sc_mcu7t5v0__filltie
XFILLER_39_209 VDD VDD VSS VSS gf180mcu_fd_sc_mcu7t5v0__fill_1
XFILLER_75_540 VDD VDD VSS VSS gf180mcu_fd_sc_mcu7t5v0__fillcap_8
XFILLER_63_702 VDD VDD VSS VSS gf180mcu_fd_sc_mcu7t5v0__fillcap_4
XFILLER_62_201 VDD VDD VSS VSS gf180mcu_fd_sc_mcu7t5v0__fill_1
XFILLER_90_521 VDD VDD VSS VSS gf180mcu_fd_sc_mcu7t5v0__fillcap_4
XFILLER_63_768 VDD VDD VSS VSS gf180mcu_fd_sc_mcu7t5v0__fill_2
XFILLER_50_418 VDD VDD VSS VSS gf180mcu_fd_sc_mcu7t5v0__fillcap_16
XFILLER_31_632 VDD VDD VSS VSS gf180mcu_fd_sc_mcu7t5v0__fillcap_64
XFILLER_43_492 VDD VDD VSS VSS gf180mcu_fd_sc_mcu7t5v0__fillcap_64
XTAP_TAPCELL_ROW_33_649 VDD VSS gf180mcu_fd_sc_mcu7t5v0__filltie
X_1812_ _2002_/A1 _1822_/A2 _1812_/B1 _2733_/I _1813_/I VDD VDD VSS VSS gf180mcu_fd_sc_mcu7t5v0__aoi22_1
X_1743_ _1743_/I _1743_/ZN VDD VDD VSS VSS gf180mcu_fd_sc_mcu7t5v0__clkinv_1
XTAP_TAPCELL_ROW_96_1412 VDD VSS gf180mcu_fd_sc_mcu7t5v0__filltie
X_1674_ _1864_/A1 _1720_/A2 _1720_/B1 _1864_/B2 _1675_/I VDD VDD VSS VSS gf180mcu_fd_sc_mcu7t5v0__aoi22_1
XTAP_TAPCELL_ROW_5_319 VDD VSS gf180mcu_fd_sc_mcu7t5v0__filltie
XFILLER_85_315 VDD VDD VSS VSS gf180mcu_fd_sc_mcu7t5v0__fillcap_32
X_2226_ _2226_/A1 _2226_/A2 _2226_/ZN VDD VDD VSS VSS gf180mcu_fd_sc_mcu7t5v0__nor2_1
XFILLER_53_212 VDD VDD VSS VSS gf180mcu_fd_sc_mcu7t5v0__fillcap_8
X_2157_ _2157_/A1 _2140_/B _2157_/B _2157_/C _2159_/A2 VDD VDD VSS VSS gf180mcu_fd_sc_mcu7t5v0__oai211_1
XFILLER_53_245 VDD VDD VSS VSS gf180mcu_fd_sc_mcu7t5v0__fill_1
X_2088_ _2193_/A1 _2377_/A1 _2090_/A1 VDD VDD VSS VSS gf180mcu_fd_sc_mcu7t5v0__nand2_1
X_1108_ _2570_/Q _2568_/Q _2246_/A2 VDD VDD VSS VSS gf180mcu_fd_sc_mcu7t5v0__nor2_2
XFILLER_41_407 VDD VDD VSS VSS gf180mcu_fd_sc_mcu7t5v0__fillcap_8
XFILLER_34_481 VDD VDD VSS VSS gf180mcu_fd_sc_mcu7t5v0__fill_2
XTAP_TAPCELL_ROW_60_980 VDD VSS gf180mcu_fd_sc_mcu7t5v0__filltie
XFILLER_89_632 VDD VDD VSS VSS gf180mcu_fd_sc_mcu7t5v0__fillcap_32
XFILLER_103_486 VDD VDD VSS VSS gf180mcu_fd_sc_mcu7t5v0__fillcap_4
XFILLER_29_220 VDD VDD VSS VSS gf180mcu_fd_sc_mcu7t5v0__fill_2
XFILLER_76_337 VDD VDD VSS VSS gf180mcu_fd_sc_mcu7t5v0__fill_1
XFILLER_29_231 VDD VDD VSS VSS gf180mcu_fd_sc_mcu7t5v0__fill_1
XFILLER_45_702 VDD VDD VSS VSS gf180mcu_fd_sc_mcu7t5v0__fillcap_64
XFILLER_57_540 VDD VDD VSS VSS gf180mcu_fd_sc_mcu7t5v0__fillcap_16
XFILLER_57_562 VDD VDD VSS VSS gf180mcu_fd_sc_mcu7t5v0__fill_1
XFILLER_85_860 VDD VDD VSS VSS gf180mcu_fd_sc_mcu7t5v0__fillcap_4
XFILLER_29_275 VDD VDD VSS VSS gf180mcu_fd_sc_mcu7t5v0__fill_1
XFILLER_44_223 VDD VDD VSS VSS gf180mcu_fd_sc_mcu7t5v0__fill_1
XFILLER_72_521 VDD VDD VSS VSS gf180mcu_fd_sc_mcu7t5v0__fillcap_4
XTAP_TAPCELL_ROW_67_1057 VDD VSS gf180mcu_fd_sc_mcu7t5v0__filltie
XFILLER_13_632 VDD VDD VSS VSS gf180mcu_fd_sc_mcu7t5v0__fillcap_64
XFILLER_25_492 VDD VDD VSS VSS gf180mcu_fd_sc_mcu7t5v0__fillcap_64
XTAP_TAPCELL_ROW_80_1213 VDD VSS gf180mcu_fd_sc_mcu7t5v0__filltie
XTAP_TAPCELL_ROW_30_619 VDD VSS gf180mcu_fd_sc_mcu7t5v0__filltie
XFILLER_40_473 VDD VDD VSS VSS gf180mcu_fd_sc_mcu7t5v0__fill_2
XFILLER_9_636 VDD VDD VSS VSS gf180mcu_fd_sc_mcu7t5v0__fill_1
XFILLER_5_842 VDD VDD VSS VSS gf180mcu_fd_sc_mcu7t5v0__fillcap_16
XTAP_TAPCELL_ROW_10_376 VDD VSS gf180mcu_fd_sc_mcu7t5v0__filltie
XTAP_TAPCELL_ROW_78_1197 VDD VSS gf180mcu_fd_sc_mcu7t5v0__filltie
X_1390_ _1390_/A1 _1486_/A2 _1390_/B1 _1390_/B2 _1391_/A2 VDD VDD VSS VSS gf180mcu_fd_sc_mcu7t5v0__aoi22_1
XTAP_TAPCELL_ROW_91_1353 VDD VSS gf180mcu_fd_sc_mcu7t5v0__filltie
XFILLER_79_142 VDD VDD VSS VSS gf180mcu_fd_sc_mcu7t5v0__fillcap_16
XFILLER_95_602 VDD VDD VSS VSS gf180mcu_fd_sc_mcu7t5v0__fill_1
XFILLER_67_348 VDD VDD VSS VSS gf180mcu_fd_sc_mcu7t5v0__fill_2
Xinput470 tl_h_i_i[79] _2012_/A1 VDD VDD VSS VSS gf180mcu_fd_sc_mcu7t5v0__dlyd_1
Xinput481 tl_h_i_i[89] _1162_/A1 VDD VDD VSS VSS gf180mcu_fd_sc_mcu7t5v0__dlyd_1
X_2011_ _2011_/I _2011_/ZN VDD VDD VSS VSS gf180mcu_fd_sc_mcu7t5v0__clkinv_1
XTAP_TAPCELL_ROW_38_708 VDD VSS gf180mcu_fd_sc_mcu7t5v0__filltie
XFILLER_35_212 VDD VDD VSS VSS gf180mcu_fd_sc_mcu7t5v0__fill_2
Xinput492 tl_h_i_i[99] _2397_/I0 VDD VDD VSS VSS gf180mcu_fd_sc_mcu7t5v0__dlyd_1
XFILLER_91_852 VDD VDD VSS VSS gf180mcu_fd_sc_mcu7t5v0__fillcap_8
XTAP_TAPCELL_ROW_18_476 VDD VSS gf180mcu_fd_sc_mcu7t5v0__filltie
XFILLER_31_440 VDD VDD VSS VSS gf180mcu_fd_sc_mcu7t5v0__fill_1
XTAP_TAPCELL_ROW_100_1460 VDD VSS gf180mcu_fd_sc_mcu7t5v0__filltie
X_2775_ _2775_/I _2775_/Z VDD VDD VSS VSS gf180mcu_fd_sc_mcu7t5v0__buf_1
Xoutput911 _2752_/Z tl_d_uart_o[93] VDD VDD VSS VSS gf180mcu_fd_sc_mcu7t5v0__dlyd_1
Xoutput900 _2742_/Z tl_d_uart_o[83] VDD VDD VSS VSS gf180mcu_fd_sc_mcu7t5v0__dlyd_1
X_1726_ _1916_/A1 _1768_/A2 _1736_/B1 _1916_/B2 _1727_/I VDD VDD VSS VSS gf180mcu_fd_sc_mcu7t5v0__aoi22_1
Xoutput955 _1471_/ZN tl_h_d_o[42] VDD VDD VSS VSS gf180mcu_fd_sc_mcu7t5v0__dlyd_1
Xoutput944 _1391_/ZN tl_h_d_o[32] VDD VDD VSS VSS gf180mcu_fd_sc_mcu7t5v0__dlyd_1
Xoutput933 _1311_/ZN tl_h_d_o[22] VDD VDD VSS VSS gf180mcu_fd_sc_mcu7t5v0__dlyd_1
Xoutput922 _2162_/ZN tl_h_d_o[12] VDD VDD VSS VSS gf180mcu_fd_sc_mcu7t5v0__dlyd_1
X_1657_ _1657_/A1 _1662_/S _1657_/ZN VDD VDD VSS VSS gf180mcu_fd_sc_mcu7t5v0__nor2_1
Xoutput966 _2204_/ZN tl_h_d_o[52] VDD VDD VSS VSS gf180mcu_fd_sc_mcu7t5v0__dlyd_1
Xoutput977 _1121_/ZN tl_h_d_o[62] VDD VDD VSS VSS gf180mcu_fd_sc_mcu7t5v0__dlyd_1
Xoutput988 _2072_/ZN tl_h_i_o[12] VDD VDD VSS VSS gf180mcu_fd_sc_mcu7t5v0__dlyd_1
X_1588_ _1876_/B2 _1587_/Z _1600_/S _1588_/Z VDD VDD VSS VSS gf180mcu_fd_sc_mcu7t5v0__mux2_2
Xoutput999 _2280_/ZN tl_h_i_o[22] VDD VDD VSS VSS gf180mcu_fd_sc_mcu7t5v0__dlyd_1
XFILLER_100_412 VDD VDD VSS VSS gf180mcu_fd_sc_mcu7t5v0__fillcap_32
XFILLER_27_702 VDD VDD VSS VSS gf180mcu_fd_sc_mcu7t5v0__fillcap_64
XFILLER_39_562 VDD VDD VSS VSS gf180mcu_fd_sc_mcu7t5v0__fillcap_64
X_2209_ _2209_/A1 _2207_/B _2246_/C _2209_/C _2211_/A2 VDD VDD VSS VSS gf180mcu_fd_sc_mcu7t5v0__aoi211_1
XFILLER_85_189 VDD VDD VSS VSS gf180mcu_fd_sc_mcu7t5v0__fillcap_16
XFILLER_85_178 VDD VDD VSS VSS gf180mcu_fd_sc_mcu7t5v0__fillcap_4
XFILLER_26_234 VDD VDD VSS VSS gf180mcu_fd_sc_mcu7t5v0__fillcap_8
XFILLER_66_392 VDD VDD VSS VSS gf180mcu_fd_sc_mcu7t5v0__fillcap_8
XFILLER_26_267 VDD VDD VSS VSS gf180mcu_fd_sc_mcu7t5v0__fillcap_4
XTAP_TAPCELL_ROW_114_1629 VDD VSS gf180mcu_fd_sc_mcu7t5v0__filltie
XFILLER_78_34 VDD VDD VSS VSS gf180mcu_fd_sc_mcu7t5v0__fill_1
XFILLER_49_304 VDD VDD VSS VSS gf180mcu_fd_sc_mcu7t5v0__fillcap_32
XFILLER_49_348 VDD VDD VSS VSS gf180mcu_fd_sc_mcu7t5v0__fill_2
XFILLER_76_112 VDD VDD VSS VSS gf180mcu_fd_sc_mcu7t5v0__fillcap_16
XFILLER_94_44 VDD VDD VSS VSS gf180mcu_fd_sc_mcu7t5v0__fillcap_16
XFILLER_72_340 VDD VDD VSS VSS gf180mcu_fd_sc_mcu7t5v0__fillcap_4
XFILLER_60_513 VDD VDD VSS VSS gf180mcu_fd_sc_mcu7t5v0__fillcap_4
XTAP_TAPCELL_ROW_15_435 VDD VSS gf180mcu_fd_sc_mcu7t5v0__filltie
XFILLER_72_384 VDD VDD VSS VSS gf180mcu_fd_sc_mcu7t5v0__fill_1
XTAP_TAPCELL_ROW_43_777 VDD VSS gf180mcu_fd_sc_mcu7t5v0__filltie
XFILLER_9_422 VDD VDD VSS VSS gf180mcu_fd_sc_mcu7t5v0__fillcap_64
X_2560_ _2560_/D _2567_/RN clkload2/I _2560_/Q VDD VDD VSS VSS gf180mcu_fd_sc_mcu7t5v0__dffrnq_1
X_2491_ _2491_/A1 _2517_/B _2491_/Z VDD VDD VSS VSS gf180mcu_fd_sc_mcu7t5v0__xor2_1
X_1511_ _1511_/A1 _1511_/A2 _1511_/ZN VDD VDD VSS VSS gf180mcu_fd_sc_mcu7t5v0__nor2_1
X_1442_ _2347_/A1 _2158_/A2 _2379_/A3 _1443_/B VDD VDD VSS VSS gf180mcu_fd_sc_mcu7t5v0__nand3_1
XFILLER_68_613 VDD VDD VSS VSS gf180mcu_fd_sc_mcu7t5v0__fillcap_8
Xxbar_tlul_2to4_1260 tl_d_esram_o[85] VDD VDD VSS VSS gf180mcu_fd_sc_mcu7t5v0__tiel
X_1373_ _1373_/I _1374_/B1 VDD VDD VSS VSS gf180mcu_fd_sc_mcu7t5v0__clkinv_1
Xxbar_tlul_2to4_1271 tl_d_rom_o[89] VDD VDD VSS VSS gf180mcu_fd_sc_mcu7t5v0__tiel
XFILLER_83_616 VDD VDD VSS VSS gf180mcu_fd_sc_mcu7t5v0__fillcap_8
XFILLER_36_543 VDD VDD VSS VSS gf180mcu_fd_sc_mcu7t5v0__fillcap_4
XFILLER_36_587 VDD VDD VSS VSS gf180mcu_fd_sc_mcu7t5v0__fillcap_8
XFILLER_23_226 VDD VDD VSS VSS gf180mcu_fd_sc_mcu7t5v0__fillcap_4
XFILLER_51_524 VDD VDD VSS VSS gf180mcu_fd_sc_mcu7t5v0__fillcap_16
X_2758_ _2758_/I _2758_/Z VDD VDD VSS VSS gf180mcu_fd_sc_mcu7t5v0__buf_1
Xoutput730 _1701_/ZN tl_d_rom_o[18] VDD VDD VSS VSS gf180mcu_fd_sc_mcu7t5v0__dlyd_1
X_1709_ _1709_/I _1709_/ZN VDD VDD VSS VSS gf180mcu_fd_sc_mcu7t5v0__clkinv_1
X_2689_ _2761_/I _2689_/Z VDD VDD VSS VSS gf180mcu_fd_sc_mcu7t5v0__buf_1
Xoutput763 _1761_/ZN tl_d_rom_o[48] VDD VDD VSS VSS gf180mcu_fd_sc_mcu7t5v0__dlyd_1
Xoutput752 _1741_/ZN tl_d_rom_o[38] VDD VDD VSS VSS gf180mcu_fd_sc_mcu7t5v0__dlyd_1
Xoutput741 _1721_/ZN tl_d_rom_o[28] VDD VDD VSS VSS gf180mcu_fd_sc_mcu7t5v0__dlyd_1
Xoutput796 _1821_/ZN tl_d_rom_o[78] VDD VDD VSS VSS gf180mcu_fd_sc_mcu7t5v0__dlyd_1
Xoutput785 _1801_/ZN tl_d_rom_o[68] VDD VDD VSS VSS gf180mcu_fd_sc_mcu7t5v0__dlyd_1
Xoutput774 _1781_/ZN tl_d_rom_o[58] VDD VDD VSS VSS gf180mcu_fd_sc_mcu7t5v0__dlyd_1
XFILLER_98_281 VDD VDD VSS VSS gf180mcu_fd_sc_mcu7t5v0__fill_1
XFILLER_39_370 VDD VDD VSS VSS gf180mcu_fd_sc_mcu7t5v0__fill_1
XFILLER_58_167 VDD VDD VSS VSS gf180mcu_fd_sc_mcu7t5v0__fillcap_8
XPHY_EDGE_ROW_100_Left_219 VDD VSS gf180mcu_fd_sc_mcu7t5v0__endcap
XFILLER_42_524 VDD VDD VSS VSS gf180mcu_fd_sc_mcu7t5v0__fill_1
XTAP_TAPCELL_ROW_64_1027 VDD VSS gf180mcu_fd_sc_mcu7t5v0__filltie
XFILLER_82_693 VDD VDD VSS VSS gf180mcu_fd_sc_mcu7t5v0__fill_1
XTAP_TAPCELL_ROW_40_736 VDD VSS gf180mcu_fd_sc_mcu7t5v0__filltie
XTAP_TAPCELL_ROW_12_405 VDD VSS gf180mcu_fd_sc_mcu7t5v0__filltie
XFILLER_108_331 VDD VDD VSS VSS gf180mcu_fd_sc_mcu7t5v0__fill_2
XTAP_TAPCELL_ROW_20_493 VDD VSS gf180mcu_fd_sc_mcu7t5v0__filltie
XTAP_TAPCELL_ROW_75_1156 VDD VSS gf180mcu_fd_sc_mcu7t5v0__filltie
XFILLER_49_178 VDD VDD VSS VSS gf180mcu_fd_sc_mcu7t5v0__fill_1
XFILLER_64_104 VDD VDD VSS VSS gf180mcu_fd_sc_mcu7t5v0__fill_1
XFILLER_65_638 VDD VDD VSS VSS gf180mcu_fd_sc_mcu7t5v0__fillcap_32
XTAP_TAPCELL_ROW_48_836 VDD VSS gf180mcu_fd_sc_mcu7t5v0__filltie
XFILLER_18_521 VDD VDD VSS VSS gf180mcu_fd_sc_mcu7t5v0__fillcap_4
XFILLER_64_137 VDD VDD VSS VSS gf180mcu_fd_sc_mcu7t5v0__fill_1
XFILLER_33_535 VDD VDD VSS VSS gf180mcu_fd_sc_mcu7t5v0__fillcap_16
XFILLER_60_321 VDD VDD VSS VSS gf180mcu_fd_sc_mcu7t5v0__fill_2
XFILLER_60_332 VDD VDD VSS VSS gf180mcu_fd_sc_mcu7t5v0__fill_2
XTAP_TAPCELL_ROW_86_1285 VDD VSS gf180mcu_fd_sc_mcu7t5v0__filltie
XTAP_TAPCELL_ROW_28_593 VDD VSS gf180mcu_fd_sc_mcu7t5v0__filltie
XFILLER_13_270 VDD VDD VSS VSS gf180mcu_fd_sc_mcu7t5v0__fill_2
XFILLER_60_387 VDD VDD VSS VSS gf180mcu_fd_sc_mcu7t5v0__fillcap_8
X_1991_ _1991_/I _1991_/ZN VDD VDD VSS VSS gf180mcu_fd_sc_mcu7t5v0__clkinv_1
X_2543_ _2543_/D _2558_/RN clkload0/I _2543_/Q VDD VDD VSS VSS gf180mcu_fd_sc_mcu7t5v0__dffrnq_1
X_2474_ _2759_/I _2584_/Q _2477_/S _2584_/D VDD VDD VSS VSS gf180mcu_fd_sc_mcu7t5v0__mux2_2
XFILLER_87_207 VDD VDD VSS VSS gf180mcu_fd_sc_mcu7t5v0__fill_2
X_1425_ _2233_/A2 _2337_/A2 _1425_/Z VDD VDD VSS VSS gf180mcu_fd_sc_mcu7t5v0__and2_1
X_1356_ input22/Z _1396_/A2 _1356_/B1 _1476_/B2 _1357_/I VDD VDD VSS VSS gf180mcu_fd_sc_mcu7t5v0__aoi22_1
XFILLER_18_18 VDD VDD VSS VSS gf180mcu_fd_sc_mcu7t5v0__fillcap_4
X_1287_ _1399_/A1 _1287_/A2 _1287_/ZN VDD VDD VSS VSS gf180mcu_fd_sc_mcu7t5v0__nor2_1
XFILLER_37_863 VDD VDD VSS VSS gf180mcu_fd_sc_mcu7t5v0__fill_2
XFILLER_70_107 VDD VDD VSS VSS gf180mcu_fd_sc_mcu7t5v0__fill_1
XFILLER_24_524 VDD VDD VSS VSS gf180mcu_fd_sc_mcu7t5v0__fill_1
XFILLER_63_170 VDD VDD VSS VSS gf180mcu_fd_sc_mcu7t5v0__fillcap_4
XFILLER_63_192 VDD VDD VSS VSS gf180mcu_fd_sc_mcu7t5v0__fill_2
XFILLER_32_590 VDD VDD VSS VSS gf180mcu_fd_sc_mcu7t5v0__fillcap_4
Xclkload5 clkload5/I clkload5/ZN VDD VDD VSS VSS gf180mcu_fd_sc_mcu7t5v0__inv_4
XFILLER_3_428 VDD VDD VSS VSS gf180mcu_fd_sc_mcu7t5v0__fillcap_16
XFILLER_105_356 VDD VDD VSS VSS gf180mcu_fd_sc_mcu7t5v0__fill_2
Xoutput560 _1540_/Z tl_d_dmem_o[57] VDD VDD VSS VSS gf180mcu_fd_sc_mcu7t5v0__dlyd_1
Xoutput571 _2654_/Z tl_d_dmem_o[67] VDD VDD VSS VSS gf180mcu_fd_sc_mcu7t5v0__dlyd_1
Xoutput582 _2664_/Z tl_d_dmem_o[77] VDD VDD VSS VSS gf180mcu_fd_sc_mcu7t5v0__dlyd_1
Xoutput593 _2674_/Z tl_d_dmem_o[87] VDD VDD VSS VSS gf180mcu_fd_sc_mcu7t5v0__dlyd_1
XTAP_TAPCELL_ROW_70_1097 VDD VSS gf180mcu_fd_sc_mcu7t5v0__filltie
XFILLER_86_295 VDD VDD VSS VSS gf180mcu_fd_sc_mcu7t5v0__fillcap_4
XFILLER_74_457 VDD VDD VSS VSS gf180mcu_fd_sc_mcu7t5v0__fillcap_32
XFILLER_27_384 VDD VDD VSS VSS gf180mcu_fd_sc_mcu7t5v0__fillcap_4
XFILLER_30_527 VDD VDD VSS VSS gf180mcu_fd_sc_mcu7t5v0__fillcap_16
XFILLER_42_365 VDD VDD VSS VSS gf180mcu_fd_sc_mcu7t5v0__fillcap_8
XFILLER_42_387 VDD VDD VSS VSS gf180mcu_fd_sc_mcu7t5v0__fillcap_4
XTAP_TAPCELL_ROW_53_894 VDD VSS gf180mcu_fd_sc_mcu7t5v0__filltie
XTAP_TAPCELL_ROW_25_552 VDD VSS gf180mcu_fd_sc_mcu7t5v0__filltie
X_2190_ _2190_/A1 _1116_/B _2215_/B _2190_/C _2192_/B1 VDD VDD VSS VSS gf180mcu_fd_sc_mcu7t5v0__oai211_1
X_1210_ _2434_/B _2775_/I VDD VDD VSS VSS gf180mcu_fd_sc_mcu7t5v0__clkinv_1
X_1141_ _1141_/A1 _1141_/A2 _1143_/A3 _1143_/A4 _2457_/A1 VDD VDD VSS VSS gf180mcu_fd_sc_mcu7t5v0__nand4_1
XTAP_TAPCELL_ROW_88_1314 VDD VSS gf180mcu_fd_sc_mcu7t5v0__filltie
X_1072_ _2559_/Q _2409_/A1 VDD VDD VSS VSS gf180mcu_fd_sc_mcu7t5v0__clkinv_1
XFILLER_92_265 VDD VDD VSS VSS gf180mcu_fd_sc_mcu7t5v0__fill_2
XFILLER_61_696 VDD VDD VSS VSS gf180mcu_fd_sc_mcu7t5v0__fillcap_4
X_1974_ _1974_/A1 _1982_/A2 _1998_/B1 _1974_/B2 _1975_/I VDD VDD VSS VSS gf180mcu_fd_sc_mcu7t5v0__aoi22_1
XTAP_TAPCELL_ROW_99_1443 VDD VSS gf180mcu_fd_sc_mcu7t5v0__filltie
X_2526_ _2596_/Q _2773_/I _2526_/B _2526_/C _2529_/A2 VDD VDD VSS VSS gf180mcu_fd_sc_mcu7t5v0__aoi211_1
X_2457_ _2457_/A1 _2773_/I _2477_/S VDD VDD VSS VSS gf180mcu_fd_sc_mcu7t5v0__nand2_1
XFILLER_88_527 VDD VDD VSS VSS gf180mcu_fd_sc_mcu7t5v0__fillcap_32
X_1408_ _1408_/A1 _1496_/A2 _2329_/A2 VDD VDD VSS VSS gf180mcu_fd_sc_mcu7t5v0__nand2_1
X_2388_ _2388_/I0 _2544_/Q _2402_/S _2544_/D VDD VDD VSS VSS gf180mcu_fd_sc_mcu7t5v0__mux2_2
XFILLER_84_722 VDD VDD VSS VSS gf180mcu_fd_sc_mcu7t5v0__fillcap_8
XFILLER_68_284 VDD VDD VSS VSS gf180mcu_fd_sc_mcu7t5v0__fillcap_16
X_1339_ _1339_/A1 _1337_/Z _1339_/B _1340_/B1 VDD VDD VSS VSS gf180mcu_fd_sc_mcu7t5v0__oai21_1
XFILLER_96_593 VDD VDD VSS VSS gf180mcu_fd_sc_mcu7t5v0__fill_2
XFILLER_44_619 VDD VDD VSS VSS gf180mcu_fd_sc_mcu7t5v0__fill_1
XTAP_TAPCELL_ROW_108_1550 VDD VSS gf180mcu_fd_sc_mcu7t5v0__filltie
XFILLER_83_265 VDD VDD VSS VSS gf180mcu_fd_sc_mcu7t5v0__fillcap_8
XFILLER_83_298 VDD VDD VSS VSS gf180mcu_fd_sc_mcu7t5v0__fillcap_8
XFILLER_12_527 VDD VDD VSS VSS gf180mcu_fd_sc_mcu7t5v0__fillcap_64
XFILLER_24_387 VDD VDD VSS VSS gf180mcu_fd_sc_mcu7t5v0__fillcap_8
XFILLER_51_162 VDD VDD VSS VSS gf180mcu_fd_sc_mcu7t5v0__fillcap_4
XTAP_TAPCELL_ROW_22_522 VDD VSS gf180mcu_fd_sc_mcu7t5v0__filltie
XTAP_TAPCELL_ROW_50_853 VDD VSS gf180mcu_fd_sc_mcu7t5v0__filltie
XTAP_TAPCELL_ROW_72_1115 VDD VSS gf180mcu_fd_sc_mcu7t5v0__filltie
XTAP_TAPCELL_ROW_72_1126 VDD VSS gf180mcu_fd_sc_mcu7t5v0__filltie
XFILLER_94_508 VDD VDD VSS VSS gf180mcu_fd_sc_mcu7t5v0__fillcap_16
XFILLER_86_34 VDD VDD VSS VSS gf180mcu_fd_sc_mcu7t5v0__fill_1
Xwire1121 wire1121/I _1396_/A2 VDD VDD VSS VSS gf180mcu_fd_sc_mcu7t5v0__clkbuf_4
XFILLER_87_582 VDD VDD VSS VSS gf180mcu_fd_sc_mcu7t5v0__fill_2
XFILLER_59_284 VDD VDD VSS VSS gf180mcu_fd_sc_mcu7t5v0__fill_1
XTAP_TAPCELL_ROW_58_953 VDD VSS gf180mcu_fd_sc_mcu7t5v0__filltie
XFILLER_75_766 VDD VDD VSS VSS gf180mcu_fd_sc_mcu7t5v0__fillcap_4
XTAP_TAPCELL_ROW_2_280 VDD VSS gf180mcu_fd_sc_mcu7t5v0__filltie
XFILLER_42_173 VDD VDD VSS VSS gf180mcu_fd_sc_mcu7t5v0__fill_2
XFILLER_43_696 VDD VDD VSS VSS gf180mcu_fd_sc_mcu7t5v0__fillcap_4
XTAP_TAPCELL_ROW_83_1255 VDD VSS gf180mcu_fd_sc_mcu7t5v0__filltie
XFILLER_31_858 VDD VDD VSS VSS gf180mcu_fd_sc_mcu7t5v0__fillcap_8
X_1690_ _1880_/A1 _1728_/A2 _1722_/B1 _1880_/B2 _1691_/I VDD VDD VSS VSS gf180mcu_fd_sc_mcu7t5v0__aoi22_1
XTAP_TAPCELL_ROW_94_1384 VDD VSS gf180mcu_fd_sc_mcu7t5v0__filltie
X_2311_ input91/Z _2343_/A2 _2311_/A3 _2312_/A2 VDD VDD VSS VSS gf180mcu_fd_sc_mcu7t5v0__nand3_1
X_2242_ _2242_/A1 _2246_/A2 _2246_/B1 _2242_/B2 _2246_/C _2244_/A1 VDD VDD VSS VSS
+ gf180mcu_fd_sc_mcu7t5v0__aoi221_1
XFILLER_18_2 VDD VDD VSS VSS gf180mcu_fd_sc_mcu7t5v0__fillcap_16
XFILLER_66_733 VDD VDD VSS VSS gf180mcu_fd_sc_mcu7t5v0__fill_2
X_2173_ input8/Z _2236_/A2 _2176_/C VDD VDD VSS VSS gf180mcu_fd_sc_mcu7t5v0__nand2_1
XFILLER_38_457 VDD VDD VSS VSS gf180mcu_fd_sc_mcu7t5v0__fillcap_64
X_1124_ _2382_/A1 _1066_/I _2379_/A2 VDD VDD VSS VSS gf180mcu_fd_sc_mcu7t5v0__nor2_1
XFILLER_53_416 VDD VDD VSS VSS gf180mcu_fd_sc_mcu7t5v0__fillcap_4
XFILLER_65_298 VDD VDD VSS VSS gf180mcu_fd_sc_mcu7t5v0__fillcap_4
XTAP_TAPCELL_ROW_0_239 VDD VSS gf180mcu_fd_sc_mcu7t5v0__filltie
XFILLER_34_641 VDD VDD VSS VSS gf180mcu_fd_sc_mcu7t5v0__fillcap_16
XFILLER_61_460 VDD VDD VSS VSS gf180mcu_fd_sc_mcu7t5v0__fillcap_16
XTAP_TAPCELL_ROW_103_1491 VDD VSS gf180mcu_fd_sc_mcu7t5v0__filltie
X_1957_ _1957_/I _1957_/ZN VDD VDD VSS VSS gf180mcu_fd_sc_mcu7t5v0__clkinv_1
X_1888_ _2387_/I0 _1914_/A2 _1914_/B1 _2708_/I _1889_/I VDD VDD VSS VSS gf180mcu_fd_sc_mcu7t5v0__aoi22_1
XFILLER_0_206 VDD VDD VSS VSS gf180mcu_fd_sc_mcu7t5v0__fillcap_32
X_2509_ _2509_/I _2593_/D VDD VDD VSS VSS gf180mcu_fd_sc_mcu7t5v0__clkinv_1
Xoutput1040 _2055_/ZN tl_h_i_o[5] VDD VDD VSS VSS gf180mcu_fd_sc_mcu7t5v0__dlyd_1
XFILLER_89_858 VDD VDD VSS VSS gf180mcu_fd_sc_mcu7t5v0__fillcap_8
Xinput107 tl_d_esram_i[45] _2371_/A1 VDD VDD VSS VSS gf180mcu_fd_sc_mcu7t5v0__dlyd_1
Xinput118 tl_d_esram_i[55] _2215_/A1 VDD VDD VSS VSS gf180mcu_fd_sc_mcu7t5v0__dlyd_1
Xinput129 tl_d_esram_i[65] _1081_/I VDD VDD VSS VSS gf180mcu_fd_sc_mcu7t5v0__dlyd_1
Xload_slew1217 _2333_/A1 _2277_/A1 VDD VDD VSS VSS gf180mcu_fd_sc_mcu7t5v0__clkbuf_4
XFILLER_56_243 VDD VDD VSS VSS gf180mcu_fd_sc_mcu7t5v0__fill_2
XFILLER_57_766 VDD VDD VSS VSS gf180mcu_fd_sc_mcu7t5v0__fillcap_4
Xload_slew1239 _2582_/RN _2583_/RN VDD VDD VSS VSS gf180mcu_fd_sc_mcu7t5v0__buf_4
XTAP_TAPCELL_ROW_55_912 VDD VSS gf180mcu_fd_sc_mcu7t5v0__filltie
XFILLER_72_14 VDD VDD VSS VSS gf180mcu_fd_sc_mcu7t5v0__fill_2
XFILLER_25_696 VDD VDD VSS VSS gf180mcu_fd_sc_mcu7t5v0__fillcap_4
XTAP_TAPCELL_ROW_35_680 VDD VSS gf180mcu_fd_sc_mcu7t5v0__filltie
XFILLER_106_451 VDD VDD VSS VSS gf180mcu_fd_sc_mcu7t5v0__fillcap_4
XFILLER_0_762 VDD VDD VSS VSS gf180mcu_fd_sc_mcu7t5v0__fillcap_4
XFILLER_75_552 VDD VDD VSS VSS gf180mcu_fd_sc_mcu7t5v0__fill_2
XFILLER_35_416 VDD VDD VSS VSS gf180mcu_fd_sc_mcu7t5v0__fillcap_4
XFILLER_47_276 VDD VDD VSS VSS gf180mcu_fd_sc_mcu7t5v0__fillcap_4
X_1811_ _1811_/I _1811_/ZN VDD VDD VSS VSS gf180mcu_fd_sc_mcu7t5v0__clkinv_1
X_1742_ _1932_/A1 _1768_/A2 _1768_/B1 _1932_/B2 _1743_/I VDD VDD VSS VSS gf180mcu_fd_sc_mcu7t5v0__aoi22_1
XTAP_TAPCELL_ROW_96_1413 VDD VSS gf180mcu_fd_sc_mcu7t5v0__filltie
X_1673_ _1673_/I _1673_/ZN VDD VDD VSS VSS gf180mcu_fd_sc_mcu7t5v0__clkinv_1
X_2225_ _2225_/A1 _1217_/C _2226_/A2 VDD VDD VSS VSS gf180mcu_fd_sc_mcu7t5v0__nor2_1
XFILLER_85_349 VDD VDD VSS VSS gf180mcu_fd_sc_mcu7t5v0__fill_1
XFILLER_39_766 VDD VDD VSS VSS gf180mcu_fd_sc_mcu7t5v0__fillcap_4
XFILLER_38_276 VDD VDD VSS VSS gf180mcu_fd_sc_mcu7t5v0__fillcap_16
XFILLER_38_298 VDD VDD VSS VSS gf180mcu_fd_sc_mcu7t5v0__fill_1
XFILLER_54_714 VDD VDD VSS VSS gf180mcu_fd_sc_mcu7t5v0__fill_2
X_2156_ _2579_/Q _2140_/B _2157_/C VDD VDD VSS VSS gf180mcu_fd_sc_mcu7t5v0__nand2_1
XFILLER_53_224 VDD VDD VSS VSS gf180mcu_fd_sc_mcu7t5v0__fill_1
X_2087_ _2087_/A1 _2087_/A2 _2087_/ZN VDD VDD VSS VSS gf180mcu_fd_sc_mcu7t5v0__nand2_1
X_1107_ _1107_/A1 _2231_/C _1248_/A3 VDD VDD VSS VSS gf180mcu_fd_sc_mcu7t5v0__nand2_1
XTAP_TAPCELL_ROW_105_1520 VDD VSS gf180mcu_fd_sc_mcu7t5v0__filltie
XPHY_EDGE_ROW_5_Right_5 VDD VSS gf180mcu_fd_sc_mcu7t5v0__endcap
XFILLER_41_419 VDD VDD VSS VSS gf180mcu_fd_sc_mcu7t5v0__fill_1
XTAP_TAPCELL_ROW_60_981 VDD VSS gf180mcu_fd_sc_mcu7t5v0__filltie
XFILLER_103_410 VDD VDD VSS VSS gf180mcu_fd_sc_mcu7t5v0__fill_1
XFILLER_89_688 VDD VDD VSS VSS gf180mcu_fd_sc_mcu7t5v0__fillcap_4
XFILLER_17_416 VDD VDD VSS VSS gf180mcu_fd_sc_mcu7t5v0__fillcap_4
Xload_slew1069 _2534_/A2 _1914_/A2 VDD VDD VSS VSS gf180mcu_fd_sc_mcu7t5v0__buf_4
XTAP_TAPCELL_ROW_67_1058 VDD VSS gf180mcu_fd_sc_mcu7t5v0__filltie
XFILLER_32_419 VDD VDD VSS VSS gf180mcu_fd_sc_mcu7t5v0__fill_1
XTAP_TAPCELL_ROW_80_1214 VDD VSS gf180mcu_fd_sc_mcu7t5v0__filltie
XFILLER_40_441 VDD VDD VSS VSS gf180mcu_fd_sc_mcu7t5v0__fillcap_8
XTAP_TAPCELL_ROW_10_377 VDD VSS gf180mcu_fd_sc_mcu7t5v0__filltie
XTAP_TAPCELL_ROW_78_1187 VDD VSS gf180mcu_fd_sc_mcu7t5v0__filltie
XTAP_TAPCELL_ROW_78_1198 VDD VSS gf180mcu_fd_sc_mcu7t5v0__filltie
XTAP_TAPCELL_ROW_91_1354 VDD VSS gf180mcu_fd_sc_mcu7t5v0__filltie
XTAP_TAPCELL_ROW_91_1343 VDD VSS gf180mcu_fd_sc_mcu7t5v0__filltie
XFILLER_79_165 VDD VDD VSS VSS gf180mcu_fd_sc_mcu7t5v0__fillcap_4
XFILLER_0_570 VDD VDD VSS VSS gf180mcu_fd_sc_mcu7t5v0__fill_1
XFILLER_95_647 VDD VDD VSS VSS gf180mcu_fd_sc_mcu7t5v0__fill_1
Xinput460 tl_h_i_i[6] _1866_/A1 VDD VDD VSS VSS gf180mcu_fd_sc_mcu7t5v0__dlyd_1
Xinput471 tl_h_i_i[7] _1868_/A1 VDD VDD VSS VSS gf180mcu_fd_sc_mcu7t5v0__dlyd_1
Xinput482 tl_h_i_i[8] _1870_/A1 VDD VDD VSS VSS gf180mcu_fd_sc_mcu7t5v0__dlyd_1
X_2010_ _2010_/A1 _2022_/A2 _2022_/B1 _2737_/I _2011_/I VDD VDD VSS VSS gf180mcu_fd_sc_mcu7t5v0__aoi22_1
XTAP_TAPCELL_ROW_38_709 VDD VSS gf180mcu_fd_sc_mcu7t5v0__filltie
XFILLER_63_500 VDD VDD VSS VSS gf180mcu_fd_sc_mcu7t5v0__fillcap_16
Xinput493 tl_h_i_i[9] _1872_/A1 VDD VDD VSS VSS gf180mcu_fd_sc_mcu7t5v0__dlyd_1
XFILLER_36_769 VDD VDD VSS VSS gf180mcu_fd_sc_mcu7t5v0__fill_2
XFILLER_91_864 VDD VDD VSS VSS gf180mcu_fd_sc_mcu7t5v0__fill_2
XFILLER_91_842 VDD VDD VSS VSS gf180mcu_fd_sc_mcu7t5v0__fillcap_4
XFILLER_35_257 VDD VDD VSS VSS gf180mcu_fd_sc_mcu7t5v0__fillcap_8
XFILLER_35_279 VDD VDD VSS VSS gf180mcu_fd_sc_mcu7t5v0__fill_1
XFILLER_63_566 VDD VDD VSS VSS gf180mcu_fd_sc_mcu7t5v0__fill_2
XTAP_TAPCELL_ROW_18_477 VDD VSS gf180mcu_fd_sc_mcu7t5v0__filltie
XTAP_TAPCELL_ROW_100_1461 VDD VSS gf180mcu_fd_sc_mcu7t5v0__filltie
X_2774_ _2774_/I _2774_/Z VDD VDD VSS VSS gf180mcu_fd_sc_mcu7t5v0__buf_1
X_1725_ _1725_/I _1725_/ZN VDD VDD VSS VSS gf180mcu_fd_sc_mcu7t5v0__clkinv_1
Xoutput912 _2753_/Z tl_d_uart_o[94] VDD VDD VSS VSS gf180mcu_fd_sc_mcu7t5v0__dlyd_1
Xoutput901 _2743_/Z tl_d_uart_o[84] VDD VDD VSS VSS gf180mcu_fd_sc_mcu7t5v0__dlyd_1
Xoutput945 _1399_/ZN tl_h_d_o[33] VDD VDD VSS VSS gf180mcu_fd_sc_mcu7t5v0__dlyd_1
Xoutput934 _1319_/ZN tl_h_d_o[23] VDD VDD VSS VSS gf180mcu_fd_sc_mcu7t5v0__dlyd_1
Xoutput923 _2168_/ZN tl_h_d_o[13] VDD VDD VSS VSS gf180mcu_fd_sc_mcu7t5v0__dlyd_1
X_1656_ _1864_/B2 _1664_/S _1656_/Z VDD VDD VSS VSS gf180mcu_fd_sc_mcu7t5v0__or2_1
Xoutput956 _1479_/ZN tl_h_d_o[43] VDD VDD VSS VSS gf180mcu_fd_sc_mcu7t5v0__dlyd_1
Xoutput967 _2211_/ZN tl_h_d_o[53] VDD VDD VSS VSS gf180mcu_fd_sc_mcu7t5v0__dlyd_1
Xoutput978 _1237_/ZN tl_h_d_o[63] VDD VDD VSS VSS gf180mcu_fd_sc_mcu7t5v0__dlyd_1
X_1587_ _1576_/Z _1586_/Z _1587_/Z VDD VDD VSS VSS gf180mcu_fd_sc_mcu7t5v0__xor2_1
Xoutput989 _2075_/ZN tl_h_i_o[13] VDD VDD VSS VSS gf180mcu_fd_sc_mcu7t5v0__dlyd_1
XPHY_EDGE_ROW_13_Left_132 VDD VSS gf180mcu_fd_sc_mcu7t5v0__endcap
XTAP_TAPCELL_ROW_111_1590 VDD VSS gf180mcu_fd_sc_mcu7t5v0__filltie
XFILLER_100_457 VDD VDD VSS VSS gf180mcu_fd_sc_mcu7t5v0__fillcap_8
XFILLER_39_552 VDD VDD VSS VSS gf180mcu_fd_sc_mcu7t5v0__fillcap_8
X_2208_ input50/Z _2247_/A2 _2208_/B _2211_/A1 VDD VDD VSS VSS gf180mcu_fd_sc_mcu7t5v0__oai21_1
XFILLER_82_831 VDD VDD VSS VSS gf180mcu_fd_sc_mcu7t5v0__fill_1
X_2139_ _2579_/Q _2580_/Q _2139_/Z VDD VDD VSS VSS gf180mcu_fd_sc_mcu7t5v0__xor2_1
XFILLER_81_396 VDD VDD VSS VSS gf180mcu_fd_sc_mcu7t5v0__fillcap_16
XPHY_EDGE_ROW_22_Left_141 VDD VSS gf180mcu_fd_sc_mcu7t5v0__endcap
XFILLER_10_658 VDD VDD VSS VSS gf180mcu_fd_sc_mcu7t5v0__fillcap_4
XTAP_TAPCELL_ROW_114_1619 VDD VSS gf180mcu_fd_sc_mcu7t5v0__filltie
XFILLER_2_857 VDD VDD VSS VSS gf180mcu_fd_sc_mcu7t5v0__fillcap_8
XPHY_EDGE_ROW_31_Left_150 VDD VSS gf180mcu_fd_sc_mcu7t5v0__endcap
XFILLER_89_430 VDD VDD VSS VSS gf180mcu_fd_sc_mcu7t5v0__fillcap_4
XFILLER_18_769 VDD VDD VSS VSS gf180mcu_fd_sc_mcu7t5v0__fill_2
XFILLER_73_842 VDD VDD VSS VSS gf180mcu_fd_sc_mcu7t5v0__fillcap_16
XFILLER_17_268 VDD VDD VSS VSS gf180mcu_fd_sc_mcu7t5v0__fillcap_8
XTAP_TAPCELL_ROW_43_778 VDD VSS gf180mcu_fd_sc_mcu7t5v0__filltie
XTAP_TAPCELL_ROW_43_767 VDD VSS gf180mcu_fd_sc_mcu7t5v0__filltie
XTAP_TAPCELL_ROW_15_436 VDD VSS gf180mcu_fd_sc_mcu7t5v0__filltie
X_2490_ _2491_/A1 _2773_/I _2497_/A1 VDD VDD VSS VSS gf180mcu_fd_sc_mcu7t5v0__nand2_1
X_1510_ _1510_/A1 _1510_/A2 _1510_/B1 _1217_/C _1511_/A2 VDD VDD VSS VSS gf180mcu_fd_sc_mcu7t5v0__aoi22_1
X_1441_ _1441_/A1 _2345_/A2 _1441_/Z VDD VDD VSS VSS gf180mcu_fd_sc_mcu7t5v0__and2_1
Xxbar_tlul_2to4_1250 tl_d_esram_o[95] VDD VDD VSS VSS gf180mcu_fd_sc_mcu7t5v0__tiel
Xxbar_tlul_2to4_1261 tl_d_esram_o[84] VDD VDD VSS VSS gf180mcu_fd_sc_mcu7t5v0__tiel
X_1372_ input25/Z _1396_/A2 _1372_/B1 _1444_/B2 _1373_/I VDD VDD VSS VSS gf180mcu_fd_sc_mcu7t5v0__aoi22_1
XFILLER_95_422 VDD VDD VSS VSS gf180mcu_fd_sc_mcu7t5v0__fillcap_8
Xxbar_tlul_2to4_1272 tl_d_rom_o[88] VDD VDD VSS VSS gf180mcu_fd_sc_mcu7t5v0__tiel
Xinput290 tl_h_d_i[19] _2710_/I VDD VDD VSS VSS gf180mcu_fd_sc_mcu7t5v0__clkbuf_2
XFILLER_95_488 VDD VDD VSS VSS gf180mcu_fd_sc_mcu7t5v0__fill_2
XFILLER_83_628 VDD VDD VSS VSS gf180mcu_fd_sc_mcu7t5v0__fill_2
XFILLER_48_393 VDD VDD VSS VSS gf180mcu_fd_sc_mcu7t5v0__fill_1
XFILLER_64_831 VDD VDD VSS VSS gf180mcu_fd_sc_mcu7t5v0__fill_1
XFILLER_63_352 VDD VDD VSS VSS gf180mcu_fd_sc_mcu7t5v0__fillcap_64
XFILLER_90_193 VDD VDD VSS VSS gf180mcu_fd_sc_mcu7t5v0__fill_1
XFILLER_31_282 VDD VDD VSS VSS gf180mcu_fd_sc_mcu7t5v0__fillcap_8
X_2757_ _2757_/I _2757_/Z VDD VDD VSS VSS gf180mcu_fd_sc_mcu7t5v0__buf_1
X_2688_ _2760_/I _2688_/Z VDD VDD VSS VSS gf180mcu_fd_sc_mcu7t5v0__buf_1
Xoutput720 _1853_/ZN tl_d_rom_o[111] VDD VDD VSS VSS gf180mcu_fd_sc_mcu7t5v0__dlyd_1
X_1708_ _1898_/A1 _1728_/A2 _1718_/B1 _2713_/I _1709_/I VDD VDD VSS VSS gf180mcu_fd_sc_mcu7t5v0__aoi22_1
Xoutput753 _1743_/ZN tl_d_rom_o[39] VDD VDD VSS VSS gf180mcu_fd_sc_mcu7t5v0__dlyd_1
Xoutput742 _1723_/ZN tl_d_rom_o[29] VDD VDD VSS VSS gf180mcu_fd_sc_mcu7t5v0__dlyd_1
Xoutput731 _1703_/ZN tl_d_rom_o[19] VDD VDD VSS VSS gf180mcu_fd_sc_mcu7t5v0__dlyd_1
X_1639_ _1950_/B2 _1641_/A2 _1639_/Z VDD VDD VSS VSS gf180mcu_fd_sc_mcu7t5v0__or2_1
XFILLER_48_16 VDD VDD VSS VSS gf180mcu_fd_sc_mcu7t5v0__fill_1
Xoutput797 _1823_/ZN tl_d_rom_o[79] VDD VDD VSS VSS gf180mcu_fd_sc_mcu7t5v0__dlyd_1
Xoutput786 _1803_/ZN tl_d_rom_o[69] VDD VDD VSS VSS gf180mcu_fd_sc_mcu7t5v0__dlyd_1
Xoutput775 _1783_/ZN tl_d_rom_o[59] VDD VDD VSS VSS gf180mcu_fd_sc_mcu7t5v0__dlyd_1
Xoutput764 _1763_/ZN tl_d_rom_o[49] VDD VDD VSS VSS gf180mcu_fd_sc_mcu7t5v0__dlyd_1
XFILLER_67_680 VDD VDD VSS VSS gf180mcu_fd_sc_mcu7t5v0__fillcap_4
XFILLER_55_842 VDD VDD VSS VSS gf180mcu_fd_sc_mcu7t5v0__fill_2
XFILLER_73_138 VDD VDD VSS VSS gf180mcu_fd_sc_mcu7t5v0__fill_2
XFILLER_55_864 VDD VDD VSS VSS gf180mcu_fd_sc_mcu7t5v0__fill_2
XFILLER_70_801 VDD VDD VSS VSS gf180mcu_fd_sc_mcu7t5v0__fillcap_4
XTAP_TAPCELL_ROW_64_1028 VDD VSS gf180mcu_fd_sc_mcu7t5v0__filltie
XFILLER_82_683 VDD VDD VSS VSS gf180mcu_fd_sc_mcu7t5v0__fillcap_8
XFILLER_70_823 VDD VDD VSS VSS gf180mcu_fd_sc_mcu7t5v0__fillcap_8
XTAP_TAPCELL_ROW_12_406 VDD VSS gf180mcu_fd_sc_mcu7t5v0__filltie
XTAP_TAPCELL_ROW_40_737 VDD VSS gf180mcu_fd_sc_mcu7t5v0__filltie
XFILLER_6_459 VDD VDD VSS VSS gf180mcu_fd_sc_mcu7t5v0__fillcap_8
XTAP_TAPCELL_ROW_20_494 VDD VSS gf180mcu_fd_sc_mcu7t5v0__filltie
XTAP_TAPCELL_ROW_75_1157 VDD VSS gf180mcu_fd_sc_mcu7t5v0__filltie
XFILLER_89_282 VDD VDD VSS VSS gf180mcu_fd_sc_mcu7t5v0__fillcap_64
XFILLER_77_422 VDD VDD VSS VSS gf180mcu_fd_sc_mcu7t5v0__fill_2
XFILLER_46_831 VDD VDD VSS VSS gf180mcu_fd_sc_mcu7t5v0__fill_1
XFILLER_64_127 VDD VDD VSS VSS gf180mcu_fd_sc_mcu7t5v0__fill_2
XTAP_TAPCELL_ROW_48_837 VDD VSS gf180mcu_fd_sc_mcu7t5v0__filltie
XFILLER_92_447 VDD VDD VSS VSS gf180mcu_fd_sc_mcu7t5v0__fillcap_8
XFILLER_45_352 VDD VDD VSS VSS gf180mcu_fd_sc_mcu7t5v0__fillcap_16
XFILLER_60_311 VDD VDD VSS VSS gf180mcu_fd_sc_mcu7t5v0__fillcap_4
XTAP_TAPCELL_ROW_86_1286 VDD VSS gf180mcu_fd_sc_mcu7t5v0__filltie
X_1990_ _1990_/A1 _2030_/A2 _2014_/B1 _2727_/I _1991_/I VDD VDD VSS VSS gf180mcu_fd_sc_mcu7t5v0__aoi22_1
XTAP_TAPCELL_ROW_28_594 VDD VSS gf180mcu_fd_sc_mcu7t5v0__filltie
XFILLER_60_399 VDD VDD VSS VSS gf180mcu_fd_sc_mcu7t5v0__fill_1
XFILLER_13_282 VDD VDD VSS VSS gf180mcu_fd_sc_mcu7t5v0__fillcap_4
XFILLER_9_275 VDD VDD VSS VSS gf180mcu_fd_sc_mcu7t5v0__fillcap_4
X_2542_ _2542_/D _2558_/RN clkload0/I _2542_/Q VDD VDD VSS VSS gf180mcu_fd_sc_mcu7t5v0__dffrnq_1
XFILLER_48_2 VDD VDD VSS VSS gf180mcu_fd_sc_mcu7t5v0__fillcap_8
X_2473_ _2758_/I _2583_/Q _2478_/S _2583_/D VDD VDD VSS VSS gf180mcu_fd_sc_mcu7t5v0__mux2_2
XFILLER_68_411 VDD VDD VSS VSS gf180mcu_fd_sc_mcu7t5v0__fill_2
X_1424_ _1424_/A1 _1432_/A2 _2337_/A2 VDD VDD VSS VSS gf180mcu_fd_sc_mcu7t5v0__nand2_1
X_1355_ _1491_/A1 _1353_/Z _1355_/B _1356_/B1 VDD VDD VSS VSS gf180mcu_fd_sc_mcu7t5v0__oai21_1
XFILLER_56_617 VDD VDD VSS VSS gf180mcu_fd_sc_mcu7t5v0__fill_2
XFILLER_37_842 VDD VDD VSS VSS gf180mcu_fd_sc_mcu7t5v0__fill_1
XFILLER_55_138 VDD VDD VSS VSS gf180mcu_fd_sc_mcu7t5v0__fill_2
X_1286_ _1286_/A1 _1398_/A2 _1286_/B1 _2146_/C _1287_/A2 VDD VDD VSS VSS gf180mcu_fd_sc_mcu7t5v0__aoi22_1
XFILLER_36_363 VDD VDD VSS VSS gf180mcu_fd_sc_mcu7t5v0__fillcap_16
XFILLER_52_823 VDD VDD VSS VSS gf180mcu_fd_sc_mcu7t5v0__fillcap_8
XFILLER_20_731 VDD VDD VSS VSS gf180mcu_fd_sc_mcu7t5v0__fillcap_4
Xclkload6 clkload6/I clkload6/ZN VDD VDD VSS VSS gf180mcu_fd_sc_mcu7t5v0__inv_2
Xoutput550 _1531_/Z tl_d_dmem_o[48] VDD VDD VSS VSS gf180mcu_fd_sc_mcu7t5v0__dlyd_1
Xoutput561 _1541_/Z tl_d_dmem_o[58] VDD VDD VSS VSS gf180mcu_fd_sc_mcu7t5v0__dlyd_1
Xoutput572 _2655_/Z tl_d_dmem_o[68] VDD VDD VSS VSS gf180mcu_fd_sc_mcu7t5v0__dlyd_1
XFILLER_105_379 VDD VDD VSS VSS gf180mcu_fd_sc_mcu7t5v0__fillcap_32
XFILLER_59_422 VDD VDD VSS VSS gf180mcu_fd_sc_mcu7t5v0__fillcap_64
Xfanout1208 _2363_/A3 _2259_/A3 VDD VDD VSS VSS gf180mcu_fd_sc_mcu7t5v0__dlyd_1
Xfanout1219 _2369_/A1 _2357_/A1 VDD VDD VSS VSS gf180mcu_fd_sc_mcu7t5v0__dlyd_1
Xoutput583 _2665_/Z tl_d_dmem_o[78] VDD VDD VSS VSS gf180mcu_fd_sc_mcu7t5v0__dlyd_1
Xoutput594 _2675_/Z tl_d_dmem_o[88] VDD VDD VSS VSS gf180mcu_fd_sc_mcu7t5v0__dlyd_1
XFILLER_101_541 VDD VDD VSS VSS gf180mcu_fd_sc_mcu7t5v0__fill_2
XFILLER_47_617 VDD VDD VSS VSS gf180mcu_fd_sc_mcu7t5v0__fillcap_8
XTAP_TAPCELL_ROW_70_1098 VDD VSS gf180mcu_fd_sc_mcu7t5v0__filltie
XFILLER_28_831 VDD VDD VSS VSS gf180mcu_fd_sc_mcu7t5v0__fill_1
XFILLER_27_352 VDD VDD VSS VSS gf180mcu_fd_sc_mcu7t5v0__fillcap_32
XFILLER_42_311 VDD VDD VSS VSS gf180mcu_fd_sc_mcu7t5v0__fillcap_4
XTAP_TAPCELL_ROW_25_553 VDD VSS gf180mcu_fd_sc_mcu7t5v0__filltie
XFILLER_70_675 VDD VDD VSS VSS gf180mcu_fd_sc_mcu7t5v0__fill_2
XTAP_TAPCELL_ROW_53_895 VDD VSS gf180mcu_fd_sc_mcu7t5v0__filltie
XFILLER_69_208 VDD VDD VSS VSS gf180mcu_fd_sc_mcu7t5v0__fill_2
X_1140_ _1146_/C _1146_/A2 _1202_/B VDD VDD VSS VSS gf180mcu_fd_sc_mcu7t5v0__nor2_1
XTAP_TAPCELL_ROW_88_1315 VDD VSS gf180mcu_fd_sc_mcu7t5v0__filltie
XFILLER_93_723 VDD VDD VSS VSS gf180mcu_fd_sc_mcu7t5v0__fill_2
XFILLER_19_842 VDD VDD VSS VSS gf180mcu_fd_sc_mcu7t5v0__fillcap_16
XFILLER_34_801 VDD VDD VSS VSS gf180mcu_fd_sc_mcu7t5v0__fillcap_4
XFILLER_37_149 VDD VDD VSS VSS gf180mcu_fd_sc_mcu7t5v0__fillcap_32
XFILLER_46_661 VDD VDD VSS VSS gf180mcu_fd_sc_mcu7t5v0__fillcap_4
X_1071_ _1071_/I _1190_/C VDD VDD VSS VSS gf180mcu_fd_sc_mcu7t5v0__clkinv_1
XFILLER_34_823 VDD VDD VSS VSS gf180mcu_fd_sc_mcu7t5v0__fillcap_8
XFILLER_33_344 VDD VDD VSS VSS gf180mcu_fd_sc_mcu7t5v0__fillcap_4
XFILLER_45_182 VDD VDD VSS VSS gf180mcu_fd_sc_mcu7t5v0__fillcap_16
XFILLER_14_591 VDD VDD VSS VSS gf180mcu_fd_sc_mcu7t5v0__fillcap_4
X_1973_ _1973_/I _1973_/ZN VDD VDD VSS VSS gf180mcu_fd_sc_mcu7t5v0__clkinv_1
XTAP_TAPCELL_ROW_99_1444 VDD VSS gf180mcu_fd_sc_mcu7t5v0__filltie
X_2525_ _2507_/B _2523_/Z _2525_/B _2596_/D VDD VDD VSS VSS gf180mcu_fd_sc_mcu7t5v0__oai21_1
XFILLER_88_517 VDD VDD VSS VSS gf180mcu_fd_sc_mcu7t5v0__fillcap_8
X_2456_ _2456_/A1 _2517_/B _2456_/B _2569_/D VDD VDD VSS VSS gf180mcu_fd_sc_mcu7t5v0__oai21_1
XFILLER_102_338 VDD VDD VSS VSS gf180mcu_fd_sc_mcu7t5v0__fillcap_32
X_1407_ _1407_/A1 _1407_/A2 _1407_/ZN VDD VDD VSS VSS gf180mcu_fd_sc_mcu7t5v0__nor2_1
XFILLER_29_628 VDD VDD VSS VSS gf180mcu_fd_sc_mcu7t5v0__fill_2
XFILLER_56_403 VDD VDD VSS VSS gf180mcu_fd_sc_mcu7t5v0__fillcap_4
XFILLER_68_241 VDD VDD VSS VSS gf180mcu_fd_sc_mcu7t5v0__fillcap_4
X_2387_ _2387_/I0 _2543_/Q _2402_/S _2543_/D VDD VDD VSS VSS gf180mcu_fd_sc_mcu7t5v0__mux2_2
XFILLER_96_561 VDD VDD VSS VSS gf180mcu_fd_sc_mcu7t5v0__fillcap_32
X_1338_ input86/Z _2116_/B1 _2259_/A3 _1339_/B VDD VDD VSS VSS gf180mcu_fd_sc_mcu7t5v0__nand3_1
XFILLER_84_734 VDD VDD VSS VSS gf180mcu_fd_sc_mcu7t5v0__fill_1
X_1269_ _1269_/I _1270_/B1 VDD VDD VSS VSS gf180mcu_fd_sc_mcu7t5v0__clkinv_1
XFILLER_24_311 VDD VDD VSS VSS gf180mcu_fd_sc_mcu7t5v0__fillcap_4
XTAP_TAPCELL_ROW_108_1551 VDD VSS gf180mcu_fd_sc_mcu7t5v0__filltie
XFILLER_83_277 VDD VDD VSS VSS gf180mcu_fd_sc_mcu7t5v0__fill_2
XFILLER_24_333 VDD VDD VSS VSS gf180mcu_fd_sc_mcu7t5v0__fill_1
XFILLER_36_193 VDD VDD VSS VSS gf180mcu_fd_sc_mcu7t5v0__fill_2
XFILLER_52_664 VDD VDD VSS VSS gf180mcu_fd_sc_mcu7t5v0__fill_1
XFILLER_51_185 VDD VDD VSS VSS gf180mcu_fd_sc_mcu7t5v0__fill_1
XTAP_TAPCELL_ROW_22_523 VDD VSS gf180mcu_fd_sc_mcu7t5v0__filltie
XTAP_TAPCELL_ROW_50_854 VDD VSS gf180mcu_fd_sc_mcu7t5v0__filltie
XTAP_TAPCELL_ROW_72_1116 VDD VSS gf180mcu_fd_sc_mcu7t5v0__filltie
XPHY_EDGE_ROW_5_Left_124 VDD VSS gf180mcu_fd_sc_mcu7t5v0__endcap
Xwire1100 _2383_/A2 _2434_/B VDD VDD VSS VSS gf180mcu_fd_sc_mcu7t5v0__clkbuf_8
XFILLER_59_274 VDD VDD VSS VSS gf180mcu_fd_sc_mcu7t5v0__fillcap_4
XFILLER_47_469 VDD VDD VSS VSS gf180mcu_fd_sc_mcu7t5v0__fillcap_4
Xwire1177 wire1177/I _2236_/B VDD VDD VSS VSS gf180mcu_fd_sc_mcu7t5v0__clkbuf_4
Xwire1199 _2230_/B _2236_/A2 VDD VDD VSS VSS gf180mcu_fd_sc_mcu7t5v0__clkbuf_4
XTAP_TAPCELL_ROW_58_954 VDD VSS gf180mcu_fd_sc_mcu7t5v0__filltie
XFILLER_90_715 VDD VDD VSS VSS gf180mcu_fd_sc_mcu7t5v0__fillcap_16
XFILLER_16_823 VDD VDD VSS VSS gf180mcu_fd_sc_mcu7t5v0__fillcap_8
XFILLER_55_480 VDD VDD VSS VSS gf180mcu_fd_sc_mcu7t5v0__fillcap_8
XTAP_TAPCELL_ROW_2_281 VDD VSS gf180mcu_fd_sc_mcu7t5v0__filltie
XFILLER_42_141 VDD VDD VSS VSS gf180mcu_fd_sc_mcu7t5v0__fillcap_32
XTAP_TAPCELL_ROW_83_1256 VDD VSS gf180mcu_fd_sc_mcu7t5v0__filltie
X_2310_ _2346_/A1 _2310_/A2 _2312_/A1 VDD VDD VSS VSS gf180mcu_fd_sc_mcu7t5v0__nand2_1
XTAP_TAPCELL_ROW_94_1385 VDD VSS gf180mcu_fd_sc_mcu7t5v0__filltie
X_2241_ _2241_/A1 _2236_/B _2244_/B VDD VDD VSS VSS gf180mcu_fd_sc_mcu7t5v0__nand2_1
XFILLER_97_347 VDD VDD VSS VSS gf180mcu_fd_sc_mcu7t5v0__fill_2
XFILLER_78_572 VDD VDD VSS VSS gf180mcu_fd_sc_mcu7t5v0__fillcap_16
X_2172_ _2172_/A1 _2172_/A2 _2172_/B1 _2172_/B2 _2172_/ZN VDD VDD VSS VSS gf180mcu_fd_sc_mcu7t5v0__aoi22_1
XFILLER_78_594 VDD VDD VSS VSS gf180mcu_fd_sc_mcu7t5v0__fill_1
XFILLER_65_266 VDD VDD VSS VSS gf180mcu_fd_sc_mcu7t5v0__fillcap_4
X_1123_ _2547_/Q _1123_/A2 _2076_/A2 VDD VDD VSS VSS gf180mcu_fd_sc_mcu7t5v0__nand2_1
XFILLER_65_277 VDD VDD VSS VSS gf180mcu_fd_sc_mcu7t5v0__fill_2
XPHY_EDGE_ROW_69_Left_188 VDD VSS gf180mcu_fd_sc_mcu7t5v0__endcap
XFILLER_80_247 VDD VDD VSS VSS gf180mcu_fd_sc_mcu7t5v0__fillcap_16
XFILLER_21_347 VDD VDD VSS VSS gf180mcu_fd_sc_mcu7t5v0__fill_2
X_1956_ _1956_/A1 _1976_/A2 _2030_/B1 _1956_/B2 _1957_/I VDD VDD VSS VSS gf180mcu_fd_sc_mcu7t5v0__aoi22_1
XTAP_TAPCELL_ROW_103_1492 VDD VSS gf180mcu_fd_sc_mcu7t5v0__filltie
X_1887_ _1887_/I _1887_/ZN VDD VDD VSS VSS gf180mcu_fd_sc_mcu7t5v0__clkinv_1
XPHY_EDGE_ROW_78_Left_197 VDD VSS gf180mcu_fd_sc_mcu7t5v0__endcap
X_2508_ _2593_/Q _2507_/B _2505_/Z _2508_/B2 _2509_/I VDD VDD VSS VSS gf180mcu_fd_sc_mcu7t5v0__aoi22_1
Xoutput1030 _2087_/ZN tl_h_i_o[50] VDD VDD VSS VSS gf180mcu_fd_sc_mcu7t5v0__dlyd_1
Xoutput1041 _2109_/ZN tl_h_i_o[60] VDD VDD VSS VSS gf180mcu_fd_sc_mcu7t5v0__dlyd_1
Xinput108 tl_d_esram_i[46] _2375_/A1 VDD VDD VSS VSS gf180mcu_fd_sc_mcu7t5v0__dlyd_1
Xinput119 tl_d_esram_i[56] _2221_/A1 VDD VDD VSS VSS gf180mcu_fd_sc_mcu7t5v0__dlyd_1
X_2439_ _2439_/A1 _2439_/A2 _2439_/A3 _2775_/I _2440_/A2 VDD VDD VSS VSS gf180mcu_fd_sc_mcu7t5v0__oai31_1
XFILLER_29_414 VDD VDD VSS VSS gf180mcu_fd_sc_mcu7t5v0__fillcap_4
Xload_slew1207 fanout1206/Z _2311_/A3 VDD VDD VSS VSS gf180mcu_fd_sc_mcu7t5v0__clkbuf_4
XFILLER_84_520 VDD VDD VSS VSS gf180mcu_fd_sc_mcu7t5v0__fillcap_4
Xload_slew1218 _2317_/A1 _2333_/A1 VDD VDD VSS VSS gf180mcu_fd_sc_mcu7t5v0__clkbuf_4
XTAP_TAPCELL_ROW_55_913 VDD VSS gf180mcu_fd_sc_mcu7t5v0__filltie
XFILLER_72_737 VDD VDD VSS VSS gf180mcu_fd_sc_mcu7t5v0__fillcap_64
XFILLER_72_37 VDD VDD VSS VSS gf180mcu_fd_sc_mcu7t5v0__fillcap_4
XFILLER_13_859 VDD VDD VSS VSS gf180mcu_fd_sc_mcu7t5v0__fillcap_4
XTAP_TAPCELL_ROW_35_681 VDD VSS gf180mcu_fd_sc_mcu7t5v0__filltie
XFILLER_40_667 VDD VDD VSS VSS gf180mcu_fd_sc_mcu7t5v0__fill_2
XTAP_TAPCELL_ROW_7_340 VDD VSS gf180mcu_fd_sc_mcu7t5v0__filltie
XFILLER_79_347 VDD VDD VSS VSS gf180mcu_fd_sc_mcu7t5v0__fill_2
XFILLER_94_317 VDD VDD VSS VSS gf180mcu_fd_sc_mcu7t5v0__fillcap_4
XFILLER_47_200 VDD VDD VSS VSS gf180mcu_fd_sc_mcu7t5v0__fillcap_8
XFILLER_48_734 VDD VDD VSS VSS gf180mcu_fd_sc_mcu7t5v0__fill_1
XFILLER_47_299 VDD VDD VSS VSS gf180mcu_fd_sc_mcu7t5v0__fillcap_32
XFILLER_62_225 VDD VDD VSS VSS gf180mcu_fd_sc_mcu7t5v0__fillcap_4
XFILLER_62_247 VDD VDD VSS VSS gf180mcu_fd_sc_mcu7t5v0__fillcap_4
XFILLER_63_748 VDD VDD VSS VSS gf180mcu_fd_sc_mcu7t5v0__fillcap_16
XFILLER_15_196 VDD VDD VSS VSS gf180mcu_fd_sc_mcu7t5v0__fillcap_8
X_1810_ _2000_/A1 _1818_/A2 _1838_/B1 _2732_/I _1811_/I VDD VDD VSS VSS gf180mcu_fd_sc_mcu7t5v0__aoi22_1
XFILLER_30_177 VDD VDD VSS VSS gf180mcu_fd_sc_mcu7t5v0__fillcap_4
X_1741_ _1741_/I _1741_/ZN VDD VDD VSS VSS gf180mcu_fd_sc_mcu7t5v0__clkinv_1
XTAP_TAPCELL_ROW_96_1414 VDD VSS gf180mcu_fd_sc_mcu7t5v0__filltie
XTAP_TAPCELL_ROW_96_1403 VDD VSS gf180mcu_fd_sc_mcu7t5v0__filltie
X_1672_ _1862_/A1 _1720_/A2 _1720_/B1 _1085_/I _1673_/I VDD VDD VSS VSS gf180mcu_fd_sc_mcu7t5v0__aoi22_1
XFILLER_30_2 VDD VDD VSS VSS gf180mcu_fd_sc_mcu7t5v0__fillcap_16
XFILLER_86_807 VDD VDD VSS VSS gf180mcu_fd_sc_mcu7t5v0__fillcap_16
XFILLER_85_306 VDD VDD VSS VSS gf180mcu_fd_sc_mcu7t5v0__fill_1
XFILLER_38_200 VDD VDD VSS VSS gf180mcu_fd_sc_mcu7t5v0__fill_2
X_2224_ _2570_/Q _2588_/Q input53/Z _2230_/B _2224_/C _2226_/A1 VDD VDD VSS VSS gf180mcu_fd_sc_mcu7t5v0__aoi221_1
XFILLER_38_233 VDD VDD VSS VSS gf180mcu_fd_sc_mcu7t5v0__fillcap_8
X_2155_ _2155_/A1 _2172_/A2 _2155_/B1 _2155_/B2 _2155_/C _2155_/ZN VDD VDD VSS VSS
+ gf180mcu_fd_sc_mcu7t5v0__aoi221_2
XFILLER_53_203 VDD VDD VSS VSS gf180mcu_fd_sc_mcu7t5v0__fillcap_4
XFILLER_54_737 VDD VDD VSS VSS gf180mcu_fd_sc_mcu7t5v0__fillcap_64
XFILLER_66_575 VDD VDD VSS VSS gf180mcu_fd_sc_mcu7t5v0__fill_1
XFILLER_66_597 VDD VDD VSS VSS gf180mcu_fd_sc_mcu7t5v0__fillcap_16
X_1106_ _2569_/Q _1106_/A2 _1106_/ZN VDD VDD VSS VSS gf180mcu_fd_sc_mcu7t5v0__nand2_1
X_2086_ _1066_/I _2552_/Q _2190_/A1 _2347_/A2 _2087_/A2 VDD VDD VSS VSS gf180mcu_fd_sc_mcu7t5v0__aoi22_1
XTAP_TAPCELL_ROW_105_1521 VDD VSS gf180mcu_fd_sc_mcu7t5v0__filltie
XFILLER_81_545 VDD VDD VSS VSS gf180mcu_fd_sc_mcu7t5v0__fillcap_4
XFILLER_34_483 VDD VDD VSS VSS gf180mcu_fd_sc_mcu7t5v0__fill_1
XFILLER_10_807 VDD VDD VSS VSS gf180mcu_fd_sc_mcu7t5v0__fillcap_16
XFILLER_22_667 VDD VDD VSS VSS gf180mcu_fd_sc_mcu7t5v0__fillcap_64
XFILLER_42_29 VDD VDD VSS VSS gf180mcu_fd_sc_mcu7t5v0__fill_2
XTAP_TAPCELL_ROW_32_640 VDD VSS gf180mcu_fd_sc_mcu7t5v0__filltie
XTAP_TAPCELL_ROW_60_982 VDD VSS gf180mcu_fd_sc_mcu7t5v0__filltie
XTAP_TAPCELL_ROW_60_971 VDD VSS gf180mcu_fd_sc_mcu7t5v0__filltie
XPHY_EDGE_ROW_86_Left_205 VDD VSS gf180mcu_fd_sc_mcu7t5v0__endcap
X_1939_ _1939_/I _1939_/ZN VDD VDD VSS VSS gf180mcu_fd_sc_mcu7t5v0__clkinv_1
Xinput90 tl_d_esram_i[2] input90/Z VDD VDD VSS VSS gf180mcu_fd_sc_mcu7t5v0__dlyd_1
XTAP_TAPCELL_ROW_116_1650 VDD VSS gf180mcu_fd_sc_mcu7t5v0__filltie
XFILLER_103_422 VDD VDD VSS VSS gf180mcu_fd_sc_mcu7t5v0__fillcap_64
XPHY_EDGE_ROW_95_Left_214 VDD VSS gf180mcu_fd_sc_mcu7t5v0__endcap
XTAP_TAPCELL_ROW_4_310 VDD VSS gf180mcu_fd_sc_mcu7t5v0__filltie
XFILLER_76_317 VDD VDD VSS VSS gf180mcu_fd_sc_mcu7t5v0__fillcap_16
Xload_slew1059 _1926_/B1 _1900_/B1 VDD VDD VSS VSS gf180mcu_fd_sc_mcu7t5v0__buf_4
XFILLER_84_372 VDD VDD VSS VSS gf180mcu_fd_sc_mcu7t5v0__fillcap_8
XFILLER_84_361 VDD VDD VSS VSS gf180mcu_fd_sc_mcu7t5v0__fill_1
XFILLER_29_299 VDD VDD VSS VSS gf180mcu_fd_sc_mcu7t5v0__fillcap_32
XFILLER_44_247 VDD VDD VSS VSS gf180mcu_fd_sc_mcu7t5v0__fill_1
XTAP_TAPCELL_ROW_67_1059 VDD VSS gf180mcu_fd_sc_mcu7t5v0__filltie
XFILLER_25_483 VDD VDD VSS VSS gf180mcu_fd_sc_mcu7t5v0__fillcap_4
XTAP_TAPCELL_ROW_80_1215 VDD VSS gf180mcu_fd_sc_mcu7t5v0__filltie
XPHY_EDGE_ROW_11_Right_11 VDD VSS gf180mcu_fd_sc_mcu7t5v0__endcap
XFILLER_40_453 VDD VDD VSS VSS gf180mcu_fd_sc_mcu7t5v0__fill_2
XFILLER_40_475 VDD VDD VSS VSS gf180mcu_fd_sc_mcu7t5v0__fill_1
XTAP_TAPCELL_ROW_10_378 VDD VSS gf180mcu_fd_sc_mcu7t5v0__filltie
XTAP_TAPCELL_ROW_78_1188 VDD VSS gf180mcu_fd_sc_mcu7t5v0__filltie
XTAP_TAPCELL_ROW_91_1344 VDD VSS gf180mcu_fd_sc_mcu7t5v0__filltie
XPHY_EDGE_ROW_20_Right_20 VDD VSS gf180mcu_fd_sc_mcu7t5v0__endcap
XFILLER_79_133 VDD VDD VSS VSS gf180mcu_fd_sc_mcu7t5v0__fillcap_4
XFILLER_79_122 VDD VDD VSS VSS gf180mcu_fd_sc_mcu7t5v0__fill_2
XFILLER_95_615 VDD VDD VSS VSS gf180mcu_fd_sc_mcu7t5v0__fill_2
XFILLER_68_807 VDD VDD VSS VSS gf180mcu_fd_sc_mcu7t5v0__fillcap_16
XFILLER_79_177 VDD VDD VSS VSS gf180mcu_fd_sc_mcu7t5v0__fillcap_32
Xinput450 tl_h_i_i[60] _1974_/A1 VDD VDD VSS VSS gf180mcu_fd_sc_mcu7t5v0__dlyd_1
Xinput461 tl_h_i_i[70] _1994_/A1 VDD VDD VSS VSS gf180mcu_fd_sc_mcu7t5v0__dlyd_1
Xinput472 tl_h_i_i[80] _2014_/A1 VDD VDD VSS VSS gf180mcu_fd_sc_mcu7t5v0__dlyd_1
XFILLER_82_309 VDD VDD VSS VSS gf180mcu_fd_sc_mcu7t5v0__fillcap_4
XFILLER_35_203 VDD VDD VSS VSS gf180mcu_fd_sc_mcu7t5v0__fillcap_4
XFILLER_36_737 VDD VDD VSS VSS gf180mcu_fd_sc_mcu7t5v0__fillcap_32
XFILLER_48_586 VDD VDD VSS VSS gf180mcu_fd_sc_mcu7t5v0__fillcap_8
XFILLER_48_597 VDD VDD VSS VSS gf180mcu_fd_sc_mcu7t5v0__fill_2
Xinput483 tl_h_i_i[90] _1165_/A4 VDD VDD VSS VSS gf180mcu_fd_sc_mcu7t5v0__dlyd_1
XFILLER_75_361 VDD VDD VSS VSS gf180mcu_fd_sc_mcu7t5v0__fill_2
XTAP_TAPCELL_ROW_18_467 VDD VSS gf180mcu_fd_sc_mcu7t5v0__filltie
XTAP_TAPCELL_ROW_18_478 VDD VSS gf180mcu_fd_sc_mcu7t5v0__filltie
XFILLER_31_475 VDD VDD VSS VSS gf180mcu_fd_sc_mcu7t5v0__fillcap_8
XTAP_TAPCELL_ROW_100_1462 VDD VSS gf180mcu_fd_sc_mcu7t5v0__filltie
XTAP_TAPCELL_ROW_100_1451 VDD VSS gf180mcu_fd_sc_mcu7t5v0__filltie
X_2773_ _2773_/I _2773_/Z VDD VDD VSS VSS gf180mcu_fd_sc_mcu7t5v0__buf_1
X_1724_ _1914_/A1 _1732_/A2 _1762_/B1 _1914_/B2 _1725_/I VDD VDD VSS VSS gf180mcu_fd_sc_mcu7t5v0__aoi22_1
Xoutput902 _2744_/Z tl_d_uart_o[85] VDD VDD VSS VSS gf180mcu_fd_sc_mcu7t5v0__dlyd_1
Xoutput946 _1407_/ZN tl_h_d_o[34] VDD VDD VSS VSS gf180mcu_fd_sc_mcu7t5v0__dlyd_1
Xoutput935 _1327_/ZN tl_h_d_o[24] VDD VDD VSS VSS gf180mcu_fd_sc_mcu7t5v0__dlyd_1
Xoutput924 _2172_/ZN tl_h_d_o[14] VDD VDD VSS VSS gf180mcu_fd_sc_mcu7t5v0__dlyd_1
Xoutput913 _2754_/Z tl_d_uart_o[95] VDD VDD VSS VSS gf180mcu_fd_sc_mcu7t5v0__dlyd_1
X_1655_ _1655_/A1 _1662_/S _1655_/ZN VDD VDD VSS VSS gf180mcu_fd_sc_mcu7t5v0__nor2_1
Xoutput957 _1487_/ZN tl_h_d_o[44] VDD VDD VSS VSS gf180mcu_fd_sc_mcu7t5v0__dlyd_1
Xoutput968 _2217_/ZN tl_h_d_o[54] VDD VDD VSS VSS gf180mcu_fd_sc_mcu7t5v0__dlyd_1
Xoutput979 _1246_/B tl_h_d_o[64] VDD VDD VSS VSS gf180mcu_fd_sc_mcu7t5v0__dlyd_1
X_1586_ _1582_/Z _1583_/Z _1585_/Z _1586_/Z VDD VDD VSS VSS gf180mcu_fd_sc_mcu7t5v0__xor3_1
XFILLER_98_431 VDD VDD VSS VSS gf180mcu_fd_sc_mcu7t5v0__fill_2
XFILLER_98_453 VDD VDD VSS VSS gf180mcu_fd_sc_mcu7t5v0__fill_2
XFILLER_98_442 VDD VDD VSS VSS gf180mcu_fd_sc_mcu7t5v0__fill_1
XFILLER_58_317 VDD VDD VSS VSS gf180mcu_fd_sc_mcu7t5v0__fillcap_4
XTAP_TAPCELL_ROW_111_1591 VDD VSS gf180mcu_fd_sc_mcu7t5v0__filltie
X_2207_ _2207_/A1 _2207_/A2 _2207_/B _2209_/C VDD VDD VSS VSS gf180mcu_fd_sc_mcu7t5v0__aoi21_1
XFILLER_26_203 VDD VDD VSS VSS gf180mcu_fd_sc_mcu7t5v0__fillcap_4
X_2138_ _2178_/C _2138_/A2 _2138_/B _2138_/ZN VDD VDD VSS VSS gf180mcu_fd_sc_mcu7t5v0__oai21_1
XFILLER_26_247 VDD VDD VSS VSS gf180mcu_fd_sc_mcu7t5v0__fill_2
X_2069_ input70/Z _2064_/B _2102_/B2 _2153_/A1 _2070_/I VDD VDD VSS VSS gf180mcu_fd_sc_mcu7t5v0__oai22_1
XFILLER_41_228 VDD VDD VSS VSS gf180mcu_fd_sc_mcu7t5v0__fill_2
XFILLER_10_637 VDD VDD VSS VSS gf180mcu_fd_sc_mcu7t5v0__fill_2
XFILLER_94_68 VDD VDD VSS VSS gf180mcu_fd_sc_mcu7t5v0__fill_2
XFILLER_92_629 VDD VDD VSS VSS gf180mcu_fd_sc_mcu7t5v0__fill_2
XFILLER_76_169 VDD VDD VSS VSS gf180mcu_fd_sc_mcu7t5v0__fillcap_4
XFILLER_17_236 VDD VDD VSS VSS gf180mcu_fd_sc_mcu7t5v0__fillcap_32
XFILLER_18_737 VDD VDD VSS VSS gf180mcu_fd_sc_mcu7t5v0__fillcap_32
XFILLER_91_139 VDD VDD VSS VSS gf180mcu_fd_sc_mcu7t5v0__fill_1
XTAP_TAPCELL_ROW_43_768 VDD VSS gf180mcu_fd_sc_mcu7t5v0__filltie
XTAP_TAPCELL_ROW_15_437 VDD VSS gf180mcu_fd_sc_mcu7t5v0__filltie
XFILLER_13_486 VDD VDD VSS VSS gf180mcu_fd_sc_mcu7t5v0__fillcap_4
XFILLER_40_283 VDD VDD VSS VSS gf180mcu_fd_sc_mcu7t5v0__fillcap_4
X_1440_ _1440_/A1 _1496_/A2 _2345_/A2 VDD VDD VSS VSS gf180mcu_fd_sc_mcu7t5v0__nand2_1
X_1371_ _1499_/A1 _1369_/Z _1371_/B _1372_/B1 VDD VDD VSS VSS gf180mcu_fd_sc_mcu7t5v0__oai21_1
Xxbar_tlul_2to4_1251 tl_d_esram_o[94] VDD VDD VSS VSS gf180mcu_fd_sc_mcu7t5v0__tiel
XFILLER_67_136 VDD VDD VSS VSS gf180mcu_fd_sc_mcu7t5v0__fillcap_4
Xxbar_tlul_2to4_1262 tl_d_esram_o[83] VDD VDD VSS VSS gf180mcu_fd_sc_mcu7t5v0__tiel
Xxbar_tlul_2to4_1273 tl_d_rom_o[87] VDD VDD VSS VSS gf180mcu_fd_sc_mcu7t5v0__tiel
Xinput280 tl_h_d_i[112] _2771_/I VDD VDD VSS VSS gf180mcu_fd_sc_mcu7t5v0__clkbuf_2
Xinput291 tl_h_d_i[1] _1856_/B2 VDD VDD VSS VSS gf180mcu_fd_sc_mcu7t5v0__dlyd_1
X_2756_ _2756_/I _2756_/Z VDD VDD VSS VSS gf180mcu_fd_sc_mcu7t5v0__buf_1
X_2687_ _2759_/I _2687_/Z VDD VDD VSS VSS gf180mcu_fd_sc_mcu7t5v0__buf_1
Xoutput721 _1855_/ZN tl_d_rom_o[112] VDD VDD VSS VSS gf180mcu_fd_sc_mcu7t5v0__dlyd_1
Xoutput710 _1835_/ZN tl_d_rom_o[102] VDD VDD VSS VSS gf180mcu_fd_sc_mcu7t5v0__dlyd_1
X_1707_ _1707_/I _1707_/ZN VDD VDD VSS VSS gf180mcu_fd_sc_mcu7t5v0__clkinv_1
Xoutput754 _1671_/ZN tl_d_rom_o[3] VDD VDD VSS VSS gf180mcu_fd_sc_mcu7t5v0__dlyd_1
Xoutput743 _1669_/ZN tl_d_rom_o[2] VDD VDD VSS VSS gf180mcu_fd_sc_mcu7t5v0__dlyd_1
Xoutput732 _1667_/ZN tl_d_rom_o[1] VDD VDD VSS VSS gf180mcu_fd_sc_mcu7t5v0__dlyd_1
X_1638_ _1948_/B2 _1641_/A2 _1638_/Z VDD VDD VSS VSS gf180mcu_fd_sc_mcu7t5v0__or2_1
Xoutput787 _1677_/ZN tl_d_rom_o[6] VDD VDD VSS VSS gf180mcu_fd_sc_mcu7t5v0__dlyd_1
Xoutput776 _1675_/ZN tl_d_rom_o[5] VDD VDD VSS VSS gf180mcu_fd_sc_mcu7t5v0__dlyd_1
Xoutput765 _1673_/ZN tl_d_rom_o[4] VDD VDD VSS VSS gf180mcu_fd_sc_mcu7t5v0__dlyd_1
XFILLER_58_103 VDD VDD VSS VSS gf180mcu_fd_sc_mcu7t5v0__fill_2
Xoutput798 _1679_/ZN tl_d_rom_o[7] VDD VDD VSS VSS gf180mcu_fd_sc_mcu7t5v0__dlyd_1
X_1569_ _2741_/I _2732_/I _1568_/Z _1569_/Z VDD VDD VSS VSS gf180mcu_fd_sc_mcu7t5v0__xor3_1
XFILLER_73_106 VDD VDD VSS VSS gf180mcu_fd_sc_mcu7t5v0__fillcap_32
XFILLER_27_556 VDD VDD VSS VSS gf180mcu_fd_sc_mcu7t5v0__fillcap_4
XFILLER_82_662 VDD VDD VSS VSS gf180mcu_fd_sc_mcu7t5v0__fill_2
XTAP_TAPCELL_ROW_64_1029 VDD VSS gf180mcu_fd_sc_mcu7t5v0__filltie
XFILLER_10_423 VDD VDD VSS VSS gf180mcu_fd_sc_mcu7t5v0__fillcap_32
XTAP_TAPCELL_ROW_40_738 VDD VSS gf180mcu_fd_sc_mcu7t5v0__filltie
XFILLER_108_333 VDD VDD VSS VSS gf180mcu_fd_sc_mcu7t5v0__fill_1
XTAP_TAPCELL_ROW_20_495 VDD VSS gf180mcu_fd_sc_mcu7t5v0__filltie
XTAP_TAPCELL_ROW_75_1158 VDD VSS gf180mcu_fd_sc_mcu7t5v0__filltie
XFILLER_8_2 VDD VDD VSS VSS gf180mcu_fd_sc_mcu7t5v0__fillcap_16
XFILLER_77_434 VDD VDD VSS VSS gf180mcu_fd_sc_mcu7t5v0__fillcap_8
XTAP_TAPCELL_ROW_48_827 VDD VSS gf180mcu_fd_sc_mcu7t5v0__filltie
XFILLER_92_415 VDD VDD VSS VSS gf180mcu_fd_sc_mcu7t5v0__fillcap_8
XFILLER_77_467 VDD VDD VSS VSS gf180mcu_fd_sc_mcu7t5v0__fill_1
XTAP_TAPCELL_ROW_48_838 VDD VSS gf180mcu_fd_sc_mcu7t5v0__filltie
XTAP_TAPCELL_ROW_86_1287 VDD VSS gf180mcu_fd_sc_mcu7t5v0__filltie
XFILLER_33_559 VDD VDD VSS VSS gf180mcu_fd_sc_mcu7t5v0__fill_1
XTAP_TAPCELL_ROW_28_595 VDD VSS gf180mcu_fd_sc_mcu7t5v0__filltie
XFILLER_9_298 VDD VDD VSS VSS gf180mcu_fd_sc_mcu7t5v0__fill_1
X_2541_ _2541_/D _2558_/RN clkload0/I _2541_/Q VDD VDD VSS VSS gf180mcu_fd_sc_mcu7t5v0__dffsnq_1
X_2472_ _2757_/I _2582_/Q _2478_/S _2582_/D VDD VDD VSS VSS gf180mcu_fd_sc_mcu7t5v0__mux2_2
X_1423_ _1503_/A1 _1423_/A2 _1423_/ZN VDD VDD VSS VSS gf180mcu_fd_sc_mcu7t5v0__nor2_1
XFILLER_87_209 VDD VDD VSS VSS gf180mcu_fd_sc_mcu7t5v0__fill_1
XFILLER_68_445 VDD VDD VSS VSS gf180mcu_fd_sc_mcu7t5v0__fillcap_8
X_1354_ input88/Z _1418_/A2 _2311_/A3 _1355_/B VDD VDD VSS VSS gf180mcu_fd_sc_mcu7t5v0__nand3_1
XFILLER_55_106 VDD VDD VSS VSS gf180mcu_fd_sc_mcu7t5v0__fillcap_32
XFILLER_68_489 VDD VDD VSS VSS gf180mcu_fd_sc_mcu7t5v0__fillcap_4
X_1285_ _1285_/I _1286_/B1 VDD VDD VSS VSS gf180mcu_fd_sc_mcu7t5v0__clkinv_1
XPHY_EDGE_ROW_50_Left_169 VDD VSS gf180mcu_fd_sc_mcu7t5v0__endcap
XFILLER_36_331 VDD VDD VSS VSS gf180mcu_fd_sc_mcu7t5v0__fillcap_32
XFILLER_37_865 VDD VDD VSS VSS gf180mcu_fd_sc_mcu7t5v0__fill_1
XFILLER_64_662 VDD VDD VSS VSS gf180mcu_fd_sc_mcu7t5v0__fill_2
XFILLER_24_504 VDD VDD VSS VSS gf180mcu_fd_sc_mcu7t5v0__fillcap_16
XFILLER_63_150 VDD VDD VSS VSS gf180mcu_fd_sc_mcu7t5v0__fill_1
XFILLER_64_684 VDD VDD VSS VSS gf180mcu_fd_sc_mcu7t5v0__fillcap_4
XFILLER_91_492 VDD VDD VSS VSS gf180mcu_fd_sc_mcu7t5v0__fill_2
X_2739_ _2739_/I _2739_/Z VDD VDD VSS VSS gf180mcu_fd_sc_mcu7t5v0__buf_1
Xoutput540 _1522_/Z tl_d_dmem_o[39] VDD VDD VSS VSS gf180mcu_fd_sc_mcu7t5v0__dlyd_1
Xoutput551 _1532_/Z tl_d_dmem_o[49] VDD VDD VSS VSS gf180mcu_fd_sc_mcu7t5v0__dlyd_1
Xoutput562 _1542_/Z tl_d_dmem_o[59] VDD VDD VSS VSS gf180mcu_fd_sc_mcu7t5v0__dlyd_1
Xoutput573 _2656_/Z tl_d_dmem_o[69] VDD VDD VSS VSS gf180mcu_fd_sc_mcu7t5v0__dlyd_1
Xoutput584 _2666_/Z tl_d_dmem_o[79] VDD VDD VSS VSS gf180mcu_fd_sc_mcu7t5v0__dlyd_1
Xoutput595 _2676_/Z tl_d_dmem_o[89] VDD VDD VSS VSS gf180mcu_fd_sc_mcu7t5v0__dlyd_1
XFILLER_99_570 VDD VDD VSS VSS gf180mcu_fd_sc_mcu7t5v0__fill_2
XFILLER_87_754 VDD VDD VSS VSS gf180mcu_fd_sc_mcu7t5v0__fill_2
XFILLER_47_629 VDD VDD VSS VSS gf180mcu_fd_sc_mcu7t5v0__fill_1
XTAP_TAPCELL_ROW_70_1099 VDD VSS gf180mcu_fd_sc_mcu7t5v0__filltie
XFILLER_43_846 VDD VDD VSS VSS gf180mcu_fd_sc_mcu7t5v0__fill_1
XFILLER_91_58 VDD VDD VSS VSS gf180mcu_fd_sc_mcu7t5v0__fillcap_4
XFILLER_30_507 VDD VDD VSS VSS gf180mcu_fd_sc_mcu7t5v0__fillcap_4
XTAP_TAPCELL_ROW_25_554 VDD VSS gf180mcu_fd_sc_mcu7t5v0__filltie
XTAP_TAPCELL_ROW_53_896 VDD VSS gf180mcu_fd_sc_mcu7t5v0__filltie
XFILLER_10_297 VDD VDD VSS VSS gf180mcu_fd_sc_mcu7t5v0__fillcap_8
XFILLER_77_220 VDD VDD VSS VSS gf180mcu_fd_sc_mcu7t5v0__fillcap_4
XTAP_TAPCELL_ROW_88_1316 VDD VSS gf180mcu_fd_sc_mcu7t5v0__filltie
XFILLER_93_735 VDD VDD VSS VSS gf180mcu_fd_sc_mcu7t5v0__fill_1
X_1070_ _1070_/I _1204_/A1 VDD VDD VSS VSS gf180mcu_fd_sc_mcu7t5v0__clkinv_1
XFILLER_92_234 VDD VDD VSS VSS gf180mcu_fd_sc_mcu7t5v0__fill_2
XFILLER_33_301 VDD VDD VSS VSS gf180mcu_fd_sc_mcu7t5v0__fill_2
XFILLER_33_312 VDD VDD VSS VSS gf180mcu_fd_sc_mcu7t5v0__fillcap_32
XFILLER_45_150 VDD VDD VSS VSS gf180mcu_fd_sc_mcu7t5v0__fillcap_32
XFILLER_61_632 VDD VDD VSS VSS gf180mcu_fd_sc_mcu7t5v0__fillcap_64
XFILLER_73_492 VDD VDD VSS VSS gf180mcu_fd_sc_mcu7t5v0__fillcap_32
X_1972_ _1972_/A1 _1982_/A2 _1998_/B1 _1972_/B2 _1973_/I VDD VDD VSS VSS gf180mcu_fd_sc_mcu7t5v0__aoi22_1
XTAP_TAPCELL_ROW_99_1445 VDD VSS gf180mcu_fd_sc_mcu7t5v0__filltie
XPHY_EDGE_ROW_112_Right_112 VDD VSS gf180mcu_fd_sc_mcu7t5v0__endcap
XPHY_EDGE_ROW_49_Right_49 VDD VSS gf180mcu_fd_sc_mcu7t5v0__endcap
X_2524_ _2596_/Q _2507_/B _2525_/B VDD VDD VSS VSS gf180mcu_fd_sc_mcu7t5v0__nand2_1
XFILLER_102_317 VDD VDD VSS VSS gf180mcu_fd_sc_mcu7t5v0__fill_1
X_2455_ _2569_/Q _2517_/B _2456_/B VDD VDD VSS VSS gf180mcu_fd_sc_mcu7t5v0__nand2_1
X_2386_ _2386_/I0 _2542_/Q _2402_/S _2542_/D VDD VDD VSS VSS gf180mcu_fd_sc_mcu7t5v0__mux2_2
X_1406_ _1406_/A1 _1406_/A2 _1406_/B1 _2160_/C _1407_/A2 VDD VDD VSS VSS gf180mcu_fd_sc_mcu7t5v0__aoi22_1
X_1337_ _1393_/A1 _2293_/A2 _1337_/Z VDD VDD VSS VSS gf180mcu_fd_sc_mcu7t5v0__and2_1
XFILLER_96_551 VDD VDD VSS VSS gf180mcu_fd_sc_mcu7t5v0__fill_1
XFILLER_83_212 VDD VDD VSS VSS gf180mcu_fd_sc_mcu7t5v0__fill_2
X_1268_ input10/Z _1348_/A2 _1268_/B1 _2155_/B1 _1269_/I VDD VDD VSS VSS gf180mcu_fd_sc_mcu7t5v0__aoi22_1
XPHY_EDGE_ROW_58_Right_58 VDD VSS gf180mcu_fd_sc_mcu7t5v0__endcap
X_1199_ _1200_/C _1200_/A1 _1200_/B _1207_/A2 VDD VDD VSS VSS gf180mcu_fd_sc_mcu7t5v0__nor3_1
XTAP_TAPCELL_ROW_108_1552 VDD VSS gf180mcu_fd_sc_mcu7t5v0__filltie
XFILLER_36_172 VDD VDD VSS VSS gf180mcu_fd_sc_mcu7t5v0__fill_2
XFILLER_52_621 VDD VDD VSS VSS gf180mcu_fd_sc_mcu7t5v0__fillcap_4
XTAP_TAPCELL_ROW_22_524 VDD VSS gf180mcu_fd_sc_mcu7t5v0__filltie
XTAP_TAPCELL_ROW_50_855 VDD VSS gf180mcu_fd_sc_mcu7t5v0__filltie
XPHY_EDGE_ROW_67_Right_67 VDD VSS gf180mcu_fd_sc_mcu7t5v0__endcap
XFILLER_10_10 VDD VDD VSS VSS gf180mcu_fd_sc_mcu7t5v0__fillcap_4
XTAP_TAPCELL_ROW_72_1117 VDD VSS gf180mcu_fd_sc_mcu7t5v0__filltie
XFILLER_87_562 VDD VDD VSS VSS gf180mcu_fd_sc_mcu7t5v0__fillcap_16
XFILLER_75_702 VDD VDD VSS VSS gf180mcu_fd_sc_mcu7t5v0__fillcap_64
XFILLER_47_437 VDD VDD VSS VSS gf180mcu_fd_sc_mcu7t5v0__fillcap_32
Xwire1145 _2116_/ZN _2118_/A1 VDD VDD VSS VSS gf180mcu_fd_sc_mcu7t5v0__buf_2
XPHY_EDGE_ROW_76_Right_76 VDD VSS gf180mcu_fd_sc_mcu7t5v0__endcap
XFILLER_87_584 VDD VDD VSS VSS gf180mcu_fd_sc_mcu7t5v0__fill_1
Xwire1167 _1489_/A1 _1393_/A1 VDD VDD VSS VSS gf180mcu_fd_sc_mcu7t5v0__clkbuf_4
XTAP_TAPCELL_ROW_58_955 VDD VSS gf180mcu_fd_sc_mcu7t5v0__filltie
XTAP_TAPCELL_ROW_2_282 VDD VSS gf180mcu_fd_sc_mcu7t5v0__filltie
XFILLER_43_632 VDD VDD VSS VSS gf180mcu_fd_sc_mcu7t5v0__fillcap_64
XPHY_EDGE_ROW_106_Left_225 VDD VSS gf180mcu_fd_sc_mcu7t5v0__endcap
XTAP_TAPCELL_ROW_83_1257 VDD VSS gf180mcu_fd_sc_mcu7t5v0__filltie
XFILLER_70_451 VDD VDD VSS VSS gf180mcu_fd_sc_mcu7t5v0__fillcap_4
XFILLER_11_562 VDD VDD VSS VSS gf180mcu_fd_sc_mcu7t5v0__fillcap_64
XPHY_EDGE_ROW_85_Right_85 VDD VSS gf180mcu_fd_sc_mcu7t5v0__endcap
XPHY_EDGE_ROW_115_Left_234 VDD VSS gf180mcu_fd_sc_mcu7t5v0__endcap
XTAP_TAPCELL_ROW_94_1386 VDD VSS gf180mcu_fd_sc_mcu7t5v0__filltie
X_2240_ _2178_/C _2240_/A2 _2240_/B _2240_/ZN VDD VDD VSS VSS gf180mcu_fd_sc_mcu7t5v0__oai21_1
XPHY_EDGE_ROW_94_Right_94 VDD VSS gf180mcu_fd_sc_mcu7t5v0__endcap
XFILLER_78_551 VDD VDD VSS VSS gf180mcu_fd_sc_mcu7t5v0__fill_2
XFILLER_65_212 VDD VDD VSS VSS gf180mcu_fd_sc_mcu7t5v0__fillcap_4
X_2171_ input7/Z _2236_/A2 _2171_/B _2172_/B2 VDD VDD VSS VSS gf180mcu_fd_sc_mcu7t5v0__aoi21_1
X_1122_ _2546_/Q _2545_/Q _1123_/A2 VDD VDD VSS VSS gf180mcu_fd_sc_mcu7t5v0__nor2_1
XFILLER_33_142 VDD VDD VSS VSS gf180mcu_fd_sc_mcu7t5v0__fill_1
XFILLER_61_484 VDD VDD VSS VSS gf180mcu_fd_sc_mcu7t5v0__fillcap_4
X_1955_ _1955_/I _1955_/ZN VDD VDD VSS VSS gf180mcu_fd_sc_mcu7t5v0__clkinv_1
XTAP_TAPCELL_ROW_103_1493 VDD VSS gf180mcu_fd_sc_mcu7t5v0__filltie
X_1886_ _2386_/I0 _1912_/A2 _1926_/B1 _1886_/B2 _1887_/I VDD VDD VSS VSS gf180mcu_fd_sc_mcu7t5v0__aoi22_1
X_2507_ _2502_/Z _2507_/A2 _2507_/B _2508_/B2 VDD VDD VSS VSS gf180mcu_fd_sc_mcu7t5v0__aoi21_1
Xoutput1020 _2356_/ZN tl_h_i_o[41] VDD VDD VSS VSS gf180mcu_fd_sc_mcu7t5v0__dlyd_1
Xoutput1031 _2090_/ZN tl_h_i_o[51] VDD VDD VSS VSS gf180mcu_fd_sc_mcu7t5v0__dlyd_1
Xoutput1042 _2111_/ZN tl_h_i_o[61] VDD VDD VSS VSS gf180mcu_fd_sc_mcu7t5v0__dlyd_1
Xinput109 tl_d_esram_i[47] _2379_/A1 VDD VDD VSS VSS gf180mcu_fd_sc_mcu7t5v0__dlyd_1
XFILLER_88_337 VDD VDD VSS VSS gf180mcu_fd_sc_mcu7t5v0__fill_2
XFILLER_57_702 VDD VDD VSS VSS gf180mcu_fd_sc_mcu7t5v0__fillcap_64
X_2438_ _2565_/Q _2775_/I _2441_/B VDD VDD VSS VSS gf180mcu_fd_sc_mcu7t5v0__xor2_1
XFILLER_69_562 VDD VDD VSS VSS gf180mcu_fd_sc_mcu7t5v0__fillcap_16
X_2369_ _2369_/A1 _2369_/A2 _2370_/A2 VDD VDD VSS VSS gf180mcu_fd_sc_mcu7t5v0__nand2_1
XFILLER_96_381 VDD VDD VSS VSS gf180mcu_fd_sc_mcu7t5v0__fillcap_4
XFILLER_44_429 VDD VDD VSS VSS gf180mcu_fd_sc_mcu7t5v0__fillcap_16
XTAP_TAPCELL_ROW_55_914 VDD VSS gf180mcu_fd_sc_mcu7t5v0__filltie
XFILLER_25_632 VDD VDD VSS VSS gf180mcu_fd_sc_mcu7t5v0__fillcap_64
XFILLER_37_492 VDD VDD VSS VSS gf180mcu_fd_sc_mcu7t5v0__fillcap_32
XTAP_TAPCELL_ROW_69_1090 VDD VSS gf180mcu_fd_sc_mcu7t5v0__filltie
XFILLER_12_304 VDD VDD VSS VSS gf180mcu_fd_sc_mcu7t5v0__fillcap_4
XTAP_TAPCELL_ROW_35_682 VDD VSS gf180mcu_fd_sc_mcu7t5v0__filltie
XTAP_TAPCELL_ROW_35_671 VDD VSS gf180mcu_fd_sc_mcu7t5v0__filltie
XFILLER_106_497 VDD VDD VSS VSS gf180mcu_fd_sc_mcu7t5v0__fill_1
XTAP_TAPCELL_ROW_7_341 VDD VSS gf180mcu_fd_sc_mcu7t5v0__filltie
XFILLER_47_212 VDD VDD VSS VSS gf180mcu_fd_sc_mcu7t5v0__fillcap_64
XFILLER_63_716 VDD VDD VSS VSS gf180mcu_fd_sc_mcu7t5v0__fillcap_32
XFILLER_90_513 VDD VDD VSS VSS gf180mcu_fd_sc_mcu7t5v0__fillcap_8
XFILLER_90_535 VDD VDD VSS VSS gf180mcu_fd_sc_mcu7t5v0__fillcap_4
XFILLER_90_579 VDD VDD VSS VSS gf180mcu_fd_sc_mcu7t5v0__fillcap_16
XFILLER_43_473 VDD VDD VSS VSS gf180mcu_fd_sc_mcu7t5v0__fillcap_16
XFILLER_62_71 VDD VDD VSS VSS gf180mcu_fd_sc_mcu7t5v0__fillcap_32
XFILLER_30_167 VDD VDD VSS VSS gf180mcu_fd_sc_mcu7t5v0__fillcap_8
XFILLER_8_831 VDD VDD VSS VSS gf180mcu_fd_sc_mcu7t5v0__fill_1
X_1740_ _1930_/A1 _1772_/A2 _1772_/B1 _1930_/B2 _1741_/I VDD VDD VSS VSS gf180mcu_fd_sc_mcu7t5v0__aoi22_1
XTAP_TAPCELL_ROW_96_1404 VDD VSS gf180mcu_fd_sc_mcu7t5v0__filltie
X_1671_ _1671_/I _1671_/ZN VDD VDD VSS VSS gf180mcu_fd_sc_mcu7t5v0__clkinv_1
XFILLER_98_602 VDD VDD VSS VSS gf180mcu_fd_sc_mcu7t5v0__fill_2
XFILLER_39_702 VDD VDD VSS VSS gf180mcu_fd_sc_mcu7t5v0__fillcap_64
X_2223_ _2223_/A1 _2224_/C _2223_/B1 _2223_/B2 _2223_/ZN VDD VDD VSS VSS gf180mcu_fd_sc_mcu7t5v0__aoi22_1
X_2154_ input4/Z _2154_/A2 _2155_/C VDD VDD VSS VSS gf180mcu_fd_sc_mcu7t5v0__nor2_1
X_1105_ _2569_/Q _1106_/A2 _1105_/Z VDD VDD VSS VSS gf180mcu_fd_sc_mcu7t5v0__and2_1
XFILLER_19_492 VDD VDD VSS VSS gf180mcu_fd_sc_mcu7t5v0__fillcap_64
X_2085_ _2187_/A1 _2377_/A1 _2087_/A1 VDD VDD VSS VSS gf180mcu_fd_sc_mcu7t5v0__nand2_1
XTAP_TAPCELL_ROW_105_1522 VDD VSS gf180mcu_fd_sc_mcu7t5v0__filltie
XTAP_TAPCELL_ROW_105_1511 VDD VSS gf180mcu_fd_sc_mcu7t5v0__filltie
XFILLER_81_557 VDD VDD VSS VSS gf180mcu_fd_sc_mcu7t5v0__fill_2
XFILLER_34_451 VDD VDD VSS VSS gf180mcu_fd_sc_mcu7t5v0__fillcap_4
XFILLER_34_473 VDD VDD VSS VSS gf180mcu_fd_sc_mcu7t5v0__fillcap_8
XTAP_TAPCELL_ROW_32_641 VDD VSS gf180mcu_fd_sc_mcu7t5v0__filltie
XTAP_TAPCELL_ROW_60_972 VDD VSS gf180mcu_fd_sc_mcu7t5v0__filltie
X_1938_ _1938_/A1 _1938_/A2 _1958_/B1 _1938_/B2 _1939_/I VDD VDD VSS VSS gf180mcu_fd_sc_mcu7t5v0__aoi22_1
X_1869_ _1869_/I _1869_/ZN VDD VDD VSS VSS gf180mcu_fd_sc_mcu7t5v0__clkinv_1
Xinput80 tl_d_esram_i[20] input80/Z VDD VDD VSS VSS gf180mcu_fd_sc_mcu7t5v0__dlyd_1
Xinput91 tl_d_esram_i[30] input91/Z VDD VDD VSS VSS gf180mcu_fd_sc_mcu7t5v0__dlyd_1
XTAP_TAPCELL_ROW_116_1651 VDD VSS gf180mcu_fd_sc_mcu7t5v0__filltie
XFILLER_107_67 VDD VDD VSS VSS gf180mcu_fd_sc_mcu7t5v0__fill_1
XTAP_TAPCELL_ROW_4_300 VDD VSS gf180mcu_fd_sc_mcu7t5v0__filltie
XFILLER_29_212 VDD VDD VSS VSS gf180mcu_fd_sc_mcu7t5v0__fillcap_8
XFILLER_85_852 VDD VDD VSS VSS gf180mcu_fd_sc_mcu7t5v0__fillcap_8
XFILLER_84_351 VDD VDD VSS VSS gf180mcu_fd_sc_mcu7t5v0__fillcap_8
XFILLER_72_513 VDD VDD VSS VSS gf180mcu_fd_sc_mcu7t5v0__fillcap_8
XFILLER_84_384 VDD VDD VSS VSS gf180mcu_fd_sc_mcu7t5v0__fill_1
XTAP_TAPCELL_ROW_80_1216 VDD VSS gf180mcu_fd_sc_mcu7t5v0__filltie
XFILLER_40_421 VDD VDD VSS VSS gf180mcu_fd_sc_mcu7t5v0__fill_1
XFILLER_32_41 VDD VDD VSS VSS gf180mcu_fd_sc_mcu7t5v0__fill_2
XTAP_TAPCELL_ROW_10_379 VDD VSS gf180mcu_fd_sc_mcu7t5v0__filltie
XTAP_TAPCELL_ROW_78_1189 VDD VSS gf180mcu_fd_sc_mcu7t5v0__filltie
XTAP_TAPCELL_ROW_91_1345 VDD VSS gf180mcu_fd_sc_mcu7t5v0__filltie
XFILLER_67_329 VDD VDD VSS VSS gf180mcu_fd_sc_mcu7t5v0__fillcap_4
XFILLER_48_543 VDD VDD VSS VSS gf180mcu_fd_sc_mcu7t5v0__fillcap_4
Xinput440 tl_h_i_i[51] _1956_/A1 VDD VDD VSS VSS gf180mcu_fd_sc_mcu7t5v0__dlyd_1
Xinput451 tl_h_i_i[61] _1976_/A1 VDD VDD VSS VSS gf180mcu_fd_sc_mcu7t5v0__dlyd_1
Xinput462 tl_h_i_i[71] _1996_/A1 VDD VDD VSS VSS gf180mcu_fd_sc_mcu7t5v0__dlyd_1
Xinput473 tl_h_i_i[81] _1058_/I VDD VDD VSS VSS gf180mcu_fd_sc_mcu7t5v0__dlyd_1
Xinput484 tl_h_i_i[91] _1162_/A2 VDD VDD VSS VSS gf180mcu_fd_sc_mcu7t5v0__dlyd_1
XFILLER_16_451 VDD VDD VSS VSS gf180mcu_fd_sc_mcu7t5v0__fillcap_4
XFILLER_63_568 VDD VDD VSS VSS gf180mcu_fd_sc_mcu7t5v0__fill_1
XTAP_TAPCELL_ROW_18_468 VDD VSS gf180mcu_fd_sc_mcu7t5v0__filltie
XFILLER_90_387 VDD VDD VSS VSS gf180mcu_fd_sc_mcu7t5v0__fillcap_16
XFILLER_31_487 VDD VDD VSS VSS gf180mcu_fd_sc_mcu7t5v0__fill_2
XTAP_TAPCELL_ROW_100_1452 VDD VSS gf180mcu_fd_sc_mcu7t5v0__filltie
X_2772_ _2772_/I _2772_/Z VDD VDD VSS VSS gf180mcu_fd_sc_mcu7t5v0__buf_1
X_1723_ _1723_/I _1723_/ZN VDD VDD VSS VSS gf180mcu_fd_sc_mcu7t5v0__clkinv_1
Xoutput903 _2745_/Z tl_d_uart_o[86] VDD VDD VSS VSS gf180mcu_fd_sc_mcu7t5v0__dlyd_1
Xoutput936 _1335_/ZN tl_h_d_o[25] VDD VDD VSS VSS gf180mcu_fd_sc_mcu7t5v0__dlyd_1
Xoutput925 _2176_/ZN tl_h_d_o[15] VDD VDD VSS VSS gf180mcu_fd_sc_mcu7t5v0__dlyd_1
Xoutput914 _2755_/Z tl_d_uart_o[96] VDD VDD VSS VSS gf180mcu_fd_sc_mcu7t5v0__dlyd_1
X_1654_ _1860_/B2 _1664_/S _1654_/Z VDD VDD VSS VSS gf180mcu_fd_sc_mcu7t5v0__or2_1
Xoutput958 _1495_/ZN tl_h_d_o[45] VDD VDD VSS VSS gf180mcu_fd_sc_mcu7t5v0__dlyd_1
Xoutput969 _2223_/ZN tl_h_d_o[55] VDD VDD VSS VSS gf180mcu_fd_sc_mcu7t5v0__dlyd_1
Xoutput947 _1415_/ZN tl_h_d_o[35] VDD VDD VSS VSS gf180mcu_fd_sc_mcu7t5v0__dlyd_1
X_1585_ _1551_/Z _1561_/Z _1584_/Z _1585_/Z VDD VDD VSS VSS gf180mcu_fd_sc_mcu7t5v0__xor3_1
X_2206_ _2585_/Q _2140_/B _2207_/A2 VDD VDD VSS VSS gf180mcu_fd_sc_mcu7t5v0__nand2_1
XTAP_TAPCELL_ROW_111_1592 VDD VSS gf180mcu_fd_sc_mcu7t5v0__filltie
XTAP_TAPCELL_ROW_37_700 VDD VSS gf180mcu_fd_sc_mcu7t5v0__filltie
XFILLER_66_384 VDD VDD VSS VSS gf180mcu_fd_sc_mcu7t5v0__fill_1
X_2137_ _2137_/A1 _2172_/A2 _2236_/A2 input66/Z _2138_/B VDD VDD VSS VSS gf180mcu_fd_sc_mcu7t5v0__aoi22_1
XFILLER_26_259 VDD VDD VSS VSS gf180mcu_fd_sc_mcu7t5v0__fillcap_8
X_2068_ _2068_/A1 _2291_/A2 _2064_/C _2068_/B2 _2068_/ZN VDD VDD VSS VSS gf180mcu_fd_sc_mcu7t5v0__aoi22_1
XFILLER_41_207 VDD VDD VSS VSS gf180mcu_fd_sc_mcu7t5v0__fill_2
XFILLER_22_421 VDD VDD VSS VSS gf180mcu_fd_sc_mcu7t5v0__fillcap_16
XFILLER_89_487 VDD VDD VSS VSS gf180mcu_fd_sc_mcu7t5v0__fill_2
XFILLER_76_137 VDD VDD VSS VSS gf180mcu_fd_sc_mcu7t5v0__fillcap_32
XFILLER_45_524 VDD VDD VSS VSS gf180mcu_fd_sc_mcu7t5v0__fillcap_16
XFILLER_84_181 VDD VDD VSS VSS gf180mcu_fd_sc_mcu7t5v0__fill_1
XFILLER_45_557 VDD VDD VSS VSS gf180mcu_fd_sc_mcu7t5v0__fill_2
XFILLER_60_505 VDD VDD VSS VSS gf180mcu_fd_sc_mcu7t5v0__fillcap_8
XFILLER_60_527 VDD VDD VSS VSS gf180mcu_fd_sc_mcu7t5v0__fillcap_64
XTAP_TAPCELL_ROW_43_769 VDD VSS gf180mcu_fd_sc_mcu7t5v0__filltie
XTAP_TAPCELL_ROW_15_438 VDD VSS gf180mcu_fd_sc_mcu7t5v0__filltie
XFILLER_4_34 VDD VDD VSS VSS gf180mcu_fd_sc_mcu7t5v0__fill_1
X_1370_ input91/Z _2158_/A2 _2379_/A3 _1371_/B VDD VDD VSS VSS gf180mcu_fd_sc_mcu7t5v0__nand3_1
Xxbar_tlul_2to4_1252 tl_d_esram_o[93] VDD VDD VSS VSS gf180mcu_fd_sc_mcu7t5v0__tiel
Xxbar_tlul_2to4_1263 tl_d_esram_o[82] VDD VDD VSS VSS gf180mcu_fd_sc_mcu7t5v0__tiel
Xxbar_tlul_2to4_1274 tl_d_rom_o[86] VDD VDD VSS VSS gf180mcu_fd_sc_mcu7t5v0__tiel
Xinput270 tl_h_d_i[103] _2762_/I VDD VDD VSS VSS gf180mcu_fd_sc_mcu7t5v0__dlyd_1
Xinput281 tl_h_d_i[113] _1076_/I VDD VDD VSS VSS gf180mcu_fd_sc_mcu7t5v0__dlyd_1
XFILLER_48_373 VDD VDD VSS VSS gf180mcu_fd_sc_mcu7t5v0__fillcap_4
Xinput292 tl_h_d_i[20] _2711_/I VDD VDD VSS VSS gf180mcu_fd_sc_mcu7t5v0__clkbuf_2
XFILLER_76_693 VDD VDD VSS VSS gf180mcu_fd_sc_mcu7t5v0__fill_1
XFILLER_23_218 VDD VDD VSS VSS gf180mcu_fd_sc_mcu7t5v0__fillcap_8
XFILLER_31_273 VDD VDD VSS VSS gf180mcu_fd_sc_mcu7t5v0__fillcap_4
X_2755_ _2755_/I _2755_/Z VDD VDD VSS VSS gf180mcu_fd_sc_mcu7t5v0__buf_1
X_2686_ _2758_/I _2686_/Z VDD VDD VSS VSS gf180mcu_fd_sc_mcu7t5v0__buf_1
Xoutput711 _1837_/ZN tl_d_rom_o[103] VDD VDD VSS VSS gf180mcu_fd_sc_mcu7t5v0__dlyd_1
Xoutput700 _2015_/ZN tl_d_esram_o[80] VDD VDD VSS VSS gf180mcu_fd_sc_mcu7t5v0__dlyd_1
X_1706_ _1896_/A1 _1732_/A2 _1722_/B1 _2712_/I _1707_/I VDD VDD VSS VSS gf180mcu_fd_sc_mcu7t5v0__aoi22_1
Xoutput744 _1725_/ZN tl_d_rom_o[30] VDD VDD VSS VSS gf180mcu_fd_sc_mcu7t5v0__dlyd_1
Xoutput733 _1705_/ZN tl_d_rom_o[20] VDD VDD VSS VSS gf180mcu_fd_sc_mcu7t5v0__dlyd_1
Xoutput722 _2704_/Z tl_d_rom_o[113] VDD VDD VSS VSS gf180mcu_fd_sc_mcu7t5v0__dlyd_1
X_1637_ _1946_/B2 _1641_/A2 _1637_/Z VDD VDD VSS VSS gf180mcu_fd_sc_mcu7t5v0__or2_1
XTAP_TAPCELL_ROW_113_1610 VDD VSS gf180mcu_fd_sc_mcu7t5v0__filltie
Xoutput788 _1805_/ZN tl_d_rom_o[70] VDD VDD VSS VSS gf180mcu_fd_sc_mcu7t5v0__dlyd_1
Xoutput777 _1785_/ZN tl_d_rom_o[60] VDD VDD VSS VSS gf180mcu_fd_sc_mcu7t5v0__dlyd_1
Xoutput766 _1765_/ZN tl_d_rom_o[50] VDD VDD VSS VSS gf180mcu_fd_sc_mcu7t5v0__dlyd_1
Xoutput755 _1745_/ZN tl_d_rom_o[40] VDD VDD VSS VSS gf180mcu_fd_sc_mcu7t5v0__dlyd_1
XFILLER_48_29 VDD VDD VSS VSS gf180mcu_fd_sc_mcu7t5v0__fillcap_4
XFILLER_59_627 VDD VDD VSS VSS gf180mcu_fd_sc_mcu7t5v0__fill_2
Xoutput799 _1825_/ZN tl_d_rom_o[80] VDD VDD VSS VSS gf180mcu_fd_sc_mcu7t5v0__dlyd_1
X_1568_ _2737_/I _2739_/I _1568_/Z VDD VDD VSS VSS gf180mcu_fd_sc_mcu7t5v0__xor2_1
X_1499_ _1499_/A1 _1497_/Z _1499_/B _1500_/B1 VDD VDD VSS VSS gf180mcu_fd_sc_mcu7t5v0__oai21_1
XFILLER_86_457 VDD VDD VSS VSS gf180mcu_fd_sc_mcu7t5v0__fillcap_64
XFILLER_82_630 VDD VDD VSS VSS gf180mcu_fd_sc_mcu7t5v0__fillcap_32
XFILLER_42_527 VDD VDD VSS VSS gf180mcu_fd_sc_mcu7t5v0__fill_2
XTAP_TAPCELL_ROW_64_1019 VDD VSS gf180mcu_fd_sc_mcu7t5v0__filltie
XTAP_TAPCELL_ROW_40_739 VDD VSS gf180mcu_fd_sc_mcu7t5v0__filltie
XFILLER_10_457 VDD VDD VSS VSS gf180mcu_fd_sc_mcu7t5v0__fillcap_64
XTAP_TAPCELL_ROW_20_496 VDD VSS gf180mcu_fd_sc_mcu7t5v0__filltie
XTAP_TAPCELL_ROW_75_1159 VDD VSS gf180mcu_fd_sc_mcu7t5v0__filltie
XFILLER_49_115 VDD VDD VSS VSS gf180mcu_fd_sc_mcu7t5v0__fillcap_16
XFILLER_77_446 VDD VDD VSS VSS gf180mcu_fd_sc_mcu7t5v0__fill_2
XFILLER_77_424 VDD VDD VSS VSS gf180mcu_fd_sc_mcu7t5v0__fill_1
XFILLER_64_107 VDD VDD VSS VSS gf180mcu_fd_sc_mcu7t5v0__fillcap_16
XFILLER_64_129 VDD VDD VSS VSS gf180mcu_fd_sc_mcu7t5v0__fill_1
XTAP_TAPCELL_ROW_48_828 VDD VSS gf180mcu_fd_sc_mcu7t5v0__filltie
XTAP_TAPCELL_ROW_86_1288 VDD VSS gf180mcu_fd_sc_mcu7t5v0__filltie
XFILLER_73_696 VDD VDD VSS VSS gf180mcu_fd_sc_mcu7t5v0__fillcap_4
XFILLER_72_173 VDD VDD VSS VSS gf180mcu_fd_sc_mcu7t5v0__fill_2
XTAP_TAPCELL_ROW_28_596 VDD VSS gf180mcu_fd_sc_mcu7t5v0__filltie
XFILLER_13_262 VDD VDD VSS VSS gf180mcu_fd_sc_mcu7t5v0__fillcap_8
X_2540_ _2540_/D _2550_/RN clkload0/I _2540_/Q VDD VDD VSS VSS gf180mcu_fd_sc_mcu7t5v0__dffrnq_1
X_2471_ _2756_/I _2581_/Q _2471_/S _2581_/D VDD VDD VSS VSS gf180mcu_fd_sc_mcu7t5v0__mux2_2
X_1422_ _1422_/A1 _1510_/A2 _1422_/B1 _2160_/C _1423_/A2 VDD VDD VSS VSS gf180mcu_fd_sc_mcu7t5v0__aoi22_1
Xclkbuf_0_clk_i clk_i clkbuf_0_clk_i/Z VDD VDD VSS VSS gf180mcu_fd_sc_mcu7t5v0__clkbuf_16
X_1353_ _1393_/A1 _2301_/A2 _1353_/Z VDD VDD VSS VSS gf180mcu_fd_sc_mcu7t5v0__and2_1
XFILLER_56_619 VDD VDD VSS VSS gf180mcu_fd_sc_mcu7t5v0__fill_1
XFILLER_68_457 VDD VDD VSS VSS gf180mcu_fd_sc_mcu7t5v0__fillcap_32
X_1284_ input12/Z _1348_/A2 _1284_/B1 _2155_/B1 _1285_/I VDD VDD VSS VSS gf180mcu_fd_sc_mcu7t5v0__aoi22_1
XFILLER_37_855 VDD VDD VSS VSS gf180mcu_fd_sc_mcu7t5v0__fillcap_8
XFILLER_24_527 VDD VDD VSS VSS gf180mcu_fd_sc_mcu7t5v0__fillcap_64
XFILLER_36_387 VDD VDD VSS VSS gf180mcu_fd_sc_mcu7t5v0__fillcap_64
XFILLER_51_346 VDD VDD VSS VSS gf180mcu_fd_sc_mcu7t5v0__fillcap_4
XFILLER_32_582 VDD VDD VSS VSS gf180mcu_fd_sc_mcu7t5v0__fillcap_8
XFILLER_118_643 VDD VDD VSS VSS gf180mcu_fd_sc_mcu7t5v0__fill_2
X_2738_ _2738_/I _2738_/Z VDD VDD VSS VSS gf180mcu_fd_sc_mcu7t5v0__buf_1
X_2669_ _2741_/I _2669_/Z VDD VDD VSS VSS gf180mcu_fd_sc_mcu7t5v0__buf_1
Xoutput530 _1545_/ZN tl_d_dmem_o[2] VDD VDD VSS VSS gf180mcu_fd_sc_mcu7t5v0__dlyd_1
Xoutput541 _1546_/Z tl_d_dmem_o[3] VDD VDD VSS VSS gf180mcu_fd_sc_mcu7t5v0__dlyd_1
Xoutput552 _1547_/ZN tl_d_dmem_o[4] VDD VDD VSS VSS gf180mcu_fd_sc_mcu7t5v0__dlyd_1
Xoutput563 _1548_/Z tl_d_dmem_o[5] VDD VDD VSS VSS gf180mcu_fd_sc_mcu7t5v0__dlyd_1
Xoutput574 _1549_/ZN tl_d_dmem_o[6] VDD VDD VSS VSS gf180mcu_fd_sc_mcu7t5v0__dlyd_1
Xoutput585 _1550_/Z tl_d_dmem_o[7] VDD VDD VSS VSS gf180mcu_fd_sc_mcu7t5v0__dlyd_1
Xoutput596 _1565_/Z tl_d_dmem_o[8] VDD VDD VSS VSS gf180mcu_fd_sc_mcu7t5v0__dlyd_1
XFILLER_101_543 VDD VDD VSS VSS gf180mcu_fd_sc_mcu7t5v0__fill_1
XFILLER_27_321 VDD VDD VSS VSS gf180mcu_fd_sc_mcu7t5v0__fillcap_16
XFILLER_54_151 VDD VDD VSS VSS gf180mcu_fd_sc_mcu7t5v0__fillcap_16
XFILLER_55_696 VDD VDD VSS VSS gf180mcu_fd_sc_mcu7t5v0__fillcap_4
XTAP_TAPCELL_ROW_25_555 VDD VSS gf180mcu_fd_sc_mcu7t5v0__filltie
XFILLER_70_677 VDD VDD VSS VSS gf180mcu_fd_sc_mcu7t5v0__fill_1
XTAP_TAPCELL_ROW_53_897 VDD VSS gf180mcu_fd_sc_mcu7t5v0__filltie
XFILLER_104_370 VDD VDD VSS VSS gf180mcu_fd_sc_mcu7t5v0__fill_1
XFILLER_77_265 VDD VDD VSS VSS gf180mcu_fd_sc_mcu7t5v0__fill_1
XFILLER_65_416 VDD VDD VSS VSS gf180mcu_fd_sc_mcu7t5v0__fillcap_4
XTAP_TAPCELL_ROW_88_1317 VDD VSS gf180mcu_fd_sc_mcu7t5v0__filltie
XFILLER_93_725 VDD VDD VSS VSS gf180mcu_fd_sc_mcu7t5v0__fill_1
XFILLER_18_387 VDD VDD VSS VSS gf180mcu_fd_sc_mcu7t5v0__fillcap_64
X_1971_ _1971_/I _1971_/ZN VDD VDD VSS VSS gf180mcu_fd_sc_mcu7t5v0__clkinv_1
XTAP_TAPCELL_ROW_99_1446 VDD VSS gf180mcu_fd_sc_mcu7t5v0__filltie
X_2523_ _2596_/Q _2517_/B _2523_/A3 _2523_/Z VDD VDD VSS VSS gf180mcu_fd_sc_mcu7t5v0__xor3_1
X_2454_ _2454_/A1 _2517_/B _2454_/B _2568_/D VDD VDD VSS VSS gf180mcu_fd_sc_mcu7t5v0__oai21_1
X_2385_ _2385_/I0 _2541_/Q _2402_/S _2541_/D VDD VDD VSS VSS gf180mcu_fd_sc_mcu7t5v0__mux2_2
X_1405_ _1405_/I _1406_/B1 VDD VDD VSS VSS gf180mcu_fd_sc_mcu7t5v0__clkinv_1
X_1336_ _1336_/A1 _1368_/A2 _2293_/A2 VDD VDD VSS VSS gf180mcu_fd_sc_mcu7t5v0__nand2_1
XFILLER_69_766 VDD VDD VSS VSS gf180mcu_fd_sc_mcu7t5v0__fillcap_4
Xinput1 rst_ni input1/Z VDD VDD VSS VSS gf180mcu_fd_sc_mcu7t5v0__clkbuf_2
X_1267_ _1339_/A1 _1265_/Z _1267_/B _1268_/B1 VDD VDD VSS VSS gf180mcu_fd_sc_mcu7t5v0__oai21_1
X_1198_ _1076_/I _1145_/B _1135_/Z _1200_/B VDD VDD VSS VSS gf180mcu_fd_sc_mcu7t5v0__nand3_1
XTAP_TAPCELL_ROW_108_1553 VDD VSS gf180mcu_fd_sc_mcu7t5v0__filltie
XFILLER_83_279 VDD VDD VSS VSS gf180mcu_fd_sc_mcu7t5v0__fill_1
XFILLER_25_858 VDD VDD VSS VSS gf180mcu_fd_sc_mcu7t5v0__fillcap_8
XFILLER_36_195 VDD VDD VSS VSS gf180mcu_fd_sc_mcu7t5v0__fill_1
XFILLER_37_696 VDD VDD VSS VSS gf180mcu_fd_sc_mcu7t5v0__fillcap_4
XFILLER_51_121 VDD VDD VSS VSS gf180mcu_fd_sc_mcu7t5v0__fillcap_16
XFILLER_24_357 VDD VDD VSS VSS gf180mcu_fd_sc_mcu7t5v0__fillcap_16
XFILLER_51_154 VDD VDD VSS VSS gf180mcu_fd_sc_mcu7t5v0__fillcap_8
XTAP_TAPCELL_ROW_22_525 VDD VSS gf180mcu_fd_sc_mcu7t5v0__filltie
XTAP_TAPCELL_ROW_50_856 VDD VSS gf180mcu_fd_sc_mcu7t5v0__filltie
XTAP_TAPCELL_ROW_72_1118 VDD VSS gf180mcu_fd_sc_mcu7t5v0__filltie
XFILLER_79_508 VDD VDD VSS VSS gf180mcu_fd_sc_mcu7t5v0__fillcap_4
XFILLER_47_416 VDD VDD VSS VSS gf180mcu_fd_sc_mcu7t5v0__fillcap_4
XFILLER_28_641 VDD VDD VSS VSS gf180mcu_fd_sc_mcu7t5v0__fillcap_16
XTAP_TAPCELL_ROW_58_956 VDD VSS gf180mcu_fd_sc_mcu7t5v0__filltie
XFILLER_15_302 VDD VDD VSS VSS gf180mcu_fd_sc_mcu7t5v0__fill_1
XTAP_TAPCELL_ROW_2_283 VDD VSS gf180mcu_fd_sc_mcu7t5v0__filltie
XTAP_TAPCELL_ROW_83_1258 VDD VSS gf180mcu_fd_sc_mcu7t5v0__filltie
XTAP_TAPCELL_ROW_83_1247 VDD VSS gf180mcu_fd_sc_mcu7t5v0__filltie
XTAP_TAPCELL_ROW_94_1387 VDD VSS gf180mcu_fd_sc_mcu7t5v0__filltie
XFILLER_97_349 VDD VDD VSS VSS gf180mcu_fd_sc_mcu7t5v0__fill_1
X_2170_ input73/Z _2142_/B _2170_/B1 _2169_/Z _2170_/C _2172_/B1 VDD VDD VSS VSS gf180mcu_fd_sc_mcu7t5v0__oai221_1
X_1121_ _1248_/A3 _1246_/A2 _1121_/ZN VDD VDD VSS VSS gf180mcu_fd_sc_mcu7t5v0__nand2_1
XFILLER_65_279 VDD VDD VSS VSS gf180mcu_fd_sc_mcu7t5v0__fill_1
XFILLER_19_696 VDD VDD VSS VSS gf180mcu_fd_sc_mcu7t5v0__fillcap_4
XFILLER_61_430 VDD VDD VSS VSS gf180mcu_fd_sc_mcu7t5v0__fillcap_4
XFILLER_73_290 VDD VDD VSS VSS gf180mcu_fd_sc_mcu7t5v0__fillcap_4
XFILLER_21_349 VDD VDD VSS VSS gf180mcu_fd_sc_mcu7t5v0__fill_1
X_1954_ _1954_/A1 _1976_/A2 _2030_/B1 _1954_/B2 _1955_/I VDD VDD VSS VSS gf180mcu_fd_sc_mcu7t5v0__aoi22_1
XTAP_TAPCELL_ROW_103_1494 VDD VSS gf180mcu_fd_sc_mcu7t5v0__filltie
X_1885_ _1885_/I _1885_/ZN VDD VDD VSS VSS gf180mcu_fd_sc_mcu7t5v0__clkinv_1
X_2506_ _2502_/Z _2507_/A2 _2516_/A1 VDD VDD VSS VSS gf180mcu_fd_sc_mcu7t5v0__nand2_1
Xoutput1010 _2320_/ZN tl_h_i_o[32] VDD VDD VSS VSS gf180mcu_fd_sc_mcu7t5v0__dlyd_1
Xoutput1021 _2360_/ZN tl_h_i_o[42] VDD VDD VSS VSS gf180mcu_fd_sc_mcu7t5v0__dlyd_1
Xoutput1032 _2092_/ZN tl_h_i_o[52] VDD VDD VSS VSS gf180mcu_fd_sc_mcu7t5v0__dlyd_1
Xoutput1043 _2255_/A1 tl_h_i_o[62] VDD VDD VSS VSS gf180mcu_fd_sc_mcu7t5v0__dlyd_1
X_2437_ _2564_/Q _2437_/A2 _2564_/D VDD VDD VSS VSS gf180mcu_fd_sc_mcu7t5v0__xor2_1
XFILLER_69_552 VDD VDD VSS VSS gf180mcu_fd_sc_mcu7t5v0__fillcap_8
X_2368_ _2368_/A1 _2368_/A2 _2376_/B _2368_/ZN VDD VDD VSS VSS gf180mcu_fd_sc_mcu7t5v0__aoi21_1
XFILLER_56_235 VDD VDD VSS VSS gf180mcu_fd_sc_mcu7t5v0__fillcap_8
Xload_slew1209 _2259_/A3 _2295_/A3 VDD VDD VSS VSS gf180mcu_fd_sc_mcu7t5v0__buf_2
X_2299_ input87/Z _2363_/A2 _2363_/A3 _2300_/A2 VDD VDD VSS VSS gf180mcu_fd_sc_mcu7t5v0__nand3_1
X_1319_ _1399_/A1 _1319_/A2 _1319_/ZN VDD VDD VSS VSS gf180mcu_fd_sc_mcu7t5v0__nor2_1
XFILLER_56_279 VDD VDD VSS VSS gf180mcu_fd_sc_mcu7t5v0__fill_2
XTAP_TAPCELL_ROW_55_915 VDD VSS gf180mcu_fd_sc_mcu7t5v0__filltie
XFILLER_72_728 VDD VDD VSS VSS gf180mcu_fd_sc_mcu7t5v0__fillcap_4
XFILLER_37_471 VDD VDD VSS VSS gf180mcu_fd_sc_mcu7t5v0__fillcap_16
XTAP_TAPCELL_ROW_69_1080 VDD VSS gf180mcu_fd_sc_mcu7t5v0__filltie
XFILLER_52_452 VDD VDD VSS VSS gf180mcu_fd_sc_mcu7t5v0__fill_2
XFILLER_72_28 VDD VDD VSS VSS gf180mcu_fd_sc_mcu7t5v0__fill_1
XTAP_TAPCELL_ROW_35_672 VDD VSS gf180mcu_fd_sc_mcu7t5v0__filltie
XFILLER_40_669 VDD VDD VSS VSS gf180mcu_fd_sc_mcu7t5v0__fill_1
XFILLER_79_349 VDD VDD VSS VSS gf180mcu_fd_sc_mcu7t5v0__fill_1
XFILLER_79_316 VDD VDD VSS VSS gf180mcu_fd_sc_mcu7t5v0__fillcap_16
XTAP_TAPCELL_ROW_7_342 VDD VSS gf180mcu_fd_sc_mcu7t5v0__filltie
XFILLER_48_769 VDD VDD VSS VSS gf180mcu_fd_sc_mcu7t5v0__fill_2
XFILLER_63_706 VDD VDD VSS VSS gf180mcu_fd_sc_mcu7t5v0__fill_2
XFILLER_90_547 VDD VDD VSS VSS gf180mcu_fd_sc_mcu7t5v0__fillcap_32
XFILLER_43_430 VDD VDD VSS VSS gf180mcu_fd_sc_mcu7t5v0__fillcap_4
XFILLER_43_441 VDD VDD VSS VSS gf180mcu_fd_sc_mcu7t5v0__fillcap_32
XFILLER_71_772 VDD VDD VSS VSS gf180mcu_fd_sc_mcu7t5v0__fillcap_32
XTAP_TAPCELL_ROW_96_1405 VDD VSS gf180mcu_fd_sc_mcu7t5v0__filltie
X_1670_ _1860_/A1 _1732_/A2 _1722_/B1 _1860_/B2 _1671_/I VDD VDD VSS VSS gf180mcu_fd_sc_mcu7t5v0__aoi22_1
XFILLER_38_202 VDD VDD VSS VSS gf180mcu_fd_sc_mcu7t5v0__fill_1
X_2222_ input52/Z _2230_/B _2236_/B _2223_/B2 VDD VDD VSS VSS gf180mcu_fd_sc_mcu7t5v0__aoi21_1
XFILLER_16_2 VDD VDD VSS VSS gf180mcu_fd_sc_mcu7t5v0__fillcap_8
X_2153_ _2153_/A1 _2153_/A2 _2142_/B input70/Z _2155_/B2 VDD VDD VSS VSS gf180mcu_fd_sc_mcu7t5v0__oai22_1
XFILLER_94_831 VDD VDD VSS VSS gf180mcu_fd_sc_mcu7t5v0__fill_1
XFILLER_54_706 VDD VDD VSS VSS gf180mcu_fd_sc_mcu7t5v0__fillcap_8
XFILLER_66_588 VDD VDD VSS VSS gf180mcu_fd_sc_mcu7t5v0__fillcap_4
X_1104_ _2458_/A1 _2568_/Q _1114_/A2 VDD VDD VSS VSS gf180mcu_fd_sc_mcu7t5v0__nand2_1
XFILLER_93_352 VDD VDD VSS VSS gf180mcu_fd_sc_mcu7t5v0__fill_1
X_2084_ _2084_/A1 _2084_/A2 _2084_/ZN VDD VDD VSS VSS gf180mcu_fd_sc_mcu7t5v0__nand2_1
XTAP_TAPCELL_ROW_105_1512 VDD VSS gf180mcu_fd_sc_mcu7t5v0__filltie
XFILLER_61_271 VDD VDD VSS VSS gf180mcu_fd_sc_mcu7t5v0__fill_1
XTAP_TAPCELL_ROW_32_642 VDD VSS gf180mcu_fd_sc_mcu7t5v0__filltie
XTAP_TAPCELL_ROW_60_973 VDD VSS gf180mcu_fd_sc_mcu7t5v0__filltie
X_1937_ _1937_/I _1937_/ZN VDD VDD VSS VSS gf180mcu_fd_sc_mcu7t5v0__clkinv_1
X_1868_ _1868_/A1 _1900_/A2 _1900_/B1 _1868_/B2 _1869_/I VDD VDD VSS VSS gf180mcu_fd_sc_mcu7t5v0__aoi22_1
Xinput70 tl_d_esram_i[11] input70/Z VDD VDD VSS VSS gf180mcu_fd_sc_mcu7t5v0__dlyd_1
Xinput81 tl_d_esram_i[21] input81/Z VDD VDD VSS VSS gf180mcu_fd_sc_mcu7t5v0__dlyd_1
XTAP_TAPCELL_ROW_116_1652 VDD VSS gf180mcu_fd_sc_mcu7t5v0__filltie
Xinput92 tl_d_esram_i[31] input92/Z VDD VDD VSS VSS gf180mcu_fd_sc_mcu7t5v0__dlyd_1
X_1799_ _1799_/I _1799_/ZN VDD VDD VSS VSS gf180mcu_fd_sc_mcu7t5v0__clkinv_1
XFILLER_103_402 VDD VDD VSS VSS gf180mcu_fd_sc_mcu7t5v0__fillcap_8
XTAP_TAPCELL_ROW_4_301 VDD VSS gf180mcu_fd_sc_mcu7t5v0__filltie
XFILLER_85_842 VDD VDD VSS VSS gf180mcu_fd_sc_mcu7t5v0__fillcap_4
XFILLER_85_864 VDD VDD VSS VSS gf180mcu_fd_sc_mcu7t5v0__fill_2
XFILLER_16_10 VDD VDD VSS VSS gf180mcu_fd_sc_mcu7t5v0__fillcap_4
XTAP_TAPCELL_ROW_80_1217 VDD VSS gf180mcu_fd_sc_mcu7t5v0__filltie
XFILLER_52_282 VDD VDD VSS VSS gf180mcu_fd_sc_mcu7t5v0__fillcap_4
XFILLER_9_607 VDD VDD VSS VSS gf180mcu_fd_sc_mcu7t5v0__fillcap_4
XFILLER_80_591 VDD VDD VSS VSS gf180mcu_fd_sc_mcu7t5v0__fillcap_4
XFILLER_9_618 VDD VDD VSS VSS gf180mcu_fd_sc_mcu7t5v0__fillcap_4
XFILLER_40_499 VDD VDD VSS VSS gf180mcu_fd_sc_mcu7t5v0__fillcap_16
XTAP_TAPCELL_ROW_91_1346 VDD VSS gf180mcu_fd_sc_mcu7t5v0__filltie
XFILLER_79_124 VDD VDD VSS VSS gf180mcu_fd_sc_mcu7t5v0__fill_1
XFILLER_0_562 VDD VDD VSS VSS gf180mcu_fd_sc_mcu7t5v0__fillcap_8
Xinput430 tl_h_i_i[42] _1938_/A1 VDD VDD VSS VSS gf180mcu_fd_sc_mcu7t5v0__dlyd_1
XFILLER_95_617 VDD VDD VSS VSS gf180mcu_fd_sc_mcu7t5v0__fill_1
Xinput441 tl_h_i_i[52] _1958_/A1 VDD VDD VSS VSS gf180mcu_fd_sc_mcu7t5v0__dlyd_1
Xinput452 tl_h_i_i[62] _1978_/A1 VDD VDD VSS VSS gf180mcu_fd_sc_mcu7t5v0__dlyd_1
Xinput463 tl_h_i_i[72] _1998_/A1 VDD VDD VSS VSS gf180mcu_fd_sc_mcu7t5v0__dlyd_1
XFILLER_76_831 VDD VDD VSS VSS gf180mcu_fd_sc_mcu7t5v0__fill_1
Xinput474 tl_h_i_i[82] _1164_/A1 VDD VDD VSS VSS gf180mcu_fd_sc_mcu7t5v0__dlyd_1
Xinput485 tl_h_i_i[92] _1162_/A3 VDD VDD VSS VSS gf180mcu_fd_sc_mcu7t5v0__dlyd_1
XFILLER_75_363 VDD VDD VSS VSS gf180mcu_fd_sc_mcu7t5v0__fill_1
XFILLER_48_599 VDD VDD VSS VSS gf180mcu_fd_sc_mcu7t5v0__fill_1
XFILLER_50_219 VDD VDD VSS VSS gf180mcu_fd_sc_mcu7t5v0__fillcap_16
XTAP_TAPCELL_ROW_18_469 VDD VSS gf180mcu_fd_sc_mcu7t5v0__filltie
XFILLER_90_377 VDD VDD VSS VSS gf180mcu_fd_sc_mcu7t5v0__fillcap_8
XFILLER_31_422 VDD VDD VSS VSS gf180mcu_fd_sc_mcu7t5v0__fillcap_16
XFILLER_43_282 VDD VDD VSS VSS gf180mcu_fd_sc_mcu7t5v0__fillcap_16
XTAP_TAPCELL_ROW_100_1453 VDD VSS gf180mcu_fd_sc_mcu7t5v0__filltie
X_2771_ _2771_/I _2771_/Z VDD VDD VSS VSS gf180mcu_fd_sc_mcu7t5v0__buf_1
X_1722_ _1912_/A1 _1722_/A2 _1722_/B1 _1912_/B2 _1723_/I VDD VDD VSS VSS gf180mcu_fd_sc_mcu7t5v0__aoi22_1
X_1653_ _1653_/A1 _1662_/S _1653_/ZN VDD VDD VSS VSS gf180mcu_fd_sc_mcu7t5v0__nor2_1
Xoutput937 _1343_/ZN tl_h_d_o[26] VDD VDD VSS VSS gf180mcu_fd_sc_mcu7t5v0__dlyd_1
Xoutput926 _1263_/ZN tl_h_d_o[16] VDD VDD VSS VSS gf180mcu_fd_sc_mcu7t5v0__dlyd_1
Xoutput915 _2756_/Z tl_d_uart_o[97] VDD VDD VSS VSS gf180mcu_fd_sc_mcu7t5v0__dlyd_1
Xoutput904 _2746_/Z tl_d_uart_o[87] VDD VDD VSS VSS gf180mcu_fd_sc_mcu7t5v0__dlyd_1
XPHY_EDGE_ROW_9_Right_9 VDD VSS gf180mcu_fd_sc_mcu7t5v0__endcap
Xoutput959 _1503_/ZN tl_h_d_o[46] VDD VDD VSS VSS gf180mcu_fd_sc_mcu7t5v0__dlyd_1
Xoutput948 _1423_/ZN tl_h_d_o[36] VDD VDD VSS VSS gf180mcu_fd_sc_mcu7t5v0__dlyd_1
X_1584_ _2721_/I _2698_/I _2732_/I _1584_/Z VDD VDD VSS VSS gf180mcu_fd_sc_mcu7t5v0__xor3_1
XFILLER_98_433 VDD VDD VSS VSS gf180mcu_fd_sc_mcu7t5v0__fill_1
XPHY_EDGE_ROW_107_Right_107 VDD VSS gf180mcu_fd_sc_mcu7t5v0__endcap
XFILLER_67_842 VDD VDD VSS VSS gf180mcu_fd_sc_mcu7t5v0__fillcap_16
X_2205_ _2205_/A1 _2218_/A2 _2207_/A1 VDD VDD VSS VSS gf180mcu_fd_sc_mcu7t5v0__nand2_1
XTAP_TAPCELL_ROW_111_1593 VDD VSS gf180mcu_fd_sc_mcu7t5v0__filltie
Xfanout1190 _1444_/B2 _2160_/A2 VDD VDD VSS VSS gf180mcu_fd_sc_mcu7t5v0__dlyd_1
X_2136_ _2136_/A1 _2238_/A2 _2238_/B1 _2136_/B2 _2138_/A2 VDD VDD VSS VSS gf180mcu_fd_sc_mcu7t5v0__aoi22_1
XTAP_TAPCELL_ROW_37_701 VDD VSS gf180mcu_fd_sc_mcu7t5v0__filltie
XFILLER_82_823 VDD VDD VSS VSS gf180mcu_fd_sc_mcu7t5v0__fillcap_8
XFILLER_19_290 VDD VDD VSS VSS gf180mcu_fd_sc_mcu7t5v0__fillcap_4
XFILLER_26_249 VDD VDD VSS VSS gf180mcu_fd_sc_mcu7t5v0__fill_1
X_2067_ _2539_/Q _2148_/A1 _2067_/B _2068_/B2 VDD VDD VSS VSS gf180mcu_fd_sc_mcu7t5v0__oai21_1
XFILLER_81_344 VDD VDD VSS VSS gf180mcu_fd_sc_mcu7t5v0__fillcap_4
XTAP_TAPCELL_ROW_66_1050 VDD VSS gf180mcu_fd_sc_mcu7t5v0__filltie
XFILLER_50_731 VDD VDD VSS VSS gf180mcu_fd_sc_mcu7t5v0__fillcap_4
XFILLER_62_591 VDD VDD VSS VSS gf180mcu_fd_sc_mcu7t5v0__fillcap_4
XFILLER_22_477 VDD VDD VSS VSS gf180mcu_fd_sc_mcu7t5v0__fillcap_32
XFILLER_10_639 VDD VDD VSS VSS gf180mcu_fd_sc_mcu7t5v0__fill_1
XFILLER_89_422 VDD VDD VSS VSS gf180mcu_fd_sc_mcu7t5v0__fillcap_8
XFILLER_58_831 VDD VDD VSS VSS gf180mcu_fd_sc_mcu7t5v0__fill_1
XFILLER_94_26 VDD VDD VSS VSS gf180mcu_fd_sc_mcu7t5v0__fill_1
XFILLER_91_108 VDD VDD VSS VSS gf180mcu_fd_sc_mcu7t5v0__fillcap_8
XFILLER_72_311 VDD VDD VSS VSS gf180mcu_fd_sc_mcu7t5v0__fillcap_4
XFILLER_72_344 VDD VDD VSS VSS gf180mcu_fd_sc_mcu7t5v0__fill_1
XFILLER_72_333 VDD VDD VSS VSS gf180mcu_fd_sc_mcu7t5v0__fill_2
XFILLER_25_260 VDD VDD VSS VSS gf180mcu_fd_sc_mcu7t5v0__fillcap_8
XFILLER_13_422 VDD VDD VSS VSS gf180mcu_fd_sc_mcu7t5v0__fillcap_64
XFILLER_25_282 VDD VDD VSS VSS gf180mcu_fd_sc_mcu7t5v0__fillcap_32
XTAP_TAPCELL_ROW_15_439 VDD VSS gf180mcu_fd_sc_mcu7t5v0__filltie
XFILLER_40_241 VDD VDD VSS VSS gf180mcu_fd_sc_mcu7t5v0__fillcap_4
XFILLER_40_263 VDD VDD VSS VSS gf180mcu_fd_sc_mcu7t5v0__fillcap_4
XFILLER_68_71 VDD VDD VSS VSS gf180mcu_fd_sc_mcu7t5v0__fillcap_8
XFILLER_49_842 VDD VDD VSS VSS gf180mcu_fd_sc_mcu7t5v0__fillcap_16
Xxbar_tlul_2to4_1253 tl_d_esram_o[92] VDD VDD VSS VSS gf180mcu_fd_sc_mcu7t5v0__tiel
Xxbar_tlul_2to4_1264 tl_d_rom_o[96] VDD VDD VSS VSS gf180mcu_fd_sc_mcu7t5v0__tiel
Xxbar_tlul_2to4_1275 tl_d_rom_o[85] VDD VDD VSS VSS gf180mcu_fd_sc_mcu7t5v0__tiel
XFILLER_64_801 VDD VDD VSS VSS gf180mcu_fd_sc_mcu7t5v0__fillcap_4
Xinput260 tl_d_uart_i[64] _1248_/A2 VDD VDD VSS VSS gf180mcu_fd_sc_mcu7t5v0__dlyd_1
Xinput271 tl_h_d_i[104] _2763_/I VDD VDD VSS VSS gf180mcu_fd_sc_mcu7t5v0__clkbuf_2
XFILLER_64_823 VDD VDD VSS VSS gf180mcu_fd_sc_mcu7t5v0__fillcap_8
Xinput282 tl_h_d_i[11] _1876_/B2 VDD VDD VSS VSS gf180mcu_fd_sc_mcu7t5v0__dlyd_1
Xinput293 tl_h_d_i[21] _2712_/I VDD VDD VSS VSS gf180mcu_fd_sc_mcu7t5v0__clkbuf_2
XFILLER_76_683 VDD VDD VSS VSS gf180mcu_fd_sc_mcu7t5v0__fill_2
XFILLER_36_547 VDD VDD VSS VSS gf180mcu_fd_sc_mcu7t5v0__fill_1
XFILLER_91_675 VDD VDD VSS VSS gf180mcu_fd_sc_mcu7t5v0__fillcap_4
XFILLER_32_731 VDD VDD VSS VSS gf180mcu_fd_sc_mcu7t5v0__fillcap_4
XFILLER_31_230 VDD VDD VSS VSS gf180mcu_fd_sc_mcu7t5v0__fill_1
XFILLER_118_814 VDD VDD VSS VSS gf180mcu_fd_sc_mcu7t5v0__fill_2
X_2754_ _2754_/I _2754_/Z VDD VDD VSS VSS gf180mcu_fd_sc_mcu7t5v0__buf_1
X_1705_ _1705_/I _1705_/ZN VDD VDD VSS VSS gf180mcu_fd_sc_mcu7t5v0__clkinv_1
X_2685_ _2757_/I _2685_/Z VDD VDD VSS VSS gf180mcu_fd_sc_mcu7t5v0__buf_1
Xoutput712 _1839_/ZN tl_d_rom_o[104] VDD VDD VSS VSS gf180mcu_fd_sc_mcu7t5v0__dlyd_1
Xoutput701 _2538_/ZN tl_d_esram_o[81] VDD VDD VSS VSS gf180mcu_fd_sc_mcu7t5v0__dlyd_1
Xoutput745 _1727_/ZN tl_d_rom_o[31] VDD VDD VSS VSS gf180mcu_fd_sc_mcu7t5v0__dlyd_1
Xoutput734 _1707_/ZN tl_d_rom_o[21] VDD VDD VSS VSS gf180mcu_fd_sc_mcu7t5v0__dlyd_1
Xoutput723 _1687_/ZN tl_d_rom_o[11] VDD VDD VSS VSS gf180mcu_fd_sc_mcu7t5v0__dlyd_1
X_1636_ _1944_/B2 _1641_/A2 _1636_/Z VDD VDD VSS VSS gf180mcu_fd_sc_mcu7t5v0__or2_1
XTAP_TAPCELL_ROW_113_1611 VDD VSS gf180mcu_fd_sc_mcu7t5v0__filltie
Xoutput778 _1787_/ZN tl_d_rom_o[61] VDD VDD VSS VSS gf180mcu_fd_sc_mcu7t5v0__dlyd_1
Xoutput767 _1767_/ZN tl_d_rom_o[51] VDD VDD VSS VSS gf180mcu_fd_sc_mcu7t5v0__dlyd_1
Xoutput756 _1747_/ZN tl_d_rom_o[41] VDD VDD VSS VSS gf180mcu_fd_sc_mcu7t5v0__dlyd_1
X_1567_ _2740_/I _2738_/I _1567_/Z VDD VDD VSS VSS gf180mcu_fd_sc_mcu7t5v0__xor2_1
Xoutput789 _1807_/ZN tl_d_rom_o[71] VDD VDD VSS VSS gf180mcu_fd_sc_mcu7t5v0__dlyd_1
X_1498_ _2375_/A1 _2230_/A2 _2375_/A3 _1499_/B VDD VDD VSS VSS gf180mcu_fd_sc_mcu7t5v0__nand3_1
XFILLER_39_352 VDD VDD VSS VSS gf180mcu_fd_sc_mcu7t5v0__fillcap_16
XFILLER_58_149 VDD VDD VSS VSS gf180mcu_fd_sc_mcu7t5v0__fillcap_4
XFILLER_39_385 VDD VDD VSS VSS gf180mcu_fd_sc_mcu7t5v0__fillcap_16
XFILLER_54_300 VDD VDD VSS VSS gf180mcu_fd_sc_mcu7t5v0__fillcap_8
XFILLER_66_171 VDD VDD VSS VSS gf180mcu_fd_sc_mcu7t5v0__fillcap_4
X_2119_ _2119_/A1 _2153_/A2 _2142_/B _2119_/B2 _2121_/A2 VDD VDD VSS VSS gf180mcu_fd_sc_mcu7t5v0__oai22_1
XFILLER_82_664 VDD VDD VSS VSS gf180mcu_fd_sc_mcu7t5v0__fill_1
XFILLER_42_506 VDD VDD VSS VSS gf180mcu_fd_sc_mcu7t5v0__fillcap_16
XFILLER_81_163 VDD VDD VSS VSS gf180mcu_fd_sc_mcu7t5v0__fillcap_4
XFILLER_22_241 VDD VDD VSS VSS gf180mcu_fd_sc_mcu7t5v0__fillcap_4
XTAP_TAPCELL_ROW_20_497 VDD VSS gf180mcu_fd_sc_mcu7t5v0__filltie
XFILLER_46_801 VDD VDD VSS VSS gf180mcu_fd_sc_mcu7t5v0__fillcap_4
XFILLER_58_661 VDD VDD VSS VSS gf180mcu_fd_sc_mcu7t5v0__fillcap_4
XFILLER_46_823 VDD VDD VSS VSS gf180mcu_fd_sc_mcu7t5v0__fillcap_8
XTAP_TAPCELL_ROW_48_829 VDD VSS gf180mcu_fd_sc_mcu7t5v0__filltie
XFILLER_61_804 VDD VDD VSS VSS gf180mcu_fd_sc_mcu7t5v0__fill_2
XTAP_TAPCELL_ROW_86_1289 VDD VSS gf180mcu_fd_sc_mcu7t5v0__filltie
XFILLER_73_664 VDD VDD VSS VSS gf180mcu_fd_sc_mcu7t5v0__fillcap_16
XFILLER_14_731 VDD VDD VSS VSS gf180mcu_fd_sc_mcu7t5v0__fillcap_4
XFILLER_26_591 VDD VDD VSS VSS gf180mcu_fd_sc_mcu7t5v0__fillcap_4
XTAP_TAPCELL_ROW_28_597 VDD VSS gf180mcu_fd_sc_mcu7t5v0__filltie
XFILLER_72_185 VDD VDD VSS VSS gf180mcu_fd_sc_mcu7t5v0__fill_2
XFILLER_41_550 VDD VDD VSS VSS gf180mcu_fd_sc_mcu7t5v0__fillcap_8
XFILLER_41_594 VDD VDD VSS VSS gf180mcu_fd_sc_mcu7t5v0__fillcap_8
XFILLER_13_296 VDD VDD VSS VSS gf180mcu_fd_sc_mcu7t5v0__fillcap_32
XFILLER_70_94 VDD VDD VSS VSS gf180mcu_fd_sc_mcu7t5v0__fill_2
X_2470_ _2765_/I _2580_/Q _2476_/S _2580_/D VDD VDD VSS VSS gf180mcu_fd_sc_mcu7t5v0__mux2_2
X_1421_ _1421_/I _1422_/B1 VDD VDD VSS VSS gf180mcu_fd_sc_mcu7t5v0__clkinv_1
XFILLER_68_403 VDD VDD VSS VSS gf180mcu_fd_sc_mcu7t5v0__fillcap_8
XFILLER_68_436 VDD VDD VSS VSS gf180mcu_fd_sc_mcu7t5v0__fill_1
X_1352_ _1352_/A1 _1368_/A2 _2301_/A2 VDD VDD VSS VSS gf180mcu_fd_sc_mcu7t5v0__nand2_1
X_1283_ _1339_/A1 _1281_/Z _1283_/B _1284_/B1 VDD VDD VSS VSS gf180mcu_fd_sc_mcu7t5v0__oai21_1
XFILLER_49_694 VDD VDD VSS VSS gf180mcu_fd_sc_mcu7t5v0__fillcap_4
XFILLER_83_417 VDD VDD VSS VSS gf180mcu_fd_sc_mcu7t5v0__fill_2
XFILLER_63_163 VDD VDD VSS VSS gf180mcu_fd_sc_mcu7t5v0__fill_2
XFILLER_64_664 VDD VDD VSS VSS gf180mcu_fd_sc_mcu7t5v0__fill_1
XFILLER_64_675 VDD VDD VSS VSS gf180mcu_fd_sc_mcu7t5v0__fill_1
XFILLER_91_472 VDD VDD VSS VSS gf180mcu_fd_sc_mcu7t5v0__fillcap_16
XFILLER_63_174 VDD VDD VSS VSS gf180mcu_fd_sc_mcu7t5v0__fill_2
XFILLER_64_697 VDD VDD VSS VSS gf180mcu_fd_sc_mcu7t5v0__fillcap_32
XFILLER_91_494 VDD VDD VSS VSS gf180mcu_fd_sc_mcu7t5v0__fill_1
XFILLER_32_550 VDD VDD VSS VSS gf180mcu_fd_sc_mcu7t5v0__fillcap_32
XFILLER_32_594 VDD VDD VSS VSS gf180mcu_fd_sc_mcu7t5v0__fill_1
XFILLER_118_611 VDD VDD VSS VSS gf180mcu_fd_sc_mcu7t5v0__fill_1
X_2737_ _2737_/I _2737_/Z VDD VDD VSS VSS gf180mcu_fd_sc_mcu7t5v0__buf_1
X_2668_ _2740_/I _2668_/Z VDD VDD VSS VSS gf180mcu_fd_sc_mcu7t5v0__buf_1
Xoutput520 _2639_/Z tl_d_dmem_o[20] VDD VDD VSS VSS gf180mcu_fd_sc_mcu7t5v0__dlyd_1
Xoutput531 _1513_/Z tl_d_dmem_o[30] VDD VDD VSS VSS gf180mcu_fd_sc_mcu7t5v0__dlyd_1
Xoutput542 _1523_/Z tl_d_dmem_o[40] VDD VDD VSS VSS gf180mcu_fd_sc_mcu7t5v0__dlyd_1
Xoutput553 _1533_/Z tl_d_dmem_o[50] VDD VDD VSS VSS gf180mcu_fd_sc_mcu7t5v0__dlyd_1
X_1619_ _1882_/B2 _1618_/Z _1619_/S _1619_/Z VDD VDD VSS VSS gf180mcu_fd_sc_mcu7t5v0__mux2_2
XFILLER_114_861 VDD VDD VSS VSS gf180mcu_fd_sc_mcu7t5v0__fillcap_4
X_2599_ _2599_/D _2601_/RN clkload5/I _2599_/Q VDD VDD VSS VSS gf180mcu_fd_sc_mcu7t5v0__dffrnq_1
Xoutput564 _1543_/Z tl_d_dmem_o[60] VDD VDD VSS VSS gf180mcu_fd_sc_mcu7t5v0__dlyd_1
Xoutput575 _2657_/Z tl_d_dmem_o[70] VDD VDD VSS VSS gf180mcu_fd_sc_mcu7t5v0__dlyd_1
Xoutput586 _2667_/Z tl_d_dmem_o[80] VDD VDD VSS VSS gf180mcu_fd_sc_mcu7t5v0__dlyd_1
XFILLER_99_550 VDD VDD VSS VSS gf180mcu_fd_sc_mcu7t5v0__fill_1
Xoutput597 _2677_/Z tl_d_dmem_o[90] VDD VDD VSS VSS gf180mcu_fd_sc_mcu7t5v0__dlyd_1
XFILLER_87_734 VDD VDD VSS VSS gf180mcu_fd_sc_mcu7t5v0__fillcap_16
XFILLER_86_200 VDD VDD VSS VSS gf180mcu_fd_sc_mcu7t5v0__fillcap_32
XFILLER_28_823 VDD VDD VSS VSS gf180mcu_fd_sc_mcu7t5v0__fillcap_8
XFILLER_86_299 VDD VDD VSS VSS gf180mcu_fd_sc_mcu7t5v0__fill_2
XFILLER_27_388 VDD VDD VSS VSS gf180mcu_fd_sc_mcu7t5v0__fill_2
XFILLER_43_859 VDD VDD VSS VSS gf180mcu_fd_sc_mcu7t5v0__fillcap_4
XFILLER_24_10 VDD VDD VSS VSS gf180mcu_fd_sc_mcu7t5v0__fillcap_4
XTAP_TAPCELL_ROW_25_556 VDD VSS gf180mcu_fd_sc_mcu7t5v0__filltie
XFILLER_70_667 VDD VDD VSS VSS gf180mcu_fd_sc_mcu7t5v0__fillcap_8
XFILLER_11_734 VDD VDD VSS VSS gf180mcu_fd_sc_mcu7t5v0__fill_2
XTAP_TAPCELL_ROW_53_898 VDD VSS gf180mcu_fd_sc_mcu7t5v0__filltie
XTAP_TAPCELL_ROW_53_887 VDD VSS gf180mcu_fd_sc_mcu7t5v0__filltie
XFILLER_78_723 VDD VDD VSS VSS gf180mcu_fd_sc_mcu7t5v0__fillcap_4
XTAP_TAPCELL_ROW_88_1318 VDD VSS gf180mcu_fd_sc_mcu7t5v0__filltie
XTAP_TAPCELL_ROW_88_1307 VDD VSS gf180mcu_fd_sc_mcu7t5v0__filltie
XFILLER_92_247 VDD VDD VSS VSS gf180mcu_fd_sc_mcu7t5v0__fill_1
XFILLER_61_601 VDD VDD VSS VSS gf180mcu_fd_sc_mcu7t5v0__fillcap_16
XFILLER_65_72 VDD VDD VSS VSS gf180mcu_fd_sc_mcu7t5v0__fillcap_64
X_1970_ _1970_/A1 _1982_/A2 _1998_/B1 _1970_/B2 _1971_/I VDD VDD VSS VSS gf180mcu_fd_sc_mcu7t5v0__aoi22_1
XFILLER_60_177 VDD VDD VSS VSS gf180mcu_fd_sc_mcu7t5v0__fillcap_16
XTAP_TAPCELL_ROW_99_1447 VDD VSS gf180mcu_fd_sc_mcu7t5v0__filltie
X_2522_ _2595_/Q _2517_/B _2522_/B _2523_/A3 VDD VDD VSS VSS gf180mcu_fd_sc_mcu7t5v0__aoi21_1
XFILLER_46_2 VDD VDD VSS VSS gf180mcu_fd_sc_mcu7t5v0__fillcap_8
X_2453_ _2568_/Q _2517_/B _2454_/B VDD VDD VSS VSS gf180mcu_fd_sc_mcu7t5v0__nand2_1
X_2384_ _2067_/B _2775_/I _2394_/S _2540_/D VDD VDD VSS VSS gf180mcu_fd_sc_mcu7t5v0__oai21_1
X_1404_ input29/Z _1468_/A2 _1404_/B1 _1476_/B2 _1405_/I VDD VDD VSS VSS gf180mcu_fd_sc_mcu7t5v0__aoi22_1
XFILLER_111_842 VDD VDD VSS VSS gf180mcu_fd_sc_mcu7t5v0__fillcap_4
XFILLER_68_233 VDD VDD VSS VSS gf180mcu_fd_sc_mcu7t5v0__fillcap_8
XFILLER_68_255 VDD VDD VSS VSS gf180mcu_fd_sc_mcu7t5v0__fillcap_4
X_1335_ _1399_/A1 _1335_/A2 _1335_/ZN VDD VDD VSS VSS gf180mcu_fd_sc_mcu7t5v0__nor2_1
Xinput2 tl_d_dmem_i[0] input2/Z VDD VDD VSS VSS gf180mcu_fd_sc_mcu7t5v0__dlyd_1
XFILLER_96_597 VDD VDD VSS VSS gf180mcu_fd_sc_mcu7t5v0__fillcap_8
XFILLER_84_737 VDD VDD VSS VSS gf180mcu_fd_sc_mcu7t5v0__fillcap_64
XFILLER_83_214 VDD VDD VSS VSS gf180mcu_fd_sc_mcu7t5v0__fill_1
X_1266_ input76/Z _2116_/B1 _2259_/A3 _1267_/B VDD VDD VSS VSS gf180mcu_fd_sc_mcu7t5v0__nand3_1
XFILLER_36_141 VDD VDD VSS VSS gf180mcu_fd_sc_mcu7t5v0__fill_1
XFILLER_36_152 VDD VDD VSS VSS gf180mcu_fd_sc_mcu7t5v0__fillcap_16
XFILLER_64_461 VDD VDD VSS VSS gf180mcu_fd_sc_mcu7t5v0__fill_2
X_1197_ _1078_/I _1197_/A2 _1197_/B _1203_/A2 VDD VDD VSS VSS gf180mcu_fd_sc_mcu7t5v0__aoi21_1
XTAP_TAPCELL_ROW_108_1554 VDD VSS gf180mcu_fd_sc_mcu7t5v0__filltie
XFILLER_36_174 VDD VDD VSS VSS gf180mcu_fd_sc_mcu7t5v0__fill_1
XFILLER_40_807 VDD VDD VSS VSS gf180mcu_fd_sc_mcu7t5v0__fillcap_16
XFILLER_52_656 VDD VDD VSS VSS gf180mcu_fd_sc_mcu7t5v0__fillcap_8
XFILLER_51_166 VDD VDD VSS VSS gf180mcu_fd_sc_mcu7t5v0__fill_2
XTAP_TAPCELL_ROW_22_515 VDD VSS gf180mcu_fd_sc_mcu7t5v0__filltie
XFILLER_32_380 VDD VDD VSS VSS gf180mcu_fd_sc_mcu7t5v0__fillcap_4
XTAP_TAPCELL_ROW_50_857 VDD VSS gf180mcu_fd_sc_mcu7t5v0__filltie
XTAP_TAPCELL_ROW_22_526 VDD VSS gf180mcu_fd_sc_mcu7t5v0__filltie
XFILLER_118_441 VDD VDD VSS VSS gf180mcu_fd_sc_mcu7t5v0__fill_1
XFILLER_20_597 VDD VDD VSS VSS gf180mcu_fd_sc_mcu7t5v0__fillcap_64
XTAP_TAPCELL_ROW_72_1119 VDD VSS gf180mcu_fd_sc_mcu7t5v0__filltie
XFILLER_102_831 VDD VDD VSS VSS gf180mcu_fd_sc_mcu7t5v0__fill_1
XFILLER_101_341 VDD VDD VSS VSS gf180mcu_fd_sc_mcu7t5v0__fill_1
XFILLER_101_352 VDD VDD VSS VSS gf180mcu_fd_sc_mcu7t5v0__fillcap_8
XFILLER_59_266 VDD VDD VSS VSS gf180mcu_fd_sc_mcu7t5v0__fillcap_8
XFILLER_101_396 VDD VDD VSS VSS gf180mcu_fd_sc_mcu7t5v0__fillcap_16
XTAP_TAPCELL_ROW_58_957 VDD VSS gf180mcu_fd_sc_mcu7t5v0__filltie
XTAP_TAPCELL_ROW_2_284 VDD VSS gf180mcu_fd_sc_mcu7t5v0__filltie
XTAP_TAPCELL_ROW_83_1248 VDD VSS gf180mcu_fd_sc_mcu7t5v0__filltie
XFILLER_30_317 VDD VDD VSS VSS gf180mcu_fd_sc_mcu7t5v0__fillcap_16
XFILLER_42_177 VDD VDD VSS VSS gf180mcu_fd_sc_mcu7t5v0__fillcap_32
XFILLER_109_463 VDD VDD VSS VSS gf180mcu_fd_sc_mcu7t5v0__fillcap_16
XTAP_TAPCELL_ROW_94_1388 VDD VSS gf180mcu_fd_sc_mcu7t5v0__filltie
XFILLER_98_807 VDD VDD VSS VSS gf180mcu_fd_sc_mcu7t5v0__fillcap_16
XFILLER_78_520 VDD VDD VSS VSS gf180mcu_fd_sc_mcu7t5v0__fillcap_4
XPHY_EDGE_ROW_29_Left_148 VDD VSS gf180mcu_fd_sc_mcu7t5v0__endcap
XFILLER_66_737 VDD VDD VSS VSS gf180mcu_fd_sc_mcu7t5v0__fillcap_64
X_1120_ input60/Z _2215_/B _1120_/B _1217_/C _1246_/A2 VDD VDD VSS VSS gf180mcu_fd_sc_mcu7t5v0__oai211_1
XFILLER_78_597 VDD VDD VSS VSS gf180mcu_fd_sc_mcu7t5v0__fillcap_8
XFILLER_65_225 VDD VDD VSS VSS gf180mcu_fd_sc_mcu7t5v0__fillcap_16
Xclkbuf_3_2__f_clk_i clkbuf_0_clk_i/Z clkload2/I VDD VDD VSS VSS gf180mcu_fd_sc_mcu7t5v0__clkbuf_16
XFILLER_18_130 VDD VDD VSS VSS gf180mcu_fd_sc_mcu7t5v0__fill_2
XFILLER_65_258 VDD VDD VSS VSS gf180mcu_fd_sc_mcu7t5v0__fillcap_8
XFILLER_80_228 VDD VDD VSS VSS gf180mcu_fd_sc_mcu7t5v0__fillcap_16
XFILLER_22_807 VDD VDD VSS VSS gf180mcu_fd_sc_mcu7t5v0__fillcap_16
XFILLER_34_667 VDD VDD VSS VSS gf180mcu_fd_sc_mcu7t5v0__fillcap_64
XPHY_EDGE_ROW_1_Left_120 VDD VSS gf180mcu_fd_sc_mcu7t5v0__endcap
XPHY_EDGE_ROW_38_Left_157 VDD VSS gf180mcu_fd_sc_mcu7t5v0__endcap
XFILLER_21_339 VDD VDD VSS VSS gf180mcu_fd_sc_mcu7t5v0__fillcap_8
X_1953_ _1953_/I _1953_/ZN VDD VDD VSS VSS gf180mcu_fd_sc_mcu7t5v0__clkinv_1
XTAP_TAPCELL_ROW_103_1495 VDD VSS gf180mcu_fd_sc_mcu7t5v0__filltie
X_1884_ _2385_/I0 _1914_/A2 _1914_/B1 _2706_/I _1885_/I VDD VDD VSS VSS gf180mcu_fd_sc_mcu7t5v0__aoi22_1
XFILLER_115_422 VDD VDD VSS VSS gf180mcu_fd_sc_mcu7t5v0__fill_1
Xoutput1000 _2284_/ZN tl_h_i_o[23] VDD VDD VSS VSS gf180mcu_fd_sc_mcu7t5v0__dlyd_1
Xoutput1011 _2324_/ZN tl_h_i_o[33] VDD VDD VSS VSS gf180mcu_fd_sc_mcu7t5v0__dlyd_1
Xoutput1022 _2364_/ZN tl_h_i_o[43] VDD VDD VSS VSS gf180mcu_fd_sc_mcu7t5v0__dlyd_1
Xoutput1033 _2095_/ZN tl_h_i_o[53] VDD VDD VSS VSS gf180mcu_fd_sc_mcu7t5v0__dlyd_1
X_2505_ _2502_/Z _2507_/A2 _2505_/Z VDD VDD VSS VSS gf180mcu_fd_sc_mcu7t5v0__or2_1
XPHY_EDGE_ROW_47_Left_166 VDD VSS gf180mcu_fd_sc_mcu7t5v0__endcap
Xoutput1044 _1243_/ZN tl_h_i_o[63] VDD VDD VSS VSS gf180mcu_fd_sc_mcu7t5v0__dlyd_1
X_2436_ _2775_/I _2433_/B _2436_/B _2436_/C _2437_/A2 VDD VDD VSS VSS gf180mcu_fd_sc_mcu7t5v0__aoi211_1
XFILLER_88_317 VDD VDD VSS VSS gf180mcu_fd_sc_mcu7t5v0__fillcap_16
XFILLER_69_531 VDD VDD VSS VSS gf180mcu_fd_sc_mcu7t5v0__fillcap_4
XFILLER_29_406 VDD VDD VSS VSS gf180mcu_fd_sc_mcu7t5v0__fillcap_8
X_2367_ _2367_/A1 _2375_/A2 _2375_/A3 _2368_/A2 VDD VDD VSS VSS gf180mcu_fd_sc_mcu7t5v0__nand3_1
XFILLER_84_512 VDD VDD VSS VSS gf180mcu_fd_sc_mcu7t5v0__fillcap_8
XFILLER_69_586 VDD VDD VSS VSS gf180mcu_fd_sc_mcu7t5v0__fillcap_32
XFILLER_56_247 VDD VDD VSS VSS gf180mcu_fd_sc_mcu7t5v0__fillcap_32
X_2298_ _2358_/A1 _2298_/A2 _2300_/A1 VDD VDD VSS VSS gf180mcu_fd_sc_mcu7t5v0__nand2_1
X_1318_ _1318_/A1 _1406_/A2 _1318_/B1 _2146_/C _1319_/A2 VDD VDD VSS VSS gf180mcu_fd_sc_mcu7t5v0__aoi22_1
X_1249_ input60/Z _1249_/A2 _1250_/A2 VDD VDD VSS VSS gf180mcu_fd_sc_mcu7t5v0__nand2_1
XTAP_TAPCELL_ROW_55_916 VDD VSS gf180mcu_fd_sc_mcu7t5v0__filltie
XTAP_TAPCELL_ROW_69_1081 VDD VSS gf180mcu_fd_sc_mcu7t5v0__filltie
XPHY_EDGE_ROW_56_Left_175 VDD VSS gf180mcu_fd_sc_mcu7t5v0__endcap
XFILLER_12_317 VDD VDD VSS VSS gf180mcu_fd_sc_mcu7t5v0__fillcap_64
XTAP_TAPCELL_ROW_35_673 VDD VSS gf180mcu_fd_sc_mcu7t5v0__filltie
XANTENNA_40 _2280_/ZN VDD VDD VSS VSS gf180mcu_fd_sc_mcu7t5v0__antenna
XFILLER_20_383 VDD VDD VSS VSS gf180mcu_fd_sc_mcu7t5v0__fill_2
XPHY_EDGE_ROW_65_Left_184 VDD VSS gf180mcu_fd_sc_mcu7t5v0__endcap
XTAP_TAPCELL_ROW_7_343 VDD VSS gf180mcu_fd_sc_mcu7t5v0__filltie
XFILLER_0_766 VDD VDD VSS VSS gf180mcu_fd_sc_mcu7t5v0__fill_2
XFILLER_48_715 VDD VDD VSS VSS gf180mcu_fd_sc_mcu7t5v0__fillcap_4
XFILLER_48_726 VDD VDD VSS VSS gf180mcu_fd_sc_mcu7t5v0__fillcap_8
XFILLER_48_737 VDD VDD VSS VSS gf180mcu_fd_sc_mcu7t5v0__fillcap_32
XFILLER_87_372 VDD VDD VSS VSS gf180mcu_fd_sc_mcu7t5v0__fill_1
XFILLER_90_504 VDD VDD VSS VSS gf180mcu_fd_sc_mcu7t5v0__fill_2
XPHY_EDGE_ROW_74_Left_193 VDD VSS gf180mcu_fd_sc_mcu7t5v0__endcap
XFILLER_16_667 VDD VDD VSS VSS gf180mcu_fd_sc_mcu7t5v0__fillcap_64
XFILLER_31_626 VDD VDD VSS VSS gf180mcu_fd_sc_mcu7t5v0__fillcap_4
XTAP_TAPCELL_ROW_96_1406 VDD VSS gf180mcu_fd_sc_mcu7t5v0__filltie
XFILLER_98_604 VDD VDD VSS VSS gf180mcu_fd_sc_mcu7t5v0__fill_1
X_2221_ _2221_/A1 _1213_/B _2235_/B _2221_/C _2223_/B1 VDD VDD VSS VSS gf180mcu_fd_sc_mcu7t5v0__oai211_1
XFILLER_38_225 VDD VDD VSS VSS gf180mcu_fd_sc_mcu7t5v0__fill_2
XFILLER_66_523 VDD VDD VSS VSS gf180mcu_fd_sc_mcu7t5v0__fill_2
X_2152_ _2152_/A1 _2171_/B _2152_/B1 _2152_/B2 _2152_/ZN VDD VDD VSS VSS gf180mcu_fd_sc_mcu7t5v0__aoi22_1
XFILLER_38_247 VDD VDD VSS VSS gf180mcu_fd_sc_mcu7t5v0__fillcap_16
X_2083_ _1066_/I _2551_/Q _2184_/A1 _2347_/A2 _2084_/A2 VDD VDD VSS VSS gf180mcu_fd_sc_mcu7t5v0__aoi22_1
X_1103_ _2570_/Q _1109_/A2 _1106_/A2 VDD VDD VSS VSS gf180mcu_fd_sc_mcu7t5v0__nor2_1
XTAP_TAPCELL_ROW_105_1513 VDD VSS gf180mcu_fd_sc_mcu7t5v0__filltie
XFILLER_81_537 VDD VDD VSS VSS gf180mcu_fd_sc_mcu7t5v0__fillcap_8
XFILLER_46_291 VDD VDD VSS VSS gf180mcu_fd_sc_mcu7t5v0__fill_1
XFILLER_81_559 VDD VDD VSS VSS gf180mcu_fd_sc_mcu7t5v0__fill_1
XTAP_TAPCELL_ROW_60_974 VDD VSS gf180mcu_fd_sc_mcu7t5v0__filltie
XTAP_TAPCELL_ROW_32_643 VDD VSS gf180mcu_fd_sc_mcu7t5v0__filltie
X_1936_ _1936_/A1 _1938_/A2 _1958_/B1 _1936_/B2 _1937_/I VDD VDD VSS VSS gf180mcu_fd_sc_mcu7t5v0__aoi22_1
X_1867_ _1867_/I _1867_/ZN VDD VDD VSS VSS gf180mcu_fd_sc_mcu7t5v0__clkinv_1
Xinput60 tl_d_dmem_i[62] input60/Z VDD VDD VSS VSS gf180mcu_fd_sc_mcu7t5v0__dlyd_1
Xinput71 tl_d_esram_i[12] input71/Z VDD VDD VSS VSS gf180mcu_fd_sc_mcu7t5v0__dlyd_1
Xinput82 tl_d_esram_i[22] input82/Z VDD VDD VSS VSS gf180mcu_fd_sc_mcu7t5v0__dlyd_1
X_1798_ _1988_/A1 _1826_/A2 _1814_/B1 _2726_/I _1799_/I VDD VDD VSS VSS gf180mcu_fd_sc_mcu7t5v0__aoi22_1
Xinput93 tl_d_esram_i[32] input93/Z VDD VDD VSS VSS gf180mcu_fd_sc_mcu7t5v0__dlyd_1
XTAP_TAPCELL_ROW_116_1653 VDD VSS gf180mcu_fd_sc_mcu7t5v0__filltie
XFILLER_107_36 VDD VDD VSS VSS gf180mcu_fd_sc_mcu7t5v0__fill_1
XFILLER_89_626 VDD VDD VSS VSS gf180mcu_fd_sc_mcu7t5v0__fillcap_4
XFILLER_29_203 VDD VDD VSS VSS gf180mcu_fd_sc_mcu7t5v0__fillcap_4
X_2419_ _2562_/Q _2434_/B _2429_/A1 VDD VDD VSS VSS gf180mcu_fd_sc_mcu7t5v0__nand2_1
XTAP_TAPCELL_ROW_4_302 VDD VSS gf180mcu_fd_sc_mcu7t5v0__filltie
XFILLER_111_480 VDD VDD VSS VSS gf180mcu_fd_sc_mcu7t5v0__fillcap_4
XFILLER_57_556 VDD VDD VSS VSS gf180mcu_fd_sc_mcu7t5v0__fillcap_4
XFILLER_37_291 VDD VDD VSS VSS gf180mcu_fd_sc_mcu7t5v0__fillcap_4
XFILLER_13_626 VDD VDD VSS VSS gf180mcu_fd_sc_mcu7t5v0__fillcap_4
XTAP_TAPCELL_ROW_80_1218 VDD VSS gf180mcu_fd_sc_mcu7t5v0__filltie
XFILLER_32_32 VDD VDD VSS VSS gf180mcu_fd_sc_mcu7t5v0__fill_2
XFILLER_5_858 VDD VDD VSS VSS gf180mcu_fd_sc_mcu7t5v0__fillcap_8
XTAP_TAPCELL_ROW_91_1347 VDD VSS gf180mcu_fd_sc_mcu7t5v0__filltie
XFILLER_95_607 VDD VDD VSS VSS gf180mcu_fd_sc_mcu7t5v0__fillcap_8
Xinput420 tl_h_i_i[33] _1920_/A1 VDD VDD VSS VSS gf180mcu_fd_sc_mcu7t5v0__dlyd_1
XFILLER_79_158 VDD VDD VSS VSS gf180mcu_fd_sc_mcu7t5v0__fill_2
Xinput431 tl_h_i_i[43] _1940_/A1 VDD VDD VSS VSS gf180mcu_fd_sc_mcu7t5v0__dlyd_1
Xinput442 tl_h_i_i[53] _1960_/A1 VDD VDD VSS VSS gf180mcu_fd_sc_mcu7t5v0__dlyd_1
Xinput453 tl_h_i_i[63] _1980_/A1 VDD VDD VSS VSS gf180mcu_fd_sc_mcu7t5v0__dlyd_1
Xinput464 tl_h_i_i[73] _2000_/A1 VDD VDD VSS VSS gf180mcu_fd_sc_mcu7t5v0__dlyd_1
Xinput475 tl_h_i_i[83] _1164_/A2 VDD VDD VSS VSS gf180mcu_fd_sc_mcu7t5v0__dlyd_1
Xinput486 tl_h_i_i[93] _1161_/A1 VDD VDD VSS VSS gf180mcu_fd_sc_mcu7t5v0__dlyd_1
XPHY_EDGE_ROW_82_Left_201 VDD VSS gf180mcu_fd_sc_mcu7t5v0__endcap
XFILLER_87_191 VDD VDD VSS VSS gf180mcu_fd_sc_mcu7t5v0__fillcap_4
XFILLER_90_312 VDD VDD VSS VSS gf180mcu_fd_sc_mcu7t5v0__fill_2
XFILLER_63_559 VDD VDD VSS VSS gf180mcu_fd_sc_mcu7t5v0__fill_1
XFILLER_90_345 VDD VDD VSS VSS gf180mcu_fd_sc_mcu7t5v0__fillcap_32
XFILLER_31_489 VDD VDD VSS VSS gf180mcu_fd_sc_mcu7t5v0__fill_1
X_2770_ _2770_/I _2770_/Z VDD VDD VSS VSS gf180mcu_fd_sc_mcu7t5v0__buf_1
XTAP_TAPCELL_ROW_100_1454 VDD VSS gf180mcu_fd_sc_mcu7t5v0__filltie
XPHY_EDGE_ROW_91_Left_210 VDD VSS gf180mcu_fd_sc_mcu7t5v0__endcap
X_1721_ _1721_/I _1721_/ZN VDD VDD VSS VSS gf180mcu_fd_sc_mcu7t5v0__clkinv_1
X_1652_ _1856_/B2 _1664_/S _1652_/Z VDD VDD VSS VSS gf180mcu_fd_sc_mcu7t5v0__or2_1
Xoutput927 _1271_/ZN tl_h_d_o[17] VDD VDD VSS VSS gf180mcu_fd_sc_mcu7t5v0__dlyd_1
Xoutput916 _2757_/Z tl_d_uart_o[98] VDD VDD VSS VSS gf180mcu_fd_sc_mcu7t5v0__dlyd_1
Xoutput905 _2747_/Z tl_d_uart_o[88] VDD VDD VSS VSS gf180mcu_fd_sc_mcu7t5v0__dlyd_1
Xoutput949 _1431_/ZN tl_h_d_o[37] VDD VDD VSS VSS gf180mcu_fd_sc_mcu7t5v0__dlyd_1
Xoutput938 _1351_/ZN tl_h_d_o[27] VDD VDD VSS VSS gf180mcu_fd_sc_mcu7t5v0__dlyd_1
X_1583_ _2748_/I _2736_/I _1556_/Z _1583_/Z VDD VDD VSS VSS gf180mcu_fd_sc_mcu7t5v0__xor3_1
XFILLER_98_489 VDD VDD VSS VSS gf180mcu_fd_sc_mcu7t5v0__fillcap_16
X_2204_ _2204_/A1 _2224_/C _2204_/B1 _2204_/B2 _2204_/ZN VDD VDD VSS VSS gf180mcu_fd_sc_mcu7t5v0__aoi22_1
XTAP_TAPCELL_ROW_111_1594 VDD VSS gf180mcu_fd_sc_mcu7t5v0__filltie
XTAP_TAPCELL_ROW_111_1583 VDD VSS gf180mcu_fd_sc_mcu7t5v0__filltie
Xfanout1180 _2343_/A2 _2347_/A2 VDD VDD VSS VSS gf180mcu_fd_sc_mcu7t5v0__dlyd_1
Xfanout1191 _1508_/B2 _1476_/B2 VDD VDD VSS VSS gf180mcu_fd_sc_mcu7t5v0__dlyd_1
X_2135_ _2135_/A1 _2172_/A2 _2154_/A2 _2135_/B2 _2135_/C _2135_/ZN VDD VDD VSS VSS
+ gf180mcu_fd_sc_mcu7t5v0__aoi221_2
XFILLER_94_651 VDD VDD VSS VSS gf180mcu_fd_sc_mcu7t5v0__fill_1
XFILLER_94_640 VDD VDD VSS VSS gf180mcu_fd_sc_mcu7t5v0__fill_1
XTAP_TAPCELL_ROW_37_702 VDD VSS gf180mcu_fd_sc_mcu7t5v0__filltie
X_2066_ _2066_/A1 _2066_/A2 _2066_/ZN VDD VDD VSS VSS gf180mcu_fd_sc_mcu7t5v0__nand2_1
XFILLER_41_209 VDD VDD VSS VSS gf180mcu_fd_sc_mcu7t5v0__fill_1
XTAP_TAPCELL_ROW_66_1051 VDD VSS gf180mcu_fd_sc_mcu7t5v0__filltie
XFILLER_22_445 VDD VDD VSS VSS gf180mcu_fd_sc_mcu7t5v0__fillcap_4
XFILLER_10_629 VDD VDD VSS VSS gf180mcu_fd_sc_mcu7t5v0__fillcap_8
X_1919_ _1919_/I _1919_/ZN VDD VDD VSS VSS gf180mcu_fd_sc_mcu7t5v0__clkinv_1
XTAP_TAPCELL_ROW_77_1180 VDD VSS gf180mcu_fd_sc_mcu7t5v0__filltie
XFILLER_89_434 VDD VDD VSS VSS gf180mcu_fd_sc_mcu7t5v0__fill_2
XFILLER_89_489 VDD VDD VSS VSS gf180mcu_fd_sc_mcu7t5v0__fill_1
XFILLER_76_128 VDD VDD VSS VSS gf180mcu_fd_sc_mcu7t5v0__fill_2
XFILLER_85_684 VDD VDD VSS VSS gf180mcu_fd_sc_mcu7t5v0__fillcap_16
XFILLER_85_673 VDD VDD VSS VSS gf180mcu_fd_sc_mcu7t5v0__fillcap_4
XFILLER_45_559 VDD VDD VSS VSS gf180mcu_fd_sc_mcu7t5v0__fill_1
XFILLER_53_570 VDD VDD VSS VSS gf180mcu_fd_sc_mcu7t5v0__fill_2
XFILLER_9_416 VDD VDD VSS VSS gf180mcu_fd_sc_mcu7t5v0__fillcap_4
XFILLER_40_275 VDD VDD VSS VSS gf180mcu_fd_sc_mcu7t5v0__fillcap_8
XFILLER_95_415 VDD VDD VSS VSS gf180mcu_fd_sc_mcu7t5v0__fillcap_4
Xxbar_tlul_2to4_1254 tl_d_esram_o[91] VDD VDD VSS VSS gf180mcu_fd_sc_mcu7t5v0__tiel
Xxbar_tlul_2to4_1265 tl_d_rom_o[95] VDD VDD VSS VSS gf180mcu_fd_sc_mcu7t5v0__tiel
Xxbar_tlul_2to4_1276 tl_d_rom_o[84] VDD VDD VSS VSS gf180mcu_fd_sc_mcu7t5v0__tiel
XFILLER_95_448 VDD VDD VSS VSS gf180mcu_fd_sc_mcu7t5v0__fillcap_32
XFILLER_68_94 VDD VDD VSS VSS gf180mcu_fd_sc_mcu7t5v0__fillcap_8
XFILLER_68_83 VDD VDD VSS VSS gf180mcu_fd_sc_mcu7t5v0__fill_1
Xinput250 tl_d_uart_i[55] _1101_/I VDD VDD VSS VSS gf180mcu_fd_sc_mcu7t5v0__dlyd_1
Xinput261 tl_d_uart_i[65] _1215_/A1 VDD VDD VSS VSS gf180mcu_fd_sc_mcu7t5v0__dlyd_1
Xinput272 tl_h_d_i[105] _2764_/I VDD VDD VSS VSS gf180mcu_fd_sc_mcu7t5v0__clkbuf_2
Xinput283 tl_h_d_i[12] _1878_/B2 VDD VDD VSS VSS gf180mcu_fd_sc_mcu7t5v0__dlyd_1
Xinput294 tl_h_d_i[22] _2713_/I VDD VDD VSS VSS gf180mcu_fd_sc_mcu7t5v0__clkbuf_2
XFILLER_91_632 VDD VDD VSS VSS gf180mcu_fd_sc_mcu7t5v0__fillcap_16
XFILLER_23_209 VDD VDD VSS VSS gf180mcu_fd_sc_mcu7t5v0__fill_1
XFILLER_91_698 VDD VDD VSS VSS gf180mcu_fd_sc_mcu7t5v0__fill_2
XTAP_TAPCELL_ROW_42_760 VDD VSS gf180mcu_fd_sc_mcu7t5v0__filltie
X_2753_ _2753_/I _2753_/Z VDD VDD VSS VSS gf180mcu_fd_sc_mcu7t5v0__buf_1
X_1704_ _1894_/A1 _1720_/A2 _1720_/B1 _2711_/I _1705_/I VDD VDD VSS VSS gf180mcu_fd_sc_mcu7t5v0__aoi22_1
X_2684_ _2756_/I _2684_/Z VDD VDD VSS VSS gf180mcu_fd_sc_mcu7t5v0__buf_1
Xoutput702 _1871_/ZN tl_d_esram_o[8] VDD VDD VSS VSS gf180mcu_fd_sc_mcu7t5v0__dlyd_1
Xoutput735 _1709_/ZN tl_d_rom_o[22] VDD VDD VSS VSS gf180mcu_fd_sc_mcu7t5v0__dlyd_1
Xoutput724 _1689_/ZN tl_d_rom_o[12] VDD VDD VSS VSS gf180mcu_fd_sc_mcu7t5v0__dlyd_1
Xoutput713 _1841_/ZN tl_d_rom_o[105] VDD VDD VSS VSS gf180mcu_fd_sc_mcu7t5v0__dlyd_1
X_1635_ _1942_/B2 _1641_/A2 _1635_/Z VDD VDD VSS VSS gf180mcu_fd_sc_mcu7t5v0__or2_1
XTAP_TAPCELL_ROW_113_1612 VDD VSS gf180mcu_fd_sc_mcu7t5v0__filltie
Xoutput779 _1789_/ZN tl_d_rom_o[62] VDD VDD VSS VSS gf180mcu_fd_sc_mcu7t5v0__dlyd_1
Xoutput768 _1769_/ZN tl_d_rom_o[52] VDD VDD VSS VSS gf180mcu_fd_sc_mcu7t5v0__dlyd_1
Xoutput757 _1749_/ZN tl_d_rom_o[42] VDD VDD VSS VSS gf180mcu_fd_sc_mcu7t5v0__dlyd_1
Xoutput746 _1729_/ZN tl_d_rom_o[32] VDD VDD VSS VSS gf180mcu_fd_sc_mcu7t5v0__dlyd_1
X_1566_ _2734_/I _2733_/I _2735_/I _1566_/Z VDD VDD VSS VSS gf180mcu_fd_sc_mcu7t5v0__xor3_1
XFILLER_59_607 VDD VDD VSS VSS gf180mcu_fd_sc_mcu7t5v0__fillcap_16
XFILLER_59_629 VDD VDD VSS VSS gf180mcu_fd_sc_mcu7t5v0__fill_1
XFILLER_58_117 VDD VDD VSS VSS gf180mcu_fd_sc_mcu7t5v0__fillcap_32
X_1497_ _2218_/A2 _2373_/A2 _1497_/Z VDD VDD VSS VSS gf180mcu_fd_sc_mcu7t5v0__and2_1
XFILLER_54_312 VDD VDD VSS VSS gf180mcu_fd_sc_mcu7t5v0__fill_2
X_2118_ _2118_/A1 _2118_/A2 _2118_/B _2118_/ZN VDD VDD VSS VSS gf180mcu_fd_sc_mcu7t5v0__oai21_1
XFILLER_42_529 VDD VDD VSS VSS gf180mcu_fd_sc_mcu7t5v0__fill_1
X_2049_ _2049_/I _2049_/ZN VDD VDD VSS VSS gf180mcu_fd_sc_mcu7t5v0__clkinv_1
XTAP_TAPCELL_ROW_20_498 VDD VSS gf180mcu_fd_sc_mcu7t5v0__filltie
XFILLER_49_139 VDD VDD VSS VSS gf180mcu_fd_sc_mcu7t5v0__fill_1
XFILLER_85_470 VDD VDD VSS VSS gf180mcu_fd_sc_mcu7t5v0__fillcap_8
XFILLER_45_345 VDD VDD VSS VSS gf180mcu_fd_sc_mcu7t5v0__fillcap_4
XFILLER_85_492 VDD VDD VSS VSS gf180mcu_fd_sc_mcu7t5v0__fillcap_4
XFILLER_73_632 VDD VDD VSS VSS gf180mcu_fd_sc_mcu7t5v0__fillcap_32
XFILLER_72_131 VDD VDD VSS VSS gf180mcu_fd_sc_mcu7t5v0__fillcap_4
XTAP_TAPCELL_ROW_28_598 VDD VSS gf180mcu_fd_sc_mcu7t5v0__filltie
XTAP_TAPCELL_ROW_28_587 VDD VSS gf180mcu_fd_sc_mcu7t5v0__filltie
XFILLER_41_562 VDD VDD VSS VSS gf180mcu_fd_sc_mcu7t5v0__fillcap_32
XFILLER_9_224 VDD VDD VSS VSS gf180mcu_fd_sc_mcu7t5v0__fillcap_16
XFILLER_13_286 VDD VDD VSS VSS gf180mcu_fd_sc_mcu7t5v0__fill_2
XFILLER_9_279 VDD VDD VSS VSS gf180mcu_fd_sc_mcu7t5v0__fill_1
X_1420_ input31/Z _1468_/A2 _1420_/B1 _1444_/B2 _1421_/I VDD VDD VSS VSS gf180mcu_fd_sc_mcu7t5v0__aoi22_1
XPHY_EDGE_ROW_10_Left_129 VDD VSS gf180mcu_fd_sc_mcu7t5v0__endcap
X_1351_ _1407_/A1 _1351_/A2 _1351_/ZN VDD VDD VSS VSS gf180mcu_fd_sc_mcu7t5v0__nor2_1
X_1282_ input78/Z _2116_/B1 _2259_/A3 _1283_/B VDD VDD VSS VSS gf180mcu_fd_sc_mcu7t5v0__nand3_1
XFILLER_49_662 VDD VDD VSS VSS gf180mcu_fd_sc_mcu7t5v0__fillcap_32
XFILLER_83_429 VDD VDD VSS VSS gf180mcu_fd_sc_mcu7t5v0__fill_1
XFILLER_48_172 VDD VDD VSS VSS gf180mcu_fd_sc_mcu7t5v0__fill_2
XFILLER_63_120 VDD VDD VSS VSS gf180mcu_fd_sc_mcu7t5v0__fillcap_4
XFILLER_64_632 VDD VDD VSS VSS gf180mcu_fd_sc_mcu7t5v0__fill_1
XFILLER_64_654 VDD VDD VSS VSS gf180mcu_fd_sc_mcu7t5v0__fillcap_8
XFILLER_63_142 VDD VDD VSS VSS gf180mcu_fd_sc_mcu7t5v0__fillcap_8
XTAP_TAPCELL_ROW_63_1010 VDD VSS gf180mcu_fd_sc_mcu7t5v0__filltie
XFILLER_118_645 VDD VDD VSS VSS gf180mcu_fd_sc_mcu7t5v0__fill_1
X_2736_ _2736_/I _2736_/Z VDD VDD VSS VSS gf180mcu_fd_sc_mcu7t5v0__buf_1
XFILLER_106_829 VDD VDD VSS VSS gf180mcu_fd_sc_mcu7t5v0__fill_2
X_2667_ _2739_/I _2667_/Z VDD VDD VSS VSS gf180mcu_fd_sc_mcu7t5v0__buf_1
Xoutput510 _1588_/Z tl_d_dmem_o[11] VDD VDD VSS VSS gf180mcu_fd_sc_mcu7t5v0__dlyd_1
Xoutput521 _2640_/Z tl_d_dmem_o[21] VDD VDD VSS VSS gf180mcu_fd_sc_mcu7t5v0__dlyd_1
Xoutput532 _1514_/Z tl_d_dmem_o[31] VDD VDD VSS VSS gf180mcu_fd_sc_mcu7t5v0__dlyd_1
Xoutput543 _1524_/Z tl_d_dmem_o[41] VDD VDD VSS VSS gf180mcu_fd_sc_mcu7t5v0__dlyd_1
Xoutput554 _1534_/Z tl_d_dmem_o[51] VDD VDD VSS VSS gf180mcu_fd_sc_mcu7t5v0__dlyd_1
X_1618_ _1560_/Z _1616_/Z _1617_/Z _1618_/Z VDD VDD VSS VSS gf180mcu_fd_sc_mcu7t5v0__xor3_1
X_2598_ _2598_/D _2601_/RN clkload5/I _2598_/Q VDD VDD VSS VSS gf180mcu_fd_sc_mcu7t5v0__dffrnq_1
Xoutput565 _2648_/Z tl_d_dmem_o[61] VDD VDD VSS VSS gf180mcu_fd_sc_mcu7t5v0__dlyd_1
Xoutput576 _2658_/Z tl_d_dmem_o[71] VDD VDD VSS VSS gf180mcu_fd_sc_mcu7t5v0__dlyd_1
Xoutput587 _2668_/Z tl_d_dmem_o[81] VDD VDD VSS VSS gf180mcu_fd_sc_mcu7t5v0__dlyd_1
XTAP_TAPCELL_ROW_74_1150 VDD VSS gf180mcu_fd_sc_mcu7t5v0__filltie
XFILLER_99_562 VDD VDD VSS VSS gf180mcu_fd_sc_mcu7t5v0__fillcap_8
XFILLER_87_702 VDD VDD VSS VSS gf180mcu_fd_sc_mcu7t5v0__fillcap_32
Xoutput598 _2678_/Z tl_d_dmem_o[91] VDD VDD VSS VSS gf180mcu_fd_sc_mcu7t5v0__dlyd_1
X_1549_ _1657_/A1 _1550_/A2 _1549_/ZN VDD VDD VSS VSS gf180mcu_fd_sc_mcu7t5v0__nor2_1
XFILLER_87_768 VDD VDD VSS VSS gf180mcu_fd_sc_mcu7t5v0__fill_2
XFILLER_55_632 VDD VDD VSS VSS gf180mcu_fd_sc_mcu7t5v0__fillcap_64
XFILLER_67_492 VDD VDD VSS VSS gf180mcu_fd_sc_mcu7t5v0__fillcap_8
XFILLER_27_345 VDD VDD VSS VSS gf180mcu_fd_sc_mcu7t5v0__fillcap_4
XFILLER_70_613 VDD VDD VSS VSS gf180mcu_fd_sc_mcu7t5v0__fill_2
XTAP_TAPCELL_ROW_25_557 VDD VSS gf180mcu_fd_sc_mcu7t5v0__filltie
XFILLER_70_657 VDD VDD VSS VSS gf180mcu_fd_sc_mcu7t5v0__fillcap_8
XFILLER_11_702 VDD VDD VSS VSS gf180mcu_fd_sc_mcu7t5v0__fillcap_32
XFILLER_23_562 VDD VDD VSS VSS gf180mcu_fd_sc_mcu7t5v0__fillcap_64
XTAP_TAPCELL_ROW_53_888 VDD VSS gf180mcu_fd_sc_mcu7t5v0__filltie
XFILLER_50_381 VDD VDD VSS VSS gf180mcu_fd_sc_mcu7t5v0__fillcap_4
XFILLER_40_10 VDD VDD VSS VSS gf180mcu_fd_sc_mcu7t5v0__fillcap_4
XFILLER_6_2 VDD VDD VSS VSS gf180mcu_fd_sc_mcu7t5v0__fillcap_8
XFILLER_77_212 VDD VDD VSS VSS gf180mcu_fd_sc_mcu7t5v0__fillcap_8
XFILLER_18_301 VDD VDD VSS VSS gf180mcu_fd_sc_mcu7t5v0__fillcap_8
XTAP_TAPCELL_ROW_88_1308 VDD VSS gf180mcu_fd_sc_mcu7t5v0__filltie
XFILLER_33_348 VDD VDD VSS VSS gf180mcu_fd_sc_mcu7t5v0__fill_2
XTAP_TAPCELL_ROW_99_1448 VDD VSS gf180mcu_fd_sc_mcu7t5v0__filltie
X_2521_ _2507_/B _2518_/Z _2522_/B _2521_/B _2595_/D VDD VDD VSS VSS gf180mcu_fd_sc_mcu7t5v0__oai31_1
X_2452_ _2567_/Q _2452_/A2 _2567_/D VDD VDD VSS VSS gf180mcu_fd_sc_mcu7t5v0__xor2_1
XFILLER_69_702 VDD VDD VSS VSS gf180mcu_fd_sc_mcu7t5v0__fillcap_64
X_2383_ _2383_/A1 _2383_/A2 _2401_/S VDD VDD VSS VSS gf180mcu_fd_sc_mcu7t5v0__or2_1
X_1403_ _1491_/A1 _1401_/Z _1403_/B _1404_/B1 VDD VDD VSS VSS gf180mcu_fd_sc_mcu7t5v0__oai21_1
XPHY_EDGE_ROW_18_Right_18 VDD VSS gf180mcu_fd_sc_mcu7t5v0__endcap
X_1334_ _1334_/A1 _1406_/A2 _1334_/B1 _1390_/B2 _1335_/A2 VDD VDD VSS VSS gf180mcu_fd_sc_mcu7t5v0__aoi22_1
XFILLER_96_543 VDD VDD VSS VSS gf180mcu_fd_sc_mcu7t5v0__fillcap_8
XFILLER_56_407 VDD VDD VSS VSS gf180mcu_fd_sc_mcu7t5v0__fill_1
X_1265_ _1393_/A1 _2257_/A2 _1265_/Z VDD VDD VSS VSS gf180mcu_fd_sc_mcu7t5v0__and2_1
XFILLER_37_632 VDD VDD VSS VSS gf180mcu_fd_sc_mcu7t5v0__fillcap_64
XFILLER_49_492 VDD VDD VSS VSS gf180mcu_fd_sc_mcu7t5v0__fillcap_8
Xinput3 tl_d_dmem_i[10] input3/Z VDD VDD VSS VSS gf180mcu_fd_sc_mcu7t5v0__dlyd_1
X_1196_ _1195_/B _1196_/A2 _1200_/C _1196_/C _1196_/ZN VDD VDD VSS VSS gf180mcu_fd_sc_mcu7t5v0__aoi211_1
XTAP_TAPCELL_ROW_108_1555 VDD VSS gf180mcu_fd_sc_mcu7t5v0__filltie
XFILLER_52_613 VDD VDD VSS VSS gf180mcu_fd_sc_mcu7t5v0__fillcap_8
XPHY_EDGE_ROW_27_Right_27 VDD VSS gf180mcu_fd_sc_mcu7t5v0__endcap
XTAP_TAPCELL_ROW_22_516 VDD VSS gf180mcu_fd_sc_mcu7t5v0__filltie
XFILLER_20_521 VDD VDD VSS VSS gf180mcu_fd_sc_mcu7t5v0__fillcap_4
XTAP_TAPCELL_ROW_50_858 VDD VSS gf180mcu_fd_sc_mcu7t5v0__filltie
X_2719_ _2719_/I _2719_/Z VDD VDD VSS VSS gf180mcu_fd_sc_mcu7t5v0__buf_1
XPHY_EDGE_ROW_36_Right_36 VDD VSS gf180mcu_fd_sc_mcu7t5v0__endcap
XFILLER_101_364 VDD VDD VSS VSS gf180mcu_fd_sc_mcu7t5v0__fillcap_32
XFILLER_59_278 VDD VDD VSS VSS gf180mcu_fd_sc_mcu7t5v0__fill_2
XTAP_TAPCELL_ROW_58_958 VDD VSS gf180mcu_fd_sc_mcu7t5v0__filltie
XTAP_TAPCELL_ROW_58_947 VDD VSS gf180mcu_fd_sc_mcu7t5v0__filltie
XTAP_TAPCELL_ROW_2_285 VDD VSS gf180mcu_fd_sc_mcu7t5v0__filltie
XPHY_EDGE_ROW_45_Right_45 VDD VSS gf180mcu_fd_sc_mcu7t5v0__endcap
XFILLER_27_197 VDD VDD VSS VSS gf180mcu_fd_sc_mcu7t5v0__fillcap_4
XTAP_TAPCELL_ROW_83_1249 VDD VSS gf180mcu_fd_sc_mcu7t5v0__filltie
XPHY_EDGE_ROW_54_Right_54 VDD VSS gf180mcu_fd_sc_mcu7t5v0__endcap
XTAP_TAPCELL_ROW_94_1389 VDD VSS gf180mcu_fd_sc_mcu7t5v0__filltie
XFILLER_78_543 VDD VDD VSS VSS gf180mcu_fd_sc_mcu7t5v0__fillcap_8
XFILLER_19_632 VDD VDD VSS VSS gf180mcu_fd_sc_mcu7t5v0__fillcap_64
XPHY_EDGE_ROW_63_Right_63 VDD VSS gf180mcu_fd_sc_mcu7t5v0__endcap
XFILLER_93_579 VDD VDD VSS VSS gf180mcu_fd_sc_mcu7t5v0__fillcap_4
XFILLER_80_218 VDD VDD VSS VSS gf180mcu_fd_sc_mcu7t5v0__fill_2
XFILLER_34_657 VDD VDD VSS VSS gf180mcu_fd_sc_mcu7t5v0__fillcap_8
XFILLER_61_476 VDD VDD VSS VSS gf180mcu_fd_sc_mcu7t5v0__fillcap_8
X_1952_ _1952_/A1 _1964_/A2 _1952_/B1 _1952_/B2 _1953_/I VDD VDD VSS VSS gf180mcu_fd_sc_mcu7t5v0__aoi22_1
XTAP_TAPCELL_ROW_103_1496 VDD VSS gf180mcu_fd_sc_mcu7t5v0__filltie
X_1883_ _1883_/I _1883_/ZN VDD VDD VSS VSS gf180mcu_fd_sc_mcu7t5v0__clkinv_1
XPHY_EDGE_ROW_72_Right_72 VDD VSS gf180mcu_fd_sc_mcu7t5v0__endcap
Xoutput1001 _2288_/ZN tl_h_i_o[24] VDD VDD VSS VSS gf180mcu_fd_sc_mcu7t5v0__dlyd_1
Xoutput1012 _2328_/ZN tl_h_i_o[34] VDD VDD VSS VSS gf180mcu_fd_sc_mcu7t5v0__dlyd_1
Xoutput1023 _2368_/ZN tl_h_i_o[44] VDD VDD VSS VSS gf180mcu_fd_sc_mcu7t5v0__dlyd_1
X_2504_ _2491_/Z _2504_/A2 _2504_/A3 _2504_/B _2507_/A2 VDD VDD VSS VSS gf180mcu_fd_sc_mcu7t5v0__oai31_1
XFILLER_115_489 VDD VDD VSS VSS gf180mcu_fd_sc_mcu7t5v0__fill_1
Xoutput1034 _2098_/ZN tl_h_i_o[54] VDD VDD VSS VSS gf180mcu_fd_sc_mcu7t5v0__dlyd_1
Xoutput1045 _1245_/ZN tl_h_i_o[64] VDD VDD VSS VSS gf180mcu_fd_sc_mcu7t5v0__dlyd_1
X_2435_ _2435_/I _2436_/C VDD VDD VSS VSS gf180mcu_fd_sc_mcu7t5v0__clkinv_1
XPHY_EDGE_ROW_102_Left_221 VDD VSS gf180mcu_fd_sc_mcu7t5v0__endcap
XFILLER_29_418 VDD VDD VSS VSS gf180mcu_fd_sc_mcu7t5v0__fill_2
X_2366_ _2374_/A1 _2366_/A2 _2368_/A1 VDD VDD VSS VSS gf180mcu_fd_sc_mcu7t5v0__nand2_1
X_2297_ _2357_/A1 _2297_/A2 _2298_/A2 VDD VDD VSS VSS gf180mcu_fd_sc_mcu7t5v0__nand2_1
X_1317_ _1317_/I _1318_/B1 VDD VDD VSS VSS gf180mcu_fd_sc_mcu7t5v0__clkinv_1
XPHY_EDGE_ROW_81_Right_81 VDD VSS gf180mcu_fd_sc_mcu7t5v0__endcap
XFILLER_84_524 VDD VDD VSS VSS gf180mcu_fd_sc_mcu7t5v0__fill_1
X_1248_ _1248_/A1 _1248_/A2 _1248_/A3 _1248_/ZN VDD VDD VSS VSS gf180mcu_fd_sc_mcu7t5v0__nor3_1
XTAP_TAPCELL_ROW_55_917 VDD VSS gf180mcu_fd_sc_mcu7t5v0__filltie
X_1179_ _1179_/A1 _1179_/A2 _1179_/A3 _1190_/A2 VDD VDD VSS VSS gf180mcu_fd_sc_mcu7t5v0__nand3_1
XTAP_TAPCELL_ROW_69_1082 VDD VSS gf180mcu_fd_sc_mcu7t5v0__filltie
XFILLER_52_454 VDD VDD VSS VSS gf180mcu_fd_sc_mcu7t5v0__fill_1
XTAP_TAPCELL_ROW_35_674 VDD VSS gf180mcu_fd_sc_mcu7t5v0__filltie
XPHY_EDGE_ROW_111_Left_230 VDD VSS gf180mcu_fd_sc_mcu7t5v0__endcap
XANTENNA_30 _2764_/I VDD VDD VSS VSS gf180mcu_fd_sc_mcu7t5v0__antenna
XANTENNA_41 _2095_/ZN VDD VDD VSS VSS gf180mcu_fd_sc_mcu7t5v0__antenna
XPHY_EDGE_ROW_90_Right_90 VDD VSS gf180mcu_fd_sc_mcu7t5v0__endcap
XFILLER_20_395 VDD VDD VSS VSS gf180mcu_fd_sc_mcu7t5v0__fillcap_4
XFILLER_0_712 VDD VDD VSS VSS gf180mcu_fd_sc_mcu7t5v0__fill_2
XTAP_TAPCELL_ROW_7_344 VDD VSS gf180mcu_fd_sc_mcu7t5v0__filltie
XFILLER_87_362 VDD VDD VSS VSS gf180mcu_fd_sc_mcu7t5v0__fillcap_4
XFILLER_75_524 VDD VDD VSS VSS gf180mcu_fd_sc_mcu7t5v0__fillcap_16
XFILLER_62_229 VDD VDD VSS VSS gf180mcu_fd_sc_mcu7t5v0__fill_2
XFILLER_90_527 VDD VDD VSS VSS gf180mcu_fd_sc_mcu7t5v0__fillcap_8
XFILLER_70_240 VDD VDD VSS VSS gf180mcu_fd_sc_mcu7t5v0__fillcap_4
XFILLER_8_823 VDD VDD VSS VSS gf180mcu_fd_sc_mcu7t5v0__fillcap_8
XTAP_TAPCELL_ROW_96_1407 VDD VSS gf180mcu_fd_sc_mcu7t5v0__filltie
X_2220_ _1213_/B _2220_/A2 _2220_/A3 _2221_/C VDD VDD VSS VSS gf180mcu_fd_sc_mcu7t5v0__nand3_1
X_2151_ input3/Z _2236_/A2 _2171_/B _2152_/B2 VDD VDD VSS VSS gf180mcu_fd_sc_mcu7t5v0__aoi21_1
X_2082_ _2181_/A1 _2377_/A1 _2084_/A1 VDD VDD VSS VSS gf180mcu_fd_sc_mcu7t5v0__nand2_1
X_1102_ _1102_/I _2237_/A1 VDD VDD VSS VSS gf180mcu_fd_sc_mcu7t5v0__clkinv_1
XFILLER_81_505 VDD VDD VSS VSS gf180mcu_fd_sc_mcu7t5v0__fillcap_32
XFILLER_53_207 VDD VDD VSS VSS gf180mcu_fd_sc_mcu7t5v0__fill_2
XTAP_TAPCELL_ROW_105_1514 VDD VSS gf180mcu_fd_sc_mcu7t5v0__filltie
XFILLER_93_376 VDD VDD VSS VSS gf180mcu_fd_sc_mcu7t5v0__fill_1
XFILLER_34_443 VDD VDD VSS VSS gf180mcu_fd_sc_mcu7t5v0__fillcap_8
XFILLER_81_549 VDD VDD VSS VSS gf180mcu_fd_sc_mcu7t5v0__fill_2
X_1935_ _1935_/I _1935_/ZN VDD VDD VSS VSS gf180mcu_fd_sc_mcu7t5v0__clkinv_1
XTAP_TAPCELL_ROW_60_975 VDD VSS gf180mcu_fd_sc_mcu7t5v0__filltie
XTAP_TAPCELL_ROW_32_644 VDD VSS gf180mcu_fd_sc_mcu7t5v0__filltie
X_1866_ _1866_/A1 _1900_/A2 _1900_/B1 _1086_/I _1867_/I VDD VDD VSS VSS gf180mcu_fd_sc_mcu7t5v0__aoi22_1
Xinput50 tl_d_dmem_i[53] input50/Z VDD VDD VSS VSS gf180mcu_fd_sc_mcu7t5v0__dlyd_1
Xinput61 tl_d_dmem_i[63] input61/Z VDD VDD VSS VSS gf180mcu_fd_sc_mcu7t5v0__dlyd_1
Xinput72 tl_d_esram_i[13] input72/Z VDD VDD VSS VSS gf180mcu_fd_sc_mcu7t5v0__dlyd_1
X_1797_ _1797_/I _1797_/ZN VDD VDD VSS VSS gf180mcu_fd_sc_mcu7t5v0__clkinv_1
XTAP_TAPCELL_ROW_116_1643 VDD VSS gf180mcu_fd_sc_mcu7t5v0__filltie
Xinput83 tl_d_esram_i[23] input83/Z VDD VDD VSS VSS gf180mcu_fd_sc_mcu7t5v0__dlyd_1
Xinput94 tl_d_esram_i[33] input94/Z VDD VDD VSS VSS gf180mcu_fd_sc_mcu7t5v0__dlyd_1
XTAP_TAPCELL_ROW_116_1654 VDD VSS gf180mcu_fd_sc_mcu7t5v0__filltie
XFILLER_107_59 VDD VDD VSS VSS gf180mcu_fd_sc_mcu7t5v0__fillcap_8
X_2418_ _2451_/B _2416_/Z _2418_/B _2561_/D VDD VDD VSS VSS gf180mcu_fd_sc_mcu7t5v0__oai21_1
XTAP_TAPCELL_ROW_4_303 VDD VSS gf180mcu_fd_sc_mcu7t5v0__filltie
X_2349_ _2377_/A1 _2349_/A2 _2350_/A2 VDD VDD VSS VSS gf180mcu_fd_sc_mcu7t5v0__nand2_1
XFILLER_84_387 VDD VDD VSS VSS gf180mcu_fd_sc_mcu7t5v0__fillcap_4
XFILLER_25_454 VDD VDD VSS VSS gf180mcu_fd_sc_mcu7t5v0__fillcap_4
XPHY_EDGE_ROW_0_Right_0 VDD VSS gf180mcu_fd_sc_mcu7t5v0__endcap
XFILLER_25_487 VDD VDD VSS VSS gf180mcu_fd_sc_mcu7t5v0__fill_2
XTAP_TAPCELL_ROW_80_1219 VDD VSS gf180mcu_fd_sc_mcu7t5v0__filltie
XFILLER_40_457 VDD VDD VSS VSS gf180mcu_fd_sc_mcu7t5v0__fillcap_16
XTAP_TAPCELL_ROW_91_1348 VDD VSS gf180mcu_fd_sc_mcu7t5v0__filltie
XFILLER_79_137 VDD VDD VSS VSS gf180mcu_fd_sc_mcu7t5v0__fill_2
Xinput410 tl_h_i_i[24] _1902_/A1 VDD VDD VSS VSS gf180mcu_fd_sc_mcu7t5v0__dlyd_1
Xinput421 tl_h_i_i[34] _1922_/A1 VDD VDD VSS VSS gf180mcu_fd_sc_mcu7t5v0__dlyd_1
XFILLER_94_107 VDD VDD VSS VSS gf180mcu_fd_sc_mcu7t5v0__fill_2
Xinput432 tl_h_i_i[44] _1942_/A1 VDD VDD VSS VSS gf180mcu_fd_sc_mcu7t5v0__dlyd_1
Xinput443 tl_h_i_i[54] _1962_/A1 VDD VDD VSS VSS gf180mcu_fd_sc_mcu7t5v0__dlyd_1
Xinput454 tl_h_i_i[64] _1982_/A1 VDD VDD VSS VSS gf180mcu_fd_sc_mcu7t5v0__dlyd_1
Xinput465 tl_h_i_i[74] _2002_/A1 VDD VDD VSS VSS gf180mcu_fd_sc_mcu7t5v0__dlyd_1
Xinput476 tl_h_i_i[84] _1164_/A3 VDD VDD VSS VSS gf180mcu_fd_sc_mcu7t5v0__dlyd_1
Xinput487 tl_h_i_i[94] _1162_/A4 VDD VDD VSS VSS gf180mcu_fd_sc_mcu7t5v0__dlyd_1
XFILLER_35_207 VDD VDD VSS VSS gf180mcu_fd_sc_mcu7t5v0__fill_2
XFILLER_63_516 VDD VDD VSS VSS gf180mcu_fd_sc_mcu7t5v0__fill_1
XFILLER_28_270 VDD VDD VSS VSS gf180mcu_fd_sc_mcu7t5v0__fillcap_16
XFILLER_75_398 VDD VDD VSS VSS gf180mcu_fd_sc_mcu7t5v0__fillcap_16
XFILLER_31_413 VDD VDD VSS VSS gf180mcu_fd_sc_mcu7t5v0__fillcap_4
XFILLER_43_262 VDD VDD VSS VSS gf180mcu_fd_sc_mcu7t5v0__fillcap_16
XTAP_TAPCELL_ROW_100_1455 VDD VSS gf180mcu_fd_sc_mcu7t5v0__filltie
X_1720_ _1910_/A1 _1720_/A2 _1720_/B1 _2719_/I _1721_/I VDD VDD VSS VSS gf180mcu_fd_sc_mcu7t5v0__aoi22_1
X_1651_ _1974_/B2 _1651_/A2 _1651_/Z VDD VDD VSS VSS gf180mcu_fd_sc_mcu7t5v0__or2_1
Xoutput928 _1279_/ZN tl_h_d_o[18] VDD VDD VSS VSS gf180mcu_fd_sc_mcu7t5v0__dlyd_1
Xoutput917 _2758_/Z tl_d_uart_o[99] VDD VDD VSS VSS gf180mcu_fd_sc_mcu7t5v0__dlyd_1
Xoutput906 _2748_/Z tl_d_uart_o[89] VDD VDD VSS VSS gf180mcu_fd_sc_mcu7t5v0__dlyd_1
Xoutput939 _1359_/ZN tl_h_d_o[28] VDD VDD VSS VSS gf180mcu_fd_sc_mcu7t5v0__dlyd_1
X_1582_ _2738_/I _2737_/I _1581_/Z _1582_/Z VDD VDD VSS VSS gf180mcu_fd_sc_mcu7t5v0__xor3_1
XFILLER_98_457 VDD VDD VSS VSS gf180mcu_fd_sc_mcu7t5v0__fillcap_32
X_2203_ input49/Z _2236_/A2 _2236_/B _2204_/B2 VDD VDD VSS VSS gf180mcu_fd_sc_mcu7t5v0__aoi21_1
XTAP_TAPCELL_ROW_111_1584 VDD VSS gf180mcu_fd_sc_mcu7t5v0__filltie
X_2134_ input65/Z _2154_/A2 _2135_/C VDD VDD VSS VSS gf180mcu_fd_sc_mcu7t5v0__nor2_1
XFILLER_26_207 VDD VDD VSS VSS gf180mcu_fd_sc_mcu7t5v0__fill_2
XFILLER_26_218 VDD VDD VSS VSS gf180mcu_fd_sc_mcu7t5v0__fillcap_16
XFILLER_54_527 VDD VDD VSS VSS gf180mcu_fd_sc_mcu7t5v0__fillcap_64
XFILLER_66_376 VDD VDD VSS VSS gf180mcu_fd_sc_mcu7t5v0__fillcap_8
XTAP_TAPCELL_ROW_37_703 VDD VSS gf180mcu_fd_sc_mcu7t5v0__filltie
XFILLER_47_590 VDD VDD VSS VSS gf180mcu_fd_sc_mcu7t5v0__fill_2
X_2065_ _2143_/A1 _2291_/A2 _2066_/A2 VDD VDD VSS VSS gf180mcu_fd_sc_mcu7t5v0__nand2_1
XTAP_TAPCELL_ROW_66_1052 VDD VSS gf180mcu_fd_sc_mcu7t5v0__filltie
XTAP_TAPCELL_ROW_45_791 VDD VSS gf180mcu_fd_sc_mcu7t5v0__filltie
XTAP_TAPCELL_ROW_17_460 VDD VSS gf180mcu_fd_sc_mcu7t5v0__filltie
X_1918_ _1918_/A1 _1938_/A2 _1930_/B1 _1918_/B2 _1919_/I VDD VDD VSS VSS gf180mcu_fd_sc_mcu7t5v0__aoi22_1
X_1849_ _1849_/I _1849_/ZN VDD VDD VSS VSS gf180mcu_fd_sc_mcu7t5v0__clkinv_1
XFILLER_118_36 VDD VDD VSS VSS gf180mcu_fd_sc_mcu7t5v0__fill_1
XTAP_TAPCELL_ROW_77_1181 VDD VSS gf180mcu_fd_sc_mcu7t5v0__filltie
XFILLER_78_18 VDD VDD VSS VSS gf180mcu_fd_sc_mcu7t5v0__fill_1
XFILLER_89_479 VDD VDD VSS VSS gf180mcu_fd_sc_mcu7t5v0__fillcap_8
XFILLER_57_398 VDD VDD VSS VSS gf180mcu_fd_sc_mcu7t5v0__fillcap_16
XFILLER_73_858 VDD VDD VSS VSS gf180mcu_fd_sc_mcu7t5v0__fillcap_8
XFILLER_72_368 VDD VDD VSS VSS gf180mcu_fd_sc_mcu7t5v0__fillcap_16
XFILLER_41_766 VDD VDD VSS VSS gf180mcu_fd_sc_mcu7t5v0__fillcap_4
XFILLER_40_287 VDD VDD VSS VSS gf180mcu_fd_sc_mcu7t5v0__fill_2
XFILLER_40_298 VDD VDD VSS VSS gf180mcu_fd_sc_mcu7t5v0__fillcap_4
Xxbar_tlul_2to4_1255 tl_d_esram_o[90] VDD VDD VSS VSS gf180mcu_fd_sc_mcu7t5v0__tiel
Xxbar_tlul_2to4_1266 tl_d_rom_o[94] VDD VDD VSS VSS gf180mcu_fd_sc_mcu7t5v0__tiel
Xxbar_tlul_2to4_1277 tl_d_rom_o[83] VDD VDD VSS VSS gf180mcu_fd_sc_mcu7t5v0__tiel
Xinput240 tl_d_uart_i[46] _1502_/A1 VDD VDD VSS VSS gf180mcu_fd_sc_mcu7t5v0__dlyd_1
Xinput251 tl_d_uart_i[56] _2225_/A1 VDD VDD VSS VSS gf180mcu_fd_sc_mcu7t5v0__dlyd_1
Xinput262 tl_d_uart_i[6] _2129_/A1 VDD VDD VSS VSS gf180mcu_fd_sc_mcu7t5v0__dlyd_1
XFILLER_88_490 VDD VDD VSS VSS gf180mcu_fd_sc_mcu7t5v0__fillcap_8
XFILLER_36_527 VDD VDD VSS VSS gf180mcu_fd_sc_mcu7t5v0__fillcap_16
XFILLER_48_365 VDD VDD VSS VSS gf180mcu_fd_sc_mcu7t5v0__fillcap_8
XFILLER_48_387 VDD VDD VSS VSS gf180mcu_fd_sc_mcu7t5v0__fillcap_4
Xinput273 tl_h_d_i[106] _2765_/I VDD VDD VSS VSS gf180mcu_fd_sc_mcu7t5v0__clkbuf_2
Xinput284 tl_h_d_i[13] _1880_/B2 VDD VDD VSS VSS gf180mcu_fd_sc_mcu7t5v0__dlyd_1
Xinput295 tl_h_d_i[23] _2714_/I VDD VDD VSS VSS gf180mcu_fd_sc_mcu7t5v0__clkbuf_2
XFILLER_63_346 VDD VDD VSS VSS gf180mcu_fd_sc_mcu7t5v0__fillcap_4
XFILLER_44_571 VDD VDD VSS VSS gf180mcu_fd_sc_mcu7t5v0__fillcap_16
XFILLER_90_187 VDD VDD VSS VSS gf180mcu_fd_sc_mcu7t5v0__fill_1
XTAP_TAPCELL_ROW_14_430 VDD VSS gf180mcu_fd_sc_mcu7t5v0__filltie
XFILLER_31_265 VDD VDD VSS VSS gf180mcu_fd_sc_mcu7t5v0__fillcap_8
XTAP_TAPCELL_ROW_42_761 VDD VSS gf180mcu_fd_sc_mcu7t5v0__filltie
X_2752_ _2752_/I _2752_/Z VDD VDD VSS VSS gf180mcu_fd_sc_mcu7t5v0__buf_1
X_1703_ _1703_/I _1703_/ZN VDD VDD VSS VSS gf180mcu_fd_sc_mcu7t5v0__clkinv_1
X_2683_ _2755_/I _2683_/Z VDD VDD VSS VSS gf180mcu_fd_sc_mcu7t5v0__buf_1
Xoutput703 _2044_/B1 tl_d_esram_o[97] VDD VDD VSS VSS gf180mcu_fd_sc_mcu7t5v0__dlyd_1
Xoutput736 _1711_/ZN tl_d_rom_o[23] VDD VDD VSS VSS gf180mcu_fd_sc_mcu7t5v0__dlyd_1
Xoutput725 _1691_/ZN tl_d_rom_o[13] VDD VDD VSS VSS gf180mcu_fd_sc_mcu7t5v0__dlyd_1
Xoutput714 _1843_/ZN tl_d_rom_o[106] VDD VDD VSS VSS gf180mcu_fd_sc_mcu7t5v0__dlyd_1
X_1634_ _1940_/B2 _1641_/A2 _1634_/Z VDD VDD VSS VSS gf180mcu_fd_sc_mcu7t5v0__or2_1
XTAP_TAPCELL_ROW_113_1613 VDD VSS gf180mcu_fd_sc_mcu7t5v0__filltie
Xoutput769 _1771_/ZN tl_d_rom_o[53] VDD VDD VSS VSS gf180mcu_fd_sc_mcu7t5v0__dlyd_1
Xoutput758 _1751_/ZN tl_d_rom_o[43] VDD VDD VSS VSS gf180mcu_fd_sc_mcu7t5v0__dlyd_1
Xoutput747 _1731_/ZN tl_d_rom_o[33] VDD VDD VSS VSS gf180mcu_fd_sc_mcu7t5v0__dlyd_1
X_1565_ _1870_/B2 _1564_/Z _1600_/S _1565_/Z VDD VDD VSS VSS gf180mcu_fd_sc_mcu7t5v0__mux2_2
X_1496_ _1496_/A1 _1496_/A2 _2373_/A2 VDD VDD VSS VSS gf180mcu_fd_sc_mcu7t5v0__nand2_1
XFILLER_39_376 VDD VDD VSS VSS gf180mcu_fd_sc_mcu7t5v0__fill_2
X_2117_ input24/Z _2154_/A2 _2118_/A2 VDD VDD VSS VSS gf180mcu_fd_sc_mcu7t5v0__nor2_1
X_2048_ input90/Z _2315_/A2 _2277_/A1 _2116_/A1 _2049_/I VDD VDD VSS VSS gf180mcu_fd_sc_mcu7t5v0__aoi22_1
XFILLER_23_766 VDD VDD VSS VSS gf180mcu_fd_sc_mcu7t5v0__fillcap_4
XTAP_TAPCELL_ROW_79_1210 VDD VSS gf180mcu_fd_sc_mcu7t5v0__filltie
XTAP_TAPCELL_ROW_20_499 VDD VSS gf180mcu_fd_sc_mcu7t5v0__filltie
XFILLER_38_10 VDD VDD VSS VSS gf180mcu_fd_sc_mcu7t5v0__fillcap_4
XFILLER_89_276 VDD VDD VSS VSS gf180mcu_fd_sc_mcu7t5v0__fillcap_4
XFILLER_38_32 VDD VDD VSS VSS gf180mcu_fd_sc_mcu7t5v0__fill_2
XFILLER_18_527 VDD VDD VSS VSS gf180mcu_fd_sc_mcu7t5v0__fillcap_64
XFILLER_45_313 VDD VDD VSS VSS gf180mcu_fd_sc_mcu7t5v0__fill_1
XFILLER_45_324 VDD VDD VSS VSS gf180mcu_fd_sc_mcu7t5v0__fillcap_16
XFILLER_33_508 VDD VDD VSS VSS gf180mcu_fd_sc_mcu7t5v0__fillcap_4
XFILLER_45_368 VDD VDD VSS VSS gf180mcu_fd_sc_mcu7t5v0__fill_1
XFILLER_45_379 VDD VDD VSS VSS gf180mcu_fd_sc_mcu7t5v0__fillcap_32
XTAP_TAPCELL_ROW_28_588 VDD VSS gf180mcu_fd_sc_mcu7t5v0__filltie
XFILLER_72_187 VDD VDD VSS VSS gf180mcu_fd_sc_mcu7t5v0__fill_1
XFILLER_72_165 VDD VDD VSS VSS gf180mcu_fd_sc_mcu7t5v0__fillcap_8
XFILLER_70_96 VDD VDD VSS VSS gf180mcu_fd_sc_mcu7t5v0__fill_1
X_1350_ _1350_/A1 _1406_/A2 _1350_/B1 _1390_/B2 _1351_/A2 VDD VDD VSS VSS gf180mcu_fd_sc_mcu7t5v0__aoi22_1
X_1281_ _1393_/A1 _2265_/A2 _1281_/Z VDD VDD VSS VSS gf180mcu_fd_sc_mcu7t5v0__and2_1
XFILLER_95_279 VDD VDD VSS VSS gf180mcu_fd_sc_mcu7t5v0__fill_1
XFILLER_83_419 VDD VDD VSS VSS gf180mcu_fd_sc_mcu7t5v0__fill_1
XFILLER_36_313 VDD VDD VSS VSS gf180mcu_fd_sc_mcu7t5v0__fill_2
XTAP_TAPCELL_ROW_47_820 VDD VSS gf180mcu_fd_sc_mcu7t5v0__filltie
XFILLER_36_379 VDD VDD VSS VSS gf180mcu_fd_sc_mcu7t5v0__fillcap_4
XFILLER_63_176 VDD VDD VSS VSS gf180mcu_fd_sc_mcu7t5v0__fill_1
XFILLER_64_688 VDD VDD VSS VSS gf180mcu_fd_sc_mcu7t5v0__fill_1
XTAP_TAPCELL_ROW_63_1011 VDD VSS gf180mcu_fd_sc_mcu7t5v0__filltie
XFILLER_20_769 VDD VDD VSS VSS gf180mcu_fd_sc_mcu7t5v0__fill_2
X_2735_ _2735_/I _2735_/Z VDD VDD VSS VSS gf180mcu_fd_sc_mcu7t5v0__buf_1
X_2666_ _2738_/I _2666_/Z VDD VDD VSS VSS gf180mcu_fd_sc_mcu7t5v0__buf_1
Xoutput500 _2692_/Z tl_d_dmem_o[105] VDD VDD VSS VSS gf180mcu_fd_sc_mcu7t5v0__dlyd_1
Xoutput511 _1600_/Z tl_d_dmem_o[12] VDD VDD VSS VSS gf180mcu_fd_sc_mcu7t5v0__dlyd_1
Xoutput522 _2641_/Z tl_d_dmem_o[22] VDD VDD VSS VSS gf180mcu_fd_sc_mcu7t5v0__dlyd_1
Xoutput533 _1515_/Z tl_d_dmem_o[32] VDD VDD VSS VSS gf180mcu_fd_sc_mcu7t5v0__dlyd_1
Xoutput544 _1525_/Z tl_d_dmem_o[42] VDD VDD VSS VSS gf180mcu_fd_sc_mcu7t5v0__dlyd_1
X_1617_ _2707_/I _2709_/I _1612_/Z _1617_/Z VDD VDD VSS VSS gf180mcu_fd_sc_mcu7t5v0__xor3_1
X_2597_ _2597_/D _2597_/RN clkload6/I _2597_/Q VDD VDD VSS VSS gf180mcu_fd_sc_mcu7t5v0__dffrnq_1
Xoutput555 _1535_/Z tl_d_dmem_o[52] VDD VDD VSS VSS gf180mcu_fd_sc_mcu7t5v0__dlyd_1
Xoutput566 _2649_/Z tl_d_dmem_o[62] VDD VDD VSS VSS gf180mcu_fd_sc_mcu7t5v0__dlyd_1
Xoutput577 _2659_/Z tl_d_dmem_o[72] VDD VDD VSS VSS gf180mcu_fd_sc_mcu7t5v0__dlyd_1
XTAP_TAPCELL_ROW_74_1140 VDD VSS gf180mcu_fd_sc_mcu7t5v0__filltie
XFILLER_59_416 VDD VDD VSS VSS gf180mcu_fd_sc_mcu7t5v0__fillcap_4
Xoutput588 _2669_/Z tl_d_dmem_o[82] VDD VDD VSS VSS gf180mcu_fd_sc_mcu7t5v0__dlyd_1
Xoutput599 _2679_/Z tl_d_dmem_o[92] VDD VDD VSS VSS gf180mcu_fd_sc_mcu7t5v0__dlyd_1
X_1548_ _1864_/B2 _1550_/A2 _1548_/Z VDD VDD VSS VSS gf180mcu_fd_sc_mcu7t5v0__or2_1
X_1479_ _1503_/A1 _1479_/A2 _1479_/ZN VDD VDD VSS VSS gf180mcu_fd_sc_mcu7t5v0__nor2_1
XFILLER_82_452 VDD VDD VSS VSS gf180mcu_fd_sc_mcu7t5v0__fill_2
XFILLER_42_349 VDD VDD VSS VSS gf180mcu_fd_sc_mcu7t5v0__fillcap_16
XTAP_TAPCELL_ROW_85_1280 VDD VSS gf180mcu_fd_sc_mcu7t5v0__filltie
XTAP_TAPCELL_ROW_25_558 VDD VSS gf180mcu_fd_sc_mcu7t5v0__filltie
XTAP_TAPCELL_ROW_53_889 VDD VSS gf180mcu_fd_sc_mcu7t5v0__filltie
XFILLER_40_22 VDD VDD VSS VSS gf180mcu_fd_sc_mcu7t5v0__fillcap_4
XFILLER_78_769 VDD VDD VSS VSS gf180mcu_fd_sc_mcu7t5v0__fill_2
XFILLER_77_224 VDD VDD VSS VSS gf180mcu_fd_sc_mcu7t5v0__fill_2
XTAP_TAPCELL_ROW_88_1309 VDD VSS gf180mcu_fd_sc_mcu7t5v0__filltie
XFILLER_18_313 VDD VDD VSS VSS gf180mcu_fd_sc_mcu7t5v0__fill_2
XFILLER_19_858 VDD VDD VSS VSS gf180mcu_fd_sc_mcu7t5v0__fillcap_8
XFILLER_85_290 VDD VDD VSS VSS gf180mcu_fd_sc_mcu7t5v0__fill_1
XFILLER_46_699 VDD VDD VSS VSS gf180mcu_fd_sc_mcu7t5v0__fillcap_16
XFILLER_61_625 VDD VDD VSS VSS gf180mcu_fd_sc_mcu7t5v0__fillcap_4
XFILLER_45_198 VDD VDD VSS VSS gf180mcu_fd_sc_mcu7t5v0__fillcap_4
XTAP_TAPCELL_ROW_99_1449 VDD VSS gf180mcu_fd_sc_mcu7t5v0__filltie
X_2520_ _2595_/Q _2507_/B _2521_/B VDD VDD VSS VSS gf180mcu_fd_sc_mcu7t5v0__nand2_1
X_2451_ _2449_/Z _2451_/A2 _2451_/B _2452_/A2 VDD VDD VSS VSS gf180mcu_fd_sc_mcu7t5v0__aoi21_1
X_1402_ input95/Z _1418_/A2 _2331_/A3 _1403_/B VDD VDD VSS VSS gf180mcu_fd_sc_mcu7t5v0__nand3_1
X_2382_ _2382_/A1 _2383_/A2 _2382_/B _2539_/D VDD VDD VSS VSS gf180mcu_fd_sc_mcu7t5v0__aoi21_1
X_1333_ _1333_/I _1334_/B1 VDD VDD VSS VSS gf180mcu_fd_sc_mcu7t5v0__clkinv_1
X_1264_ _1264_/A1 _1368_/A2 _2257_/A2 VDD VDD VSS VSS gf180mcu_fd_sc_mcu7t5v0__nand2_1
XFILLER_83_205 VDD VDD VSS VSS gf180mcu_fd_sc_mcu7t5v0__fillcap_4
XFILLER_49_471 VDD VDD VSS VSS gf180mcu_fd_sc_mcu7t5v0__fillcap_16
Xinput4 tl_d_dmem_i[11] input4/Z VDD VDD VSS VSS gf180mcu_fd_sc_mcu7t5v0__dlyd_1
XFILLER_83_249 VDD VDD VSS VSS gf180mcu_fd_sc_mcu7t5v0__fillcap_16
XFILLER_64_441 VDD VDD VSS VSS gf180mcu_fd_sc_mcu7t5v0__fillcap_8
X_1195_ _1200_/C _1196_/C _1196_/A2 _1195_/B _2531_/A2 VDD VDD VSS VSS gf180mcu_fd_sc_mcu7t5v0__oai31_1
XTAP_TAPCELL_ROW_108_1556 VDD VSS gf180mcu_fd_sc_mcu7t5v0__filltie
XFILLER_64_463 VDD VDD VSS VSS gf180mcu_fd_sc_mcu7t5v0__fill_1
XFILLER_91_271 VDD VDD VSS VSS gf180mcu_fd_sc_mcu7t5v0__fillcap_8
XFILLER_91_282 VDD VDD VSS VSS gf180mcu_fd_sc_mcu7t5v0__fillcap_16
XFILLER_51_168 VDD VDD VSS VSS gf180mcu_fd_sc_mcu7t5v0__fill_1
XTAP_TAPCELL_ROW_50_859 VDD VSS gf180mcu_fd_sc_mcu7t5v0__filltie
XTAP_TAPCELL_ROW_22_517 VDD VSS gf180mcu_fd_sc_mcu7t5v0__filltie
XFILLER_118_410 VDD VDD VSS VSS gf180mcu_fd_sc_mcu7t5v0__fill_2
X_2718_ _2718_/I _2718_/Z VDD VDD VSS VSS gf180mcu_fd_sc_mcu7t5v0__buf_1
XFILLER_10_14 VDD VDD VSS VSS gf180mcu_fd_sc_mcu7t5v0__fill_2
X_2649_ _2721_/I _2649_/Z VDD VDD VSS VSS gf180mcu_fd_sc_mcu7t5v0__buf_1
XFILLER_102_811 VDD VDD VSS VSS gf180mcu_fd_sc_mcu7t5v0__fillcap_16
XFILLER_87_555 VDD VDD VSS VSS gf180mcu_fd_sc_mcu7t5v0__fillcap_4
XFILLER_19_45 VDD VDD VSS VSS gf180mcu_fd_sc_mcu7t5v0__fill_2
XFILLER_47_408 VDD VDD VSS VSS gf180mcu_fd_sc_mcu7t5v0__fillcap_8
XTAP_TAPCELL_ROW_58_948 VDD VSS gf180mcu_fd_sc_mcu7t5v0__filltie
XFILLER_27_165 VDD VDD VSS VSS gf180mcu_fd_sc_mcu7t5v0__fill_1
XFILLER_43_625 VDD VDD VSS VSS gf180mcu_fd_sc_mcu7t5v0__fillcap_4
XTAP_TAPCELL_ROW_2_286 VDD VSS gf180mcu_fd_sc_mcu7t5v0__filltie
XTAP_TAPCELL_ROW_2_275 VDD VSS gf180mcu_fd_sc_mcu7t5v0__filltie
XFILLER_15_349 VDD VDD VSS VSS gf180mcu_fd_sc_mcu7t5v0__fill_1
XFILLER_109_487 VDD VDD VSS VSS gf180mcu_fd_sc_mcu7t5v0__fill_2
XTAP_TAPCELL_ROW_94_1379 VDD VSS gf180mcu_fd_sc_mcu7t5v0__filltie
XFILLER_78_588 VDD VDD VSS VSS gf180mcu_fd_sc_mcu7t5v0__fillcap_4
XFILLER_65_216 VDD VDD VSS VSS gf180mcu_fd_sc_mcu7t5v0__fill_2
XFILLER_93_547 VDD VDD VSS VSS gf180mcu_fd_sc_mcu7t5v0__fillcap_4
XFILLER_18_132 VDD VDD VSS VSS gf180mcu_fd_sc_mcu7t5v0__fill_1
XFILLER_46_441 VDD VDD VSS VSS gf180mcu_fd_sc_mcu7t5v0__fill_2
XFILLER_61_422 VDD VDD VSS VSS gf180mcu_fd_sc_mcu7t5v0__fillcap_8
XFILLER_73_282 VDD VDD VSS VSS gf180mcu_fd_sc_mcu7t5v0__fillcap_8
XFILLER_61_488 VDD VDD VSS VSS gf180mcu_fd_sc_mcu7t5v0__fill_2
XFILLER_30_831 VDD VDD VSS VSS gf180mcu_fd_sc_mcu7t5v0__fill_1
X_1951_ _1951_/I _1951_/ZN VDD VDD VSS VSS gf180mcu_fd_sc_mcu7t5v0__clkinv_1
X_1882_ _1882_/A1 _2534_/A2 _2537_/A2 _1882_/B2 _1883_/I VDD VDD VSS VSS gf180mcu_fd_sc_mcu7t5v0__aoi22_1
XTAP_TAPCELL_ROW_103_1497 VDD VSS gf180mcu_fd_sc_mcu7t5v0__filltie
X_2503_ _1152_/Z _2517_/B _2504_/B VDD VDD VSS VSS gf180mcu_fd_sc_mcu7t5v0__nand2_1
Xoutput1002 _2292_/ZN tl_h_i_o[25] VDD VDD VSS VSS gf180mcu_fd_sc_mcu7t5v0__dlyd_1
Xoutput1013 _2332_/ZN tl_h_i_o[35] VDD VDD VSS VSS gf180mcu_fd_sc_mcu7t5v0__dlyd_1
Xoutput1024 _2372_/ZN tl_h_i_o[45] VDD VDD VSS VSS gf180mcu_fd_sc_mcu7t5v0__dlyd_1
XFILLER_115_479 VDD VDD VSS VSS gf180mcu_fd_sc_mcu7t5v0__fill_1
Xoutput1035 _2100_/ZN tl_h_i_o[55] VDD VDD VSS VSS gf180mcu_fd_sc_mcu7t5v0__dlyd_1
Xoutput1046 _2776_/Z tl_h_i_o[65] VDD VDD VSS VSS gf180mcu_fd_sc_mcu7t5v0__dlyd_1
X_2434_ _2562_/Q _2563_/Q _2434_/A3 _2434_/B _2435_/I VDD VDD VSS VSS gf180mcu_fd_sc_mcu7t5v0__oai31_1
XTAP_TAPCELL_ROW_71_1110 VDD VSS gf180mcu_fd_sc_mcu7t5v0__filltie
X_2365_ _2373_/A1 _2365_/A2 _2366_/A2 VDD VDD VSS VSS gf180mcu_fd_sc_mcu7t5v0__nand2_1
XFILLER_97_842 VDD VDD VSS VSS gf180mcu_fd_sc_mcu7t5v0__fillcap_4
X_1316_ input17/Z _1348_/A2 _1316_/B1 _2160_/A2 _1317_/I VDD VDD VSS VSS gf180mcu_fd_sc_mcu7t5v0__aoi22_1
XFILLER_97_864 VDD VDD VSS VSS gf180mcu_fd_sc_mcu7t5v0__fill_2
X_2296_ _2296_/A1 _2296_/A2 _2296_/B _2296_/ZN VDD VDD VSS VSS gf180mcu_fd_sc_mcu7t5v0__aoi21_1
XFILLER_65_761 VDD VDD VSS VSS gf180mcu_fd_sc_mcu7t5v0__fillcap_8
X_1247_ _1247_/A1 _1247_/A2 _1247_/A3 _1511_/A1 VDD VDD VSS VSS gf180mcu_fd_sc_mcu7t5v0__nand3_1
XFILLER_65_772 VDD VDD VSS VSS gf180mcu_fd_sc_mcu7t5v0__fillcap_32
X_1178_ _2562_/Q _2561_/Q _2564_/Q _2563_/Q _1179_/A3 VDD VDD VSS VSS gf180mcu_fd_sc_mcu7t5v0__nor4_1
XTAP_TAPCELL_ROW_55_918 VDD VSS gf180mcu_fd_sc_mcu7t5v0__filltie
XFILLER_52_444 VDD VDD VSS VSS gf180mcu_fd_sc_mcu7t5v0__fillcap_8
XFILLER_64_271 VDD VDD VSS VSS gf180mcu_fd_sc_mcu7t5v0__fillcap_32
XTAP_TAPCELL_ROW_69_1083 VDD VSS gf180mcu_fd_sc_mcu7t5v0__filltie
XFILLER_12_308 VDD VDD VSS VSS gf180mcu_fd_sc_mcu7t5v0__fill_1
XTAP_TAPCELL_ROW_35_675 VDD VSS gf180mcu_fd_sc_mcu7t5v0__filltie
XANTENNA_20 tl_h_i_i[93] VDD VDD VSS VSS gf180mcu_fd_sc_mcu7t5v0__antenna
XANTENNA_31 _2765_/I VDD VDD VSS VSS gf180mcu_fd_sc_mcu7t5v0__antenna
XFILLER_21_842 VDD VDD VSS VSS gf180mcu_fd_sc_mcu7t5v0__fillcap_16
XANTENNA_42 tl_h_i_i[7] VDD VDD VSS VSS gf180mcu_fd_sc_mcu7t5v0__antenna
XFILLER_20_363 VDD VDD VSS VSS gf180mcu_fd_sc_mcu7t5v0__fillcap_16
XFILLER_106_435 VDD VDD VSS VSS gf180mcu_fd_sc_mcu7t5v0__fillcap_16
XFILLER_106_457 VDD VDD VSS VSS gf180mcu_fd_sc_mcu7t5v0__fill_2
XFILLER_0_746 VDD VDD VSS VSS gf180mcu_fd_sc_mcu7t5v0__fill_2
XTAP_TAPCELL_ROW_7_345 VDD VSS gf180mcu_fd_sc_mcu7t5v0__filltie
XFILLER_88_831 VDD VDD VSS VSS gf180mcu_fd_sc_mcu7t5v0__fill_1
XFILLER_102_663 VDD VDD VSS VSS gf180mcu_fd_sc_mcu7t5v0__fill_2
XPHY_EDGE_ROW_102_Right_102 VDD VSS gf180mcu_fd_sc_mcu7t5v0__endcap
XFILLER_87_352 VDD VDD VSS VSS gf180mcu_fd_sc_mcu7t5v0__fillcap_4
XFILLER_46_10 VDD VDD VSS VSS gf180mcu_fd_sc_mcu7t5v0__fill_2
Xxbar_tlul_2to4 tl_d_esram_o[96] VDD VDD VSS VSS gf180mcu_fd_sc_mcu7t5v0__tiel
XFILLER_90_506 VDD VDD VSS VSS gf180mcu_fd_sc_mcu7t5v0__fill_1
XFILLER_90_539 VDD VDD VSS VSS gf180mcu_fd_sc_mcu7t5v0__fill_2
XFILLER_43_422 VDD VDD VSS VSS gf180mcu_fd_sc_mcu7t5v0__fillcap_8
XFILLER_55_282 VDD VDD VSS VSS gf180mcu_fd_sc_mcu7t5v0__fillcap_32
XFILLER_12_831 VDD VDD VSS VSS gf180mcu_fd_sc_mcu7t5v0__fill_1
XFILLER_11_352 VDD VDD VSS VSS gf180mcu_fd_sc_mcu7t5v0__fillcap_64
XTAP_TAPCELL_ROW_96_1408 VDD VSS gf180mcu_fd_sc_mcu7t5v0__filltie
XFILLER_79_842 VDD VDD VSS VSS gf180mcu_fd_sc_mcu7t5v0__fillcap_16
XFILLER_78_363 VDD VDD VSS VSS gf180mcu_fd_sc_mcu7t5v0__fillcap_4
X_2150_ _1087_/I _2142_/B _2150_/B1 _2150_/B2 _2170_/C _2152_/B1 VDD VDD VSS VSS gf180mcu_fd_sc_mcu7t5v0__oai221_1
XFILLER_94_823 VDD VDD VSS VSS gf180mcu_fd_sc_mcu7t5v0__fillcap_8
X_2081_ _2081_/I _2081_/ZN VDD VDD VSS VSS gf180mcu_fd_sc_mcu7t5v0__clkinv_1
X_1101_ _1101_/I _2223_/A1 VDD VDD VSS VSS gf180mcu_fd_sc_mcu7t5v0__clkinv_1
XTAP_TAPCELL_ROW_105_1515 VDD VSS gf180mcu_fd_sc_mcu7t5v0__filltie
X_1934_ _1934_/A1 _1964_/A2 _1958_/B1 _1934_/B2 _1935_/I VDD VDD VSS VSS gf180mcu_fd_sc_mcu7t5v0__aoi22_1
XTAP_TAPCELL_ROW_32_645 VDD VSS gf180mcu_fd_sc_mcu7t5v0__filltie
XTAP_TAPCELL_ROW_60_976 VDD VSS gf180mcu_fd_sc_mcu7t5v0__filltie
Xinput40 tl_d_dmem_i[44] input40/Z VDD VDD VSS VSS gf180mcu_fd_sc_mcu7t5v0__dlyd_1
X_1865_ _1865_/I _1865_/ZN VDD VDD VSS VSS gf180mcu_fd_sc_mcu7t5v0__clkinv_1
Xinput51 tl_d_dmem_i[54] input51/Z VDD VDD VSS VSS gf180mcu_fd_sc_mcu7t5v0__dlyd_1
Xinput62 tl_d_dmem_i[64] input62/Z VDD VDD VSS VSS gf180mcu_fd_sc_mcu7t5v0__dlyd_1
Xinput73 tl_d_esram_i[14] input73/Z VDD VDD VSS VSS gf180mcu_fd_sc_mcu7t5v0__dlyd_1
X_1796_ _1986_/A1 _1818_/A2 _1838_/B1 _2725_/I _1797_/I VDD VDD VSS VSS gf180mcu_fd_sc_mcu7t5v0__aoi22_1
Xinput84 tl_d_esram_i[24] input84/Z VDD VDD VSS VSS gf180mcu_fd_sc_mcu7t5v0__dlyd_1
Xinput95 tl_d_esram_i[34] input95/Z VDD VDD VSS VSS gf180mcu_fd_sc_mcu7t5v0__dlyd_1
XTAP_TAPCELL_ROW_116_1644 VDD VSS gf180mcu_fd_sc_mcu7t5v0__filltie
X_2417_ _2561_/Q _2451_/B _2418_/B VDD VDD VSS VSS gf180mcu_fd_sc_mcu7t5v0__nand2_1
XTAP_TAPCELL_ROW_4_304 VDD VSS gf180mcu_fd_sc_mcu7t5v0__filltie
XFILLER_69_352 VDD VDD VSS VSS gf180mcu_fd_sc_mcu7t5v0__fillcap_8
X_2348_ _2348_/A1 _2348_/A2 _2348_/B _2348_/ZN VDD VDD VSS VSS gf180mcu_fd_sc_mcu7t5v0__aoi21_1
X_2279_ input82/Z _2291_/A2 _2311_/A3 _2280_/A2 VDD VDD VSS VSS gf180mcu_fd_sc_mcu7t5v0__nand3_1
XFILLER_37_260 VDD VDD VSS VSS gf180mcu_fd_sc_mcu7t5v0__fillcap_4
XFILLER_25_422 VDD VDD VSS VSS gf180mcu_fd_sc_mcu7t5v0__fillcap_32
XFILLER_37_282 VDD VDD VSS VSS gf180mcu_fd_sc_mcu7t5v0__fillcap_4
XFILLER_52_230 VDD VDD VSS VSS gf180mcu_fd_sc_mcu7t5v0__fill_1
XFILLER_52_274 VDD VDD VSS VSS gf180mcu_fd_sc_mcu7t5v0__fillcap_8
XFILLER_32_34 VDD VDD VSS VSS gf180mcu_fd_sc_mcu7t5v0__fill_1
XTAP_TAPCELL_ROW_91_1349 VDD VSS gf180mcu_fd_sc_mcu7t5v0__filltie
Xinput400 tl_h_i_i[15] _2385_/I0 VDD VDD VSS VSS gf180mcu_fd_sc_mcu7t5v0__dlyd_1
Xinput411 tl_h_i_i[25] _1904_/A1 VDD VDD VSS VSS gf180mcu_fd_sc_mcu7t5v0__dlyd_1
XFILLER_88_661 VDD VDD VSS VSS gf180mcu_fd_sc_mcu7t5v0__fillcap_4
XFILLER_76_801 VDD VDD VSS VSS gf180mcu_fd_sc_mcu7t5v0__fillcap_4
Xinput422 tl_h_i_i[35] _1924_/A1 VDD VDD VSS VSS gf180mcu_fd_sc_mcu7t5v0__dlyd_1
Xinput433 tl_h_i_i[45] _1944_/A1 VDD VDD VSS VSS gf180mcu_fd_sc_mcu7t5v0__dlyd_1
Xinput444 tl_h_i_i[55] _1964_/A1 VDD VDD VSS VSS gf180mcu_fd_sc_mcu7t5v0__dlyd_1
Xinput455 tl_h_i_i[65] _1984_/A1 VDD VDD VSS VSS gf180mcu_fd_sc_mcu7t5v0__dlyd_1
XFILLER_76_823 VDD VDD VSS VSS gf180mcu_fd_sc_mcu7t5v0__fillcap_8
Xinput466 tl_h_i_i[75] _2004_/A1 VDD VDD VSS VSS gf180mcu_fd_sc_mcu7t5v0__dlyd_1
Xinput477 tl_h_i_i[85] _1165_/A1 VDD VDD VSS VSS gf180mcu_fd_sc_mcu7t5v0__dlyd_1
Xinput488 tl_h_i_i[95] _1161_/A3 VDD VDD VSS VSS gf180mcu_fd_sc_mcu7t5v0__dlyd_1
XFILLER_90_314 VDD VDD VSS VSS gf180mcu_fd_sc_mcu7t5v0__fill_1
XFILLER_44_731 VDD VDD VSS VSS gf180mcu_fd_sc_mcu7t5v0__fillcap_4
XFILLER_56_591 VDD VDD VSS VSS gf180mcu_fd_sc_mcu7t5v0__fillcap_4
XFILLER_90_325 VDD VDD VSS VSS gf180mcu_fd_sc_mcu7t5v0__fill_2
XFILLER_71_594 VDD VDD VSS VSS gf180mcu_fd_sc_mcu7t5v0__fillcap_16
XFILLER_12_661 VDD VDD VSS VSS gf180mcu_fd_sc_mcu7t5v0__fillcap_4
XTAP_TAPCELL_ROW_100_1456 VDD VSS gf180mcu_fd_sc_mcu7t5v0__filltie
X_1650_ _1972_/B2 _1651_/A2 _1650_/Z VDD VDD VSS VSS gf180mcu_fd_sc_mcu7t5v0__or2_1
Xoutput918 _1660_/Z tl_d_uart_o[9] VDD VDD VSS VSS gf180mcu_fd_sc_mcu7t5v0__dlyd_1
Xoutput907 _1659_/Z tl_d_uart_o[8] VDD VDD VSS VSS gf180mcu_fd_sc_mcu7t5v0__dlyd_1
X_1581_ _2749_/I _2750_/I _1581_/Z VDD VDD VSS VSS gf180mcu_fd_sc_mcu7t5v0__xor2_1
Xoutput929 _1287_/ZN tl_h_d_o[19] VDD VDD VSS VSS gf180mcu_fd_sc_mcu7t5v0__dlyd_1
XFILLER_66_311 VDD VDD VSS VSS gf180mcu_fd_sc_mcu7t5v0__fillcap_4
X_2202_ _2202_/A1 _2157_/B _2202_/B _2202_/C _2204_/B1 VDD VDD VSS VSS gf180mcu_fd_sc_mcu7t5v0__oai211_1
XTAP_TAPCELL_ROW_111_1585 VDD VSS gf180mcu_fd_sc_mcu7t5v0__filltie
XFILLER_79_694 VDD VDD VSS VSS gf180mcu_fd_sc_mcu7t5v0__fillcap_4
XFILLER_79_672 VDD VDD VSS VSS gf180mcu_fd_sc_mcu7t5v0__fillcap_4
XFILLER_14_2 VDD VDD VSS VSS gf180mcu_fd_sc_mcu7t5v0__fill_2
XFILLER_39_536 VDD VDD VSS VSS gf180mcu_fd_sc_mcu7t5v0__fillcap_16
Xfanout1160 _2207_/B _2246_/B1 VDD VDD VSS VSS gf180mcu_fd_sc_mcu7t5v0__dlyd_1
Xfanout1171 _1217_/C _2160_/C VDD VDD VSS VSS gf180mcu_fd_sc_mcu7t5v0__dlyd_1
Xfanout1182 _2379_/A2 _2343_/A2 VDD VDD VSS VSS gf180mcu_fd_sc_mcu7t5v0__dlyd_1
X_2133_ _2133_/A1 _2153_/A2 _2142_/B _2133_/B2 _2135_/B2 VDD VDD VSS VSS gf180mcu_fd_sc_mcu7t5v0__oai22_1
Xfanout1193 _2235_/B _1508_/B2 VDD VDD VSS VSS gf180mcu_fd_sc_mcu7t5v0__dlyd_1
XTAP_TAPCELL_ROW_37_704 VDD VSS gf180mcu_fd_sc_mcu7t5v0__filltie
XFILLER_19_282 VDD VDD VSS VSS gf180mcu_fd_sc_mcu7t5v0__fillcap_8
X_2064_ _1066_/I _2142_/A1 _2064_/B _2064_/C _2066_/A1 VDD VDD VSS VSS gf180mcu_fd_sc_mcu7t5v0__oai211_1
XFILLER_34_230 VDD VDD VSS VSS gf180mcu_fd_sc_mcu7t5v0__fillcap_4
XTAP_TAPCELL_ROW_66_1053 VDD VSS gf180mcu_fd_sc_mcu7t5v0__filltie
XFILLER_22_403 VDD VDD VSS VSS gf180mcu_fd_sc_mcu7t5v0__fillcap_4
XTAP_TAPCELL_ROW_17_461 VDD VSS gf180mcu_fd_sc_mcu7t5v0__filltie
XTAP_TAPCELL_ROW_45_792 VDD VSS gf180mcu_fd_sc_mcu7t5v0__filltie
X_1917_ _1917_/I _1917_/ZN VDD VDD VSS VSS gf180mcu_fd_sc_mcu7t5v0__clkinv_1
X_1848_ _2038_/A1 _1854_/A2 _1850_/B1 _2768_/I _1849_/I VDD VDD VSS VSS gf180mcu_fd_sc_mcu7t5v0__aoi22_1
X_1779_ _1779_/I _1779_/ZN VDD VDD VSS VSS gf180mcu_fd_sc_mcu7t5v0__clkinv_1
XTAP_TAPCELL_ROW_77_1182 VDD VSS gf180mcu_fd_sc_mcu7t5v0__filltie
XFILLER_89_436 VDD VDD VSS VSS gf180mcu_fd_sc_mcu7t5v0__fill_1
XFILLER_58_801 VDD VDD VSS VSS gf180mcu_fd_sc_mcu7t5v0__fillcap_4
XFILLER_58_823 VDD VDD VSS VSS gf180mcu_fd_sc_mcu7t5v0__fillcap_8
XFILLER_97_480 VDD VDD VSS VSS gf180mcu_fd_sc_mcu7t5v0__fillcap_8
XFILLER_57_366 VDD VDD VSS VSS gf180mcu_fd_sc_mcu7t5v0__fillcap_32
XFILLER_26_731 VDD VDD VSS VSS gf180mcu_fd_sc_mcu7t5v0__fillcap_4
XFILLER_53_572 VDD VDD VSS VSS gf180mcu_fd_sc_mcu7t5v0__fill_1
XFILLER_68_30 VDD VDD VSS VSS gf180mcu_fd_sc_mcu7t5v0__fillcap_4
XFILLER_48_300 VDD VDD VSS VSS gf180mcu_fd_sc_mcu7t5v0__fillcap_8
Xxbar_tlul_2to4_1256 tl_d_esram_o[89] VDD VDD VSS VSS gf180mcu_fd_sc_mcu7t5v0__tiel
Xxbar_tlul_2to4_1267 tl_d_rom_o[93] VDD VDD VSS VSS gf180mcu_fd_sc_mcu7t5v0__tiel
Xinput230 tl_d_uart_i[37] _1430_/A1 VDD VDD VSS VSS gf180mcu_fd_sc_mcu7t5v0__dlyd_1
Xinput241 tl_d_uart_i[47] _1510_/A1 VDD VDD VSS VSS gf180mcu_fd_sc_mcu7t5v0__dlyd_1
Xinput252 tl_d_uart_i[57] _2229_/A1 VDD VDD VSS VSS gf180mcu_fd_sc_mcu7t5v0__dlyd_1
Xinput263 tl_d_uart_i[7] _1091_/I VDD VDD VSS VSS gf180mcu_fd_sc_mcu7t5v0__dlyd_1
Xxbar_tlul_2to4_1278 tl_d_rom_o[82] VDD VDD VSS VSS gf180mcu_fd_sc_mcu7t5v0__tiel
XFILLER_75_130 VDD VDD VSS VSS gf180mcu_fd_sc_mcu7t5v0__fillcap_8
XFILLER_48_377 VDD VDD VSS VSS gf180mcu_fd_sc_mcu7t5v0__fill_2
Xinput274 tl_h_d_i[107] _2766_/I VDD VDD VSS VSS gf180mcu_fd_sc_mcu7t5v0__dlyd_1
Xinput285 tl_h_d_i[14] _1882_/B2 VDD VDD VSS VSS gf180mcu_fd_sc_mcu7t5v0__dlyd_1
Xinput296 tl_h_d_i[24] _2715_/I VDD VDD VSS VSS gf180mcu_fd_sc_mcu7t5v0__dlyd_1
XFILLER_76_664 VDD VDD VSS VSS gf180mcu_fd_sc_mcu7t5v0__fill_1
XTAP_TAPCELL_ROW_14_420 VDD VSS gf180mcu_fd_sc_mcu7t5v0__filltie
XFILLER_31_277 VDD VDD VSS VSS gf180mcu_fd_sc_mcu7t5v0__fill_2
XTAP_TAPCELL_ROW_42_762 VDD VSS gf180mcu_fd_sc_mcu7t5v0__filltie
X_2751_ _2751_/I _2751_/Z VDD VDD VSS VSS gf180mcu_fd_sc_mcu7t5v0__buf_1
X_2682_ _2754_/I _2682_/Z VDD VDD VSS VSS gf180mcu_fd_sc_mcu7t5v0__buf_1
X_1702_ _1892_/A1 _1728_/A2 _1718_/B1 _2710_/I _1703_/I VDD VDD VSS VSS gf180mcu_fd_sc_mcu7t5v0__aoi22_1
XFILLER_8_451 VDD VDD VSS VSS gf180mcu_fd_sc_mcu7t5v0__fillcap_4
X_1633_ _1938_/B2 _1641_/A2 _1633_/Z VDD VDD VSS VSS gf180mcu_fd_sc_mcu7t5v0__or2_1
Xoutput726 _1693_/ZN tl_d_rom_o[14] VDD VDD VSS VSS gf180mcu_fd_sc_mcu7t5v0__dlyd_1
Xoutput715 _1845_/ZN tl_d_rom_o[107] VDD VDD VSS VSS gf180mcu_fd_sc_mcu7t5v0__dlyd_1
Xoutput704 _2017_/ZN tl_d_esram_o[98] VDD VDD VSS VSS gf180mcu_fd_sc_mcu7t5v0__dlyd_1
XTAP_TAPCELL_ROW_113_1614 VDD VSS gf180mcu_fd_sc_mcu7t5v0__filltie
Xoutput759 _1753_/ZN tl_d_rom_o[44] VDD VDD VSS VSS gf180mcu_fd_sc_mcu7t5v0__dlyd_1
Xoutput748 _1733_/ZN tl_d_rom_o[34] VDD VDD VSS VSS gf180mcu_fd_sc_mcu7t5v0__dlyd_1
Xoutput737 _1713_/ZN tl_d_rom_o[24] VDD VDD VSS VSS gf180mcu_fd_sc_mcu7t5v0__dlyd_1
X_1564_ _1558_/Z _1563_/Z _1564_/Z VDD VDD VSS VSS gf180mcu_fd_sc_mcu7t5v0__xor2_1
X_1495_ _1503_/A1 _1495_/A2 _1495_/ZN VDD VDD VSS VSS gf180mcu_fd_sc_mcu7t5v0__nor2_1
XFILLER_99_767 VDD VDD VSS VSS gf180mcu_fd_sc_mcu7t5v0__fill_2
XFILLER_67_664 VDD VDD VSS VSS gf180mcu_fd_sc_mcu7t5v0__fillcap_16
XFILLER_54_314 VDD VDD VSS VSS gf180mcu_fd_sc_mcu7t5v0__fill_1
X_2116_ _2116_/A1 _2238_/A2 _2116_/B1 input90/Z _2178_/C _2116_/ZN VDD VDD VSS VSS
+ gf180mcu_fd_sc_mcu7t5v0__aoi221_2
X_2047_ _2047_/I _2047_/ZN VDD VDD VSS VSS gf180mcu_fd_sc_mcu7t5v0__clkinv_1
XFILLER_82_667 VDD VDD VSS VSS gf180mcu_fd_sc_mcu7t5v0__fillcap_16
XFILLER_70_807 VDD VDD VSS VSS gf180mcu_fd_sc_mcu7t5v0__fillcap_16
XFILLER_50_575 VDD VDD VSS VSS gf180mcu_fd_sc_mcu7t5v0__fillcap_4
XFILLER_22_288 VDD VDD VSS VSS gf180mcu_fd_sc_mcu7t5v0__fillcap_16
XFILLER_50_597 VDD VDD VSS VSS gf180mcu_fd_sc_mcu7t5v0__fillcap_8
XTAP_TAPCELL_ROW_79_1200 VDD VSS gf180mcu_fd_sc_mcu7t5v0__filltie
XFILLER_85_483 VDD VDD VSS VSS gf180mcu_fd_sc_mcu7t5v0__fillcap_4
XFILLER_60_317 VDD VDD VSS VSS gf180mcu_fd_sc_mcu7t5v0__fillcap_4
XFILLER_60_328 VDD VDD VSS VSS gf180mcu_fd_sc_mcu7t5v0__fillcap_4
XTAP_TAPCELL_ROW_28_589 VDD VSS gf180mcu_fd_sc_mcu7t5v0__filltie
XFILLER_72_177 VDD VDD VSS VSS gf180mcu_fd_sc_mcu7t5v0__fillcap_8
XFILLER_107_371 VDD VDD VSS VSS gf180mcu_fd_sc_mcu7t5v0__fill_2
XFILLER_68_428 VDD VDD VSS VSS gf180mcu_fd_sc_mcu7t5v0__fillcap_8
X_1280_ _1280_/A1 _1368_/A2 _2265_/A2 VDD VDD VSS VSS gf180mcu_fd_sc_mcu7t5v0__nand2_1
XFILLER_83_409 VDD VDD VSS VSS gf180mcu_fd_sc_mcu7t5v0__fillcap_8
XFILLER_48_174 VDD VDD VSS VSS gf180mcu_fd_sc_mcu7t5v0__fill_1
XTAP_TAPCELL_ROW_47_821 VDD VSS gf180mcu_fd_sc_mcu7t5v0__filltie
XFILLER_52_807 VDD VDD VSS VSS gf180mcu_fd_sc_mcu7t5v0__fillcap_16
XFILLER_64_667 VDD VDD VSS VSS gf180mcu_fd_sc_mcu7t5v0__fillcap_8
Xload_slew1170 _1390_/B2 _2146_/C VDD VDD VSS VSS gf180mcu_fd_sc_mcu7t5v0__buf_4
Xload_slew1181 _2347_/A2 _2375_/A2 VDD VDD VSS VSS gf180mcu_fd_sc_mcu7t5v0__buf_4
Xload_slew1192 _1476_/B2 _1444_/B2 VDD VDD VSS VSS gf180mcu_fd_sc_mcu7t5v0__buf_4
XTAP_TAPCELL_ROW_63_1012 VDD VSS gf180mcu_fd_sc_mcu7t5v0__filltie
XFILLER_20_737 VDD VDD VSS VSS gf180mcu_fd_sc_mcu7t5v0__fillcap_32
XFILLER_32_597 VDD VDD VSS VSS gf180mcu_fd_sc_mcu7t5v0__fillcap_64
XFILLER_118_614 VDD VDD VSS VSS gf180mcu_fd_sc_mcu7t5v0__fill_2
X_2734_ _2734_/I _2734_/Z VDD VDD VSS VSS gf180mcu_fd_sc_mcu7t5v0__buf_1
X_2665_ _2737_/I _2665_/Z VDD VDD VSS VSS gf180mcu_fd_sc_mcu7t5v0__buf_1
Xoutput501 _2693_/Z tl_d_dmem_o[106] VDD VDD VSS VSS gf180mcu_fd_sc_mcu7t5v0__dlyd_1
X_2596_ _2596_/D _2597_/RN _2596_/CLK _2596_/Q VDD VDD VSS VSS gf180mcu_fd_sc_mcu7t5v0__dffrnq_1
Xoutput512 _1610_/Z tl_d_dmem_o[13] VDD VDD VSS VSS gf180mcu_fd_sc_mcu7t5v0__dlyd_1
Xoutput523 _2642_/Z tl_d_dmem_o[23] VDD VDD VSS VSS gf180mcu_fd_sc_mcu7t5v0__dlyd_1
Xoutput534 _1516_/Z tl_d_dmem_o[33] VDD VDD VSS VSS gf180mcu_fd_sc_mcu7t5v0__dlyd_1
Xoutput545 _1526_/Z tl_d_dmem_o[43] VDD VDD VSS VSS gf180mcu_fd_sc_mcu7t5v0__dlyd_1
X_1616_ _1613_/Z _1614_/Z _1615_/Z _1616_/Z VDD VDD VSS VSS gf180mcu_fd_sc_mcu7t5v0__xor3_1
XFILLER_114_853 VDD VDD VSS VSS gf180mcu_fd_sc_mcu7t5v0__fillcap_8
Xoutput556 _1536_/Z tl_d_dmem_o[53] VDD VDD VSS VSS gf180mcu_fd_sc_mcu7t5v0__dlyd_1
Xoutput567 _2650_/Z tl_d_dmem_o[63] VDD VDD VSS VSS gf180mcu_fd_sc_mcu7t5v0__dlyd_1
Xoutput578 _2660_/Z tl_d_dmem_o[73] VDD VDD VSS VSS gf180mcu_fd_sc_mcu7t5v0__dlyd_1
XTAP_TAPCELL_ROW_74_1141 VDD VSS gf180mcu_fd_sc_mcu7t5v0__filltie
Xoutput589 _2670_/Z tl_d_dmem_o[83] VDD VDD VSS VSS gf180mcu_fd_sc_mcu7t5v0__dlyd_1
X_1547_ _1655_/A1 _1550_/A2 _1547_/ZN VDD VDD VSS VSS gf180mcu_fd_sc_mcu7t5v0__nor2_1
XFILLER_101_558 VDD VDD VSS VSS gf180mcu_fd_sc_mcu7t5v0__fill_2
X_1478_ _1478_/A1 _1510_/A2 _1478_/B1 _2160_/C _1479_/A2 VDD VDD VSS VSS gf180mcu_fd_sc_mcu7t5v0__aoi22_1
XFILLER_42_317 VDD VDD VSS VSS gf180mcu_fd_sc_mcu7t5v0__fillcap_32
XFILLER_54_177 VDD VDD VSS VSS gf180mcu_fd_sc_mcu7t5v0__fillcap_32
XTAP_TAPCELL_ROW_85_1281 VDD VSS gf180mcu_fd_sc_mcu7t5v0__filltie
XTAP_TAPCELL_ROW_25_559 VDD VSS gf180mcu_fd_sc_mcu7t5v0__filltie
XFILLER_105_842 VDD VDD VSS VSS gf180mcu_fd_sc_mcu7t5v0__fillcap_4
XFILLER_105_864 VDD VDD VSS VSS gf180mcu_fd_sc_mcu7t5v0__fill_2
XFILLER_78_737 VDD VDD VSS VSS gf180mcu_fd_sc_mcu7t5v0__fillcap_32
XFILLER_78_715 VDD VDD VSS VSS gf180mcu_fd_sc_mcu7t5v0__fillcap_8
XFILLER_86_770 VDD VDD VSS VSS gf180mcu_fd_sc_mcu7t5v0__fill_1
XFILLER_34_807 VDD VDD VSS VSS gf180mcu_fd_sc_mcu7t5v0__fillcap_16
XFILLER_46_667 VDD VDD VSS VSS gf180mcu_fd_sc_mcu7t5v0__fillcap_32
XFILLER_60_103 VDD VDD VSS VSS gf180mcu_fd_sc_mcu7t5v0__fill_2
XFILLER_73_486 VDD VDD VSS VSS gf180mcu_fd_sc_mcu7t5v0__fillcap_4
XFILLER_26_380 VDD VDD VSS VSS gf180mcu_fd_sc_mcu7t5v0__fillcap_4
XFILLER_14_597 VDD VDD VSS VSS gf180mcu_fd_sc_mcu7t5v0__fillcap_64
XFILLER_41_372 VDD VDD VSS VSS gf180mcu_fd_sc_mcu7t5v0__fill_1
XTAP_TAPCELL_ROW_99_1439 VDD VSS gf180mcu_fd_sc_mcu7t5v0__filltie
XPHY_EDGE_ROW_116_Right_116 VDD VSS gf180mcu_fd_sc_mcu7t5v0__endcap
X_2450_ _2566_/Q _2775_/I _2445_/B _2451_/A2 VDD VDD VSS VSS gf180mcu_fd_sc_mcu7t5v0__nand3_1
X_1401_ _1489_/A1 _2325_/A2 _1401_/Z VDD VDD VSS VSS gf180mcu_fd_sc_mcu7t5v0__and2_1
X_2381_ _1207_/B _2383_/A2 _2382_/B VDD VDD VSS VSS gf180mcu_fd_sc_mcu7t5v0__nor2_1
XFILLER_96_501 VDD VDD VSS VSS gf180mcu_fd_sc_mcu7t5v0__fillcap_8
X_1332_ input19/Z _1396_/A2 _1332_/B1 _1444_/B2 _1333_/I VDD VDD VSS VSS gf180mcu_fd_sc_mcu7t5v0__aoi22_1
X_1263_ _1399_/A1 _1263_/A2 _1263_/ZN VDD VDD VSS VSS gf180mcu_fd_sc_mcu7t5v0__nor2_1
Xinput5 tl_d_dmem_i[12] input5/Z VDD VDD VSS VSS gf180mcu_fd_sc_mcu7t5v0__dlyd_1
XFILLER_64_453 VDD VDD VSS VSS gf180mcu_fd_sc_mcu7t5v0__fill_2
X_1194_ _1226_/A2 _1194_/A2 _1194_/ZN VDD VDD VSS VSS gf180mcu_fd_sc_mcu7t5v0__nor2_1
XTAP_TAPCELL_ROW_108_1557 VDD VSS gf180mcu_fd_sc_mcu7t5v0__filltie
XFILLER_24_317 VDD VDD VSS VSS gf180mcu_fd_sc_mcu7t5v0__fillcap_16
XFILLER_36_177 VDD VDD VSS VSS gf180mcu_fd_sc_mcu7t5v0__fillcap_16
XTAP_TAPCELL_ROW_22_518 VDD VSS gf180mcu_fd_sc_mcu7t5v0__filltie
X_2717_ _2717_/I _2717_/Z VDD VDD VSS VSS gf180mcu_fd_sc_mcu7t5v0__buf_1
X_2648_ _2720_/I _2648_/Z VDD VDD VSS VSS gf180mcu_fd_sc_mcu7t5v0__buf_1
X_2579_ _2579_/D _2580_/RN clkload1/I _2579_/Q VDD VDD VSS VSS gf180mcu_fd_sc_mcu7t5v0__dffrnq_1
XFILLER_99_372 VDD VDD VSS VSS gf180mcu_fd_sc_mcu7t5v0__fillcap_32
XFILLER_99_361 VDD VDD VSS VSS gf180mcu_fd_sc_mcu7t5v0__fill_2
XFILLER_101_333 VDD VDD VSS VSS gf180mcu_fd_sc_mcu7t5v0__fillcap_8
XFILLER_87_578 VDD VDD VSS VSS gf180mcu_fd_sc_mcu7t5v0__fillcap_4
XTAP_TAPCELL_ROW_58_949 VDD VSS gf180mcu_fd_sc_mcu7t5v0__filltie
XFILLER_16_807 VDD VDD VSS VSS gf180mcu_fd_sc_mcu7t5v0__fillcap_16
XFILLER_28_667 VDD VDD VSS VSS gf180mcu_fd_sc_mcu7t5v0__fillcap_64
XFILLER_15_317 VDD VDD VSS VSS gf180mcu_fd_sc_mcu7t5v0__fillcap_32
XFILLER_55_464 VDD VDD VSS VSS gf180mcu_fd_sc_mcu7t5v0__fillcap_16
XTAP_TAPCELL_ROW_2_276 VDD VSS gf180mcu_fd_sc_mcu7t5v0__filltie
XFILLER_70_489 VDD VDD VSS VSS gf180mcu_fd_sc_mcu7t5v0__fillcap_8
XFILLER_11_556 VDD VDD VSS VSS gf180mcu_fd_sc_mcu7t5v0__fillcap_4
XFILLER_109_422 VDD VDD VSS VSS gf180mcu_fd_sc_mcu7t5v0__fill_1
XFILLER_78_512 VDD VDD VSS VSS gf180mcu_fd_sc_mcu7t5v0__fillcap_8
XFILLER_78_501 VDD VDD VSS VSS gf180mcu_fd_sc_mcu7t5v0__fill_2
XFILLER_66_729 VDD VDD VSS VSS gf180mcu_fd_sc_mcu7t5v0__fillcap_4
XFILLER_65_206 VDD VDD VSS VSS gf180mcu_fd_sc_mcu7t5v0__fillcap_4
XFILLER_58_291 VDD VDD VSS VSS gf180mcu_fd_sc_mcu7t5v0__fillcap_4
XFILLER_80_209 VDD VDD VSS VSS gf180mcu_fd_sc_mcu7t5v0__fillcap_4
XFILLER_61_434 VDD VDD VSS VSS gf180mcu_fd_sc_mcu7t5v0__fill_2
XFILLER_73_294 VDD VDD VSS VSS gf180mcu_fd_sc_mcu7t5v0__fill_2
XFILLER_73_272 VDD VDD VSS VSS gf180mcu_fd_sc_mcu7t5v0__fillcap_8
X_1950_ _1950_/A1 _1964_/A2 _1952_/B1 _1950_/B2 _1951_/I VDD VDD VSS VSS gf180mcu_fd_sc_mcu7t5v0__aoi22_1
XTAP_TAPCELL_ROW_103_1487 VDD VSS gf180mcu_fd_sc_mcu7t5v0__filltie
X_1881_ _1881_/I _1881_/ZN VDD VDD VSS VSS gf180mcu_fd_sc_mcu7t5v0__clkinv_1
XTAP_TAPCELL_ROW_103_1498 VDD VSS gf180mcu_fd_sc_mcu7t5v0__filltie
X_2502_ _2593_/Q _2517_/B _2502_/Z VDD VDD VSS VSS gf180mcu_fd_sc_mcu7t5v0__xor2_1
Xoutput1003 _2296_/ZN tl_h_i_o[26] VDD VDD VSS VSS gf180mcu_fd_sc_mcu7t5v0__dlyd_1
Xoutput1014 _2336_/ZN tl_h_i_o[36] VDD VDD VSS VSS gf180mcu_fd_sc_mcu7t5v0__dlyd_1
XFILLER_44_2 VDD VDD VSS VSS gf180mcu_fd_sc_mcu7t5v0__fillcap_8
Xoutput1025 _2376_/ZN tl_h_i_o[46] VDD VDD VSS VSS gf180mcu_fd_sc_mcu7t5v0__dlyd_1
Xoutput1036 _2101_/Z tl_h_i_o[56] VDD VDD VSS VSS gf180mcu_fd_sc_mcu7t5v0__dlyd_1
Xoutput1047 _2057_/ZN tl_h_i_o[6] VDD VDD VSS VSS gf180mcu_fd_sc_mcu7t5v0__dlyd_1
X_2433_ _2563_/Q _2434_/B _2433_/B _2433_/C _2436_/B VDD VDD VSS VSS gf180mcu_fd_sc_mcu7t5v0__aoi211_1
XTAP_TAPCELL_ROW_71_1111 VDD VSS gf180mcu_fd_sc_mcu7t5v0__filltie
X_2364_ _2364_/A1 _2364_/A2 _2364_/B _2364_/ZN VDD VDD VSS VSS gf180mcu_fd_sc_mcu7t5v0__aoi21_1
X_1315_ _1339_/A1 _1313_/Z _1315_/B _1316_/B1 VDD VDD VSS VSS gf180mcu_fd_sc_mcu7t5v0__oai21_1
XFILLER_69_578 VDD VDD VSS VSS gf180mcu_fd_sc_mcu7t5v0__fillcap_4
X_2295_ input86/Z _2323_/A2 _2295_/A3 _2296_/A2 VDD VDD VSS VSS gf180mcu_fd_sc_mcu7t5v0__nand3_1
XPHY_EDGE_ROW_16_Left_135 VDD VSS gf180mcu_fd_sc_mcu7t5v0__endcap
X_1246_ _1248_/A3 _1246_/A2 _1246_/B _1247_/A3 VDD VDD VSS VSS gf180mcu_fd_sc_mcu7t5v0__aoi21_1
XFILLER_112_17 VDD VDD VSS VSS gf180mcu_fd_sc_mcu7t5v0__fill_1
X_1177_ _2560_/Q _2559_/Q _1179_/A2 VDD VDD VSS VSS gf180mcu_fd_sc_mcu7t5v0__nor2_1
XTAP_TAPCELL_ROW_55_919 VDD VSS gf180mcu_fd_sc_mcu7t5v0__filltie
XFILLER_25_626 VDD VDD VSS VSS gf180mcu_fd_sc_mcu7t5v0__fillcap_4
XTAP_TAPCELL_ROW_69_1084 VDD VSS gf180mcu_fd_sc_mcu7t5v0__filltie
XFILLER_80_732 VDD VDD VSS VSS gf180mcu_fd_sc_mcu7t5v0__fill_2
XTAP_TAPCELL_ROW_82_1240 VDD VSS gf180mcu_fd_sc_mcu7t5v0__filltie
XTAP_TAPCELL_ROW_35_676 VDD VSS gf180mcu_fd_sc_mcu7t5v0__filltie
XANTENNA_10 _2125_/ZN VDD VDD VSS VSS gf180mcu_fd_sc_mcu7t5v0__antenna
XANTENNA_21 _2711_/I VDD VDD VSS VSS gf180mcu_fd_sc_mcu7t5v0__antenna
XANTENNA_32 _2718_/I VDD VDD VSS VSS gf180mcu_fd_sc_mcu7t5v0__antenna
XPHY_EDGE_ROW_25_Left_144 VDD VSS gf180mcu_fd_sc_mcu7t5v0__endcap
XANTENNA_43 _2644_/Z VDD VDD VSS VSS gf180mcu_fd_sc_mcu7t5v0__antenna
XTAP_TAPCELL_ROW_7_346 VDD VSS gf180mcu_fd_sc_mcu7t5v0__filltie
XTAP_TAPCELL_ROW_7_335 VDD VSS gf180mcu_fd_sc_mcu7t5v0__filltie
XPHY_EDGE_ROW_34_Left_153 VDD VSS gf180mcu_fd_sc_mcu7t5v0__endcap
XFILLER_75_548 VDD VDD VSS VSS gf180mcu_fd_sc_mcu7t5v0__fillcap_4
XFILLER_28_453 VDD VDD VSS VSS gf180mcu_fd_sc_mcu7t5v0__fill_2
XFILLER_62_209 VDD VDD VSS VSS gf180mcu_fd_sc_mcu7t5v0__fillcap_16
XFILLER_55_272 VDD VDD VSS VSS gf180mcu_fd_sc_mcu7t5v0__fillcap_8
XFILLER_62_10 VDD VDD VSS VSS gf180mcu_fd_sc_mcu7t5v0__fillcap_16
XFILLER_43_489 VDD VDD VSS VSS gf180mcu_fd_sc_mcu7t5v0__fill_1
XPHY_EDGE_ROW_43_Left_162 VDD VSS gf180mcu_fd_sc_mcu7t5v0__endcap
XTAP_TAPCELL_ROW_96_1409 VDD VSS gf180mcu_fd_sc_mcu7t5v0__filltie
XPHY_EDGE_ROW_52_Left_171 VDD VSS gf180mcu_fd_sc_mcu7t5v0__endcap
XFILLER_98_618 VDD VDD VSS VSS gf180mcu_fd_sc_mcu7t5v0__fill_1
XFILLER_78_331 VDD VDD VSS VSS gf180mcu_fd_sc_mcu7t5v0__fillcap_32
XFILLER_38_217 VDD VDD VSS VSS gf180mcu_fd_sc_mcu7t5v0__fillcap_4
X_1100_ _1100_/I _2217_/A1 VDD VDD VSS VSS gf180mcu_fd_sc_mcu7t5v0__clkinv_1
XFILLER_66_559 VDD VDD VSS VSS gf180mcu_fd_sc_mcu7t5v0__fillcap_16
X_2080_ _2178_/B2 _2315_/A2 _2357_/A1 _2178_/A1 _2081_/I VDD VDD VSS VSS gf180mcu_fd_sc_mcu7t5v0__aoi22_1
XFILLER_53_209 VDD VDD VSS VSS gf180mcu_fd_sc_mcu7t5v0__fill_1
XFILLER_19_486 VDD VDD VSS VSS gf180mcu_fd_sc_mcu7t5v0__fillcap_4
XFILLER_62_721 VDD VDD VSS VSS gf180mcu_fd_sc_mcu7t5v0__fillcap_8
XTAP_TAPCELL_ROW_105_1516 VDD VSS gf180mcu_fd_sc_mcu7t5v0__filltie
XFILLER_61_253 VDD VDD VSS VSS gf180mcu_fd_sc_mcu7t5v0__fillcap_16
XPHY_EDGE_ROW_61_Left_180 VDD VSS gf180mcu_fd_sc_mcu7t5v0__endcap
X_1933_ _1933_/I _1933_/ZN VDD VDD VSS VSS gf180mcu_fd_sc_mcu7t5v0__clkinv_1
XTAP_TAPCELL_ROW_32_646 VDD VSS gf180mcu_fd_sc_mcu7t5v0__filltie
XTAP_TAPCELL_ROW_32_635 VDD VSS gf180mcu_fd_sc_mcu7t5v0__filltie
XTAP_TAPCELL_ROW_60_977 VDD VSS gf180mcu_fd_sc_mcu7t5v0__filltie
Xinput30 tl_d_dmem_i[35] input30/Z VDD VDD VSS VSS gf180mcu_fd_sc_mcu7t5v0__dlyd_1
X_1864_ _1864_/A1 _1900_/A2 _1900_/B1 _1864_/B2 _1865_/I VDD VDD VSS VSS gf180mcu_fd_sc_mcu7t5v0__aoi22_1
Xinput41 tl_d_dmem_i[45] input41/Z VDD VDD VSS VSS gf180mcu_fd_sc_mcu7t5v0__dlyd_1
Xinput52 tl_d_dmem_i[55] input52/Z VDD VDD VSS VSS gf180mcu_fd_sc_mcu7t5v0__dlyd_1
Xinput63 tl_d_dmem_i[65] input63/Z VDD VDD VSS VSS gf180mcu_fd_sc_mcu7t5v0__dlyd_1
X_1795_ _1795_/I _1795_/ZN VDD VDD VSS VSS gf180mcu_fd_sc_mcu7t5v0__clkinv_1
Xinput74 tl_d_esram_i[15] input74/Z VDD VDD VSS VSS gf180mcu_fd_sc_mcu7t5v0__dlyd_1
Xinput85 tl_d_esram_i[25] input85/Z VDD VDD VSS VSS gf180mcu_fd_sc_mcu7t5v0__dlyd_1
Xinput96 tl_d_esram_i[35] input96/Z VDD VDD VSS VSS gf180mcu_fd_sc_mcu7t5v0__dlyd_1
XTAP_TAPCELL_ROW_116_1645 VDD VSS gf180mcu_fd_sc_mcu7t5v0__filltie
X_2416_ _2415_/B _2416_/A2 _2416_/Z VDD VDD VSS VSS gf180mcu_fd_sc_mcu7t5v0__xor2_1
XTAP_TAPCELL_ROW_4_305 VDD VSS gf180mcu_fd_sc_mcu7t5v0__filltie
X_2347_ _2347_/A1 _2347_/A2 _2379_/A3 _2348_/A2 VDD VDD VSS VSS gf180mcu_fd_sc_mcu7t5v0__nand3_1
XFILLER_69_375 VDD VDD VSS VSS gf180mcu_fd_sc_mcu7t5v0__fillcap_32
X_2278_ _2346_/A1 _2278_/A2 _2280_/A1 VDD VDD VSS VSS gf180mcu_fd_sc_mcu7t5v0__nand2_1
X_1229_ _1158_/Z _2538_/A2 _2702_/I VDD VDD VSS VSS gf180mcu_fd_sc_mcu7t5v0__nand2_1
XFILLER_25_467 VDD VDD VSS VSS gf180mcu_fd_sc_mcu7t5v0__fillcap_16
XFILLER_52_220 VDD VDD VSS VSS gf180mcu_fd_sc_mcu7t5v0__fillcap_8
XFILLER_25_489 VDD VDD VSS VSS gf180mcu_fd_sc_mcu7t5v0__fill_1
XFILLER_52_286 VDD VDD VSS VSS gf180mcu_fd_sc_mcu7t5v0__fill_2
XFILLER_52_297 VDD VDD VSS VSS gf180mcu_fd_sc_mcu7t5v0__fillcap_16
XFILLER_79_139 VDD VDD VSS VSS gf180mcu_fd_sc_mcu7t5v0__fill_1
Xinput401 tl_h_i_i[16] _2386_/I0 VDD VDD VSS VSS gf180mcu_fd_sc_mcu7t5v0__dlyd_1
Xinput412 tl_h_i_i[26] _1906_/A1 VDD VDD VSS VSS gf180mcu_fd_sc_mcu7t5v0__dlyd_1
XFILLER_0_577 VDD VDD VSS VSS gf180mcu_fd_sc_mcu7t5v0__fill_1
Xinput423 tl_h_i_i[36] _1926_/A1 VDD VDD VSS VSS gf180mcu_fd_sc_mcu7t5v0__dlyd_1
Xinput434 tl_h_i_i[46] _1946_/A1 VDD VDD VSS VSS gf180mcu_fd_sc_mcu7t5v0__dlyd_1
Xinput445 tl_h_i_i[56] _1966_/A1 VDD VDD VSS VSS gf180mcu_fd_sc_mcu7t5v0__dlyd_1
Xinput456 tl_h_i_i[66] _1986_/A1 VDD VDD VSS VSS gf180mcu_fd_sc_mcu7t5v0__dlyd_1
Xinput467 tl_h_i_i[76] _2006_/A1 VDD VDD VSS VSS gf180mcu_fd_sc_mcu7t5v0__dlyd_1
Xinput478 tl_h_i_i[86] _1164_/A4 VDD VDD VSS VSS gf180mcu_fd_sc_mcu7t5v0__dlyd_1
XFILLER_35_209 VDD VDD VSS VSS gf180mcu_fd_sc_mcu7t5v0__fill_1
Xinput489 tl_h_i_i[96] _1161_/A2 VDD VDD VSS VSS gf180mcu_fd_sc_mcu7t5v0__dlyd_1
XFILLER_71_562 VDD VDD VSS VSS gf180mcu_fd_sc_mcu7t5v0__fillcap_32
XTAP_TAPCELL_ROW_100_1457 VDD VSS gf180mcu_fd_sc_mcu7t5v0__filltie
Xoutput919 _2773_/Z tl_h_d_o[0] VDD VDD VSS VSS gf180mcu_fd_sc_mcu7t5v0__dlyd_1
Xoutput908 _2749_/Z tl_d_uart_o[90] VDD VDD VSS VSS gf180mcu_fd_sc_mcu7t5v0__dlyd_1
X_1580_ _1874_/B2 _1579_/Z _1600_/S _1580_/Z VDD VDD VSS VSS gf180mcu_fd_sc_mcu7t5v0__mux2_2
XFILLER_39_504 VDD VDD VSS VSS gf180mcu_fd_sc_mcu7t5v0__fillcap_32
X_2201_ _2157_/B _2201_/A2 _2201_/A3 _2202_/C VDD VDD VSS VSS gf180mcu_fd_sc_mcu7t5v0__nand3_1
XTAP_TAPCELL_ROW_111_1586 VDD VSS gf180mcu_fd_sc_mcu7t5v0__filltie
Xfanout1172 _1106_/ZN _1217_/C VDD VDD VSS VSS gf180mcu_fd_sc_mcu7t5v0__dlyd_1
X_2132_ _2132_/A1 _2132_/A2 _2132_/B _2132_/ZN VDD VDD VSS VSS gf180mcu_fd_sc_mcu7t5v0__oai21_1
XTAP_TAPCELL_ROW_37_705 VDD VSS gf180mcu_fd_sc_mcu7t5v0__filltie
XFILLER_47_592 VDD VDD VSS VSS gf180mcu_fd_sc_mcu7t5v0__fill_1
X_2063_ _2102_/B2 _2063_/A2 _2064_/C VDD VDD VSS VSS gf180mcu_fd_sc_mcu7t5v0__nand2_1
XFILLER_19_294 VDD VDD VSS VSS gf180mcu_fd_sc_mcu7t5v0__fill_1
XTAP_TAPCELL_ROW_66_1054 VDD VSS gf180mcu_fd_sc_mcu7t5v0__filltie
XTAP_TAPCELL_ROW_66_1043 VDD VSS gf180mcu_fd_sc_mcu7t5v0__filltie
XFILLER_81_348 VDD VDD VSS VSS gf180mcu_fd_sc_mcu7t5v0__fill_2
XTAP_TAPCELL_ROW_17_462 VDD VSS gf180mcu_fd_sc_mcu7t5v0__filltie
XFILLER_22_437 VDD VDD VSS VSS gf180mcu_fd_sc_mcu7t5v0__fillcap_8
XTAP_TAPCELL_ROW_45_793 VDD VSS gf180mcu_fd_sc_mcu7t5v0__filltie
X_1916_ _1916_/A1 _1938_/A2 _1926_/B1 _1916_/B2 _1917_/I VDD VDD VSS VSS gf180mcu_fd_sc_mcu7t5v0__aoi22_1
X_1847_ _1847_/I _1847_/ZN VDD VDD VSS VSS gf180mcu_fd_sc_mcu7t5v0__clkinv_1
X_1778_ _1968_/A1 _1822_/A2 _1812_/B1 _1968_/B2 _1779_/I VDD VDD VSS VSS gf180mcu_fd_sc_mcu7t5v0__aoi22_1
XTAP_TAPCELL_ROW_77_1183 VDD VSS gf180mcu_fd_sc_mcu7t5v0__filltie
XFILLER_97_492 VDD VDD VSS VSS gf180mcu_fd_sc_mcu7t5v0__fillcap_32
XFILLER_85_621 VDD VDD VSS VSS gf180mcu_fd_sc_mcu7t5v0__fillcap_8
XFILLER_81_860 VDD VDD VSS VSS gf180mcu_fd_sc_mcu7t5v0__fillcap_4
XFILLER_41_702 VDD VDD VSS VSS gf180mcu_fd_sc_mcu7t5v0__fillcap_64
XFILLER_53_562 VDD VDD VSS VSS gf180mcu_fd_sc_mcu7t5v0__fillcap_8
XFILLER_40_267 VDD VDD VSS VSS gf180mcu_fd_sc_mcu7t5v0__fill_2
XFILLER_21_492 VDD VDD VSS VSS gf180mcu_fd_sc_mcu7t5v0__fillcap_64
XFILLER_1_842 VDD VDD VSS VSS gf180mcu_fd_sc_mcu7t5v0__fillcap_16
Xinput220 tl_d_uart_i[28] _1358_/A1 VDD VDD VSS VSS gf180mcu_fd_sc_mcu7t5v0__dlyd_1
Xxbar_tlul_2to4_1257 tl_d_esram_o[88] VDD VDD VSS VSS gf180mcu_fd_sc_mcu7t5v0__tiel
Xxbar_tlul_2to4_1268 tl_d_rom_o[92] VDD VDD VSS VSS gf180mcu_fd_sc_mcu7t5v0__tiel
XFILLER_95_407 VDD VDD VSS VSS gf180mcu_fd_sc_mcu7t5v0__fillcap_8
XFILLER_48_312 VDD VDD VSS VSS gf180mcu_fd_sc_mcu7t5v0__fill_2
Xinput231 tl_d_uart_i[38] _1438_/A1 VDD VDD VSS VSS gf180mcu_fd_sc_mcu7t5v0__dlyd_1
Xinput242 tl_d_uart_i[48] _2177_/A1 VDD VDD VSS VSS gf180mcu_fd_sc_mcu7t5v0__dlyd_1
Xinput253 tl_d_uart_i[58] _1102_/I VDD VDD VSS VSS gf180mcu_fd_sc_mcu7t5v0__dlyd_1
Xxbar_tlul_2to4_1279 tl_d_rom_o[81] VDD VDD VSS VSS gf180mcu_fd_sc_mcu7t5v0__tiel
XFILLER_76_621 VDD VDD VSS VSS gf180mcu_fd_sc_mcu7t5v0__fill_1
Xinput264 tl_d_uart_i[8] _2137_/A1 VDD VDD VSS VSS gf180mcu_fd_sc_mcu7t5v0__dlyd_1
Xinput275 tl_h_d_i[108] _2767_/I VDD VDD VSS VSS gf180mcu_fd_sc_mcu7t5v0__dlyd_1
Xinput286 tl_h_d_i[15] _1694_/B2 VDD VDD VSS VSS gf180mcu_fd_sc_mcu7t5v0__clkbuf_2
Xinput297 tl_h_d_i[25] _2716_/I VDD VDD VSS VSS gf180mcu_fd_sc_mcu7t5v0__dlyd_1
XFILLER_75_142 VDD VDD VSS VSS gf180mcu_fd_sc_mcu7t5v0__fillcap_64
XFILLER_31_212 VDD VDD VSS VSS gf180mcu_fd_sc_mcu7t5v0__fillcap_16
XTAP_TAPCELL_ROW_14_421 VDD VSS gf180mcu_fd_sc_mcu7t5v0__filltie
XTAP_TAPCELL_ROW_42_763 VDD VSS gf180mcu_fd_sc_mcu7t5v0__filltie
X_2750_ _2750_/I _2750_/Z VDD VDD VSS VSS gf180mcu_fd_sc_mcu7t5v0__buf_1
X_2681_ _2753_/I _2681_/Z VDD VDD VSS VSS gf180mcu_fd_sc_mcu7t5v0__buf_1
X_1701_ _1701_/I _1701_/ZN VDD VDD VSS VSS gf180mcu_fd_sc_mcu7t5v0__clkinv_1
X_1632_ _1936_/B2 _1641_/A2 _1632_/Z VDD VDD VSS VSS gf180mcu_fd_sc_mcu7t5v0__or2_1
Xoutput727 _1695_/ZN tl_d_rom_o[15] VDD VDD VSS VSS gf180mcu_fd_sc_mcu7t5v0__dlyd_1
Xoutput716 _1847_/ZN tl_d_rom_o[108] VDD VDD VSS VSS gf180mcu_fd_sc_mcu7t5v0__dlyd_1
Xoutput705 _2019_/ZN tl_d_esram_o[99] VDD VDD VSS VSS gf180mcu_fd_sc_mcu7t5v0__dlyd_1
XTAP_TAPCELL_ROW_113_1615 VDD VSS gf180mcu_fd_sc_mcu7t5v0__filltie
Xoutput749 _1735_/ZN tl_d_rom_o[35] VDD VDD VSS VSS gf180mcu_fd_sc_mcu7t5v0__dlyd_1
Xoutput738 _1715_/ZN tl_d_rom_o[25] VDD VDD VSS VSS gf180mcu_fd_sc_mcu7t5v0__dlyd_1
X_1563_ _1574_/A1 _1560_/Z _1562_/Z _1563_/Z VDD VDD VSS VSS gf180mcu_fd_sc_mcu7t5v0__xor3_1
X_1494_ _1494_/A1 _1510_/A2 _1494_/B1 _1217_/C _1495_/A2 VDD VDD VSS VSS gf180mcu_fd_sc_mcu7t5v0__aoi22_1
XFILLER_100_217 VDD VDD VSS VSS gf180mcu_fd_sc_mcu7t5v0__fill_1
XFILLER_104_18 VDD VDD VSS VSS gf180mcu_fd_sc_mcu7t5v0__fill_1
XFILLER_39_334 VDD VDD VSS VSS gf180mcu_fd_sc_mcu7t5v0__fillcap_16
XFILLER_67_632 VDD VDD VSS VSS gf180mcu_fd_sc_mcu7t5v0__fillcap_32
XFILLER_79_492 VDD VDD VSS VSS gf180mcu_fd_sc_mcu7t5v0__fillcap_16
XFILLER_94_451 VDD VDD VSS VSS gf180mcu_fd_sc_mcu7t5v0__fillcap_4
XFILLER_39_378 VDD VDD VSS VSS gf180mcu_fd_sc_mcu7t5v0__fill_1
X_2115_ _2115_/A1 _2171_/B _2118_/B VDD VDD VSS VSS gf180mcu_fd_sc_mcu7t5v0__nand2_1
XFILLER_82_613 VDD VDD VSS VSS gf180mcu_fd_sc_mcu7t5v0__fillcap_4
X_2046_ input79/Z _2064_/B _2102_/B2 _2112_/A1 _2047_/I VDD VDD VSS VSS gf180mcu_fd_sc_mcu7t5v0__oai22_1
XFILLER_23_702 VDD VDD VSS VSS gf180mcu_fd_sc_mcu7t5v0__fillcap_64
XFILLER_35_562 VDD VDD VSS VSS gf180mcu_fd_sc_mcu7t5v0__fillcap_16
XFILLER_22_256 VDD VDD VSS VSS gf180mcu_fd_sc_mcu7t5v0__fillcap_32
XTAP_TAPCELL_ROW_79_1201 VDD VSS gf180mcu_fd_sc_mcu7t5v0__filltie
XFILLER_89_212 VDD VDD VSS VSS gf180mcu_fd_sc_mcu7t5v0__fillcap_64
XPHY_EDGE_ROW_8_Left_127 VDD VSS gf180mcu_fd_sc_mcu7t5v0__endcap
XFILLER_38_34 VDD VDD VSS VSS gf180mcu_fd_sc_mcu7t5v0__fill_1
XFILLER_58_621 VDD VDD VSS VSS gf180mcu_fd_sc_mcu7t5v0__fill_1
XFILLER_57_186 VDD VDD VSS VSS gf180mcu_fd_sc_mcu7t5v0__fillcap_16
XFILLER_72_101 VDD VDD VSS VSS gf180mcu_fd_sc_mcu7t5v0__fillcap_4
XFILLER_72_123 VDD VDD VSS VSS gf180mcu_fd_sc_mcu7t5v0__fillcap_8
XFILLER_0_160 VDD VDD VSS VSS gf180mcu_fd_sc_mcu7t5v0__fillcap_8
XFILLER_49_632 VDD VDD VSS VSS gf180mcu_fd_sc_mcu7t5v0__fillcap_4
XFILLER_76_451 VDD VDD VSS VSS gf180mcu_fd_sc_mcu7t5v0__fillcap_4
XFILLER_49_698 VDD VDD VSS VSS gf180mcu_fd_sc_mcu7t5v0__fill_2
XFILLER_64_613 VDD VDD VSS VSS gf180mcu_fd_sc_mcu7t5v0__fillcap_4
XTAP_TAPCELL_ROW_47_822 VDD VSS gf180mcu_fd_sc_mcu7t5v0__filltie
Xclkbuf_3_5__f_clk_i clkbuf_0_clk_i/Z clkload5/I VDD VDD VSS VSS gf180mcu_fd_sc_mcu7t5v0__clkbuf_16
XFILLER_17_562 VDD VDD VSS VSS gf180mcu_fd_sc_mcu7t5v0__fillcap_64
XFILLER_45_860 VDD VDD VSS VSS gf180mcu_fd_sc_mcu7t5v0__fillcap_4
XFILLER_32_521 VDD VDD VSS VSS gf180mcu_fd_sc_mcu7t5v0__fillcap_4
XFILLER_44_392 VDD VDD VSS VSS gf180mcu_fd_sc_mcu7t5v0__fill_2
XTAP_TAPCELL_ROW_63_1013 VDD VSS gf180mcu_fd_sc_mcu7t5v0__filltie
X_2733_ _2733_/I _2733_/Z VDD VDD VSS VSS gf180mcu_fd_sc_mcu7t5v0__buf_1
X_2664_ _2736_/I _2664_/Z VDD VDD VSS VSS gf180mcu_fd_sc_mcu7t5v0__buf_1
Xoutput502 _2694_/Z tl_d_dmem_o[107] VDD VDD VSS VSS gf180mcu_fd_sc_mcu7t5v0__dlyd_1
X_2595_ _2595_/D _2597_/RN _2596_/CLK _2595_/Q VDD VDD VSS VSS gf180mcu_fd_sc_mcu7t5v0__dffrnq_1
Xoutput513 _1619_/Z tl_d_dmem_o[14] VDD VDD VSS VSS gf180mcu_fd_sc_mcu7t5v0__dlyd_1
Xoutput524 _2643_/Z tl_d_dmem_o[24] VDD VDD VSS VSS gf180mcu_fd_sc_mcu7t5v0__dlyd_1
Xoutput535 _1517_/Z tl_d_dmem_o[34] VDD VDD VSS VSS gf180mcu_fd_sc_mcu7t5v0__dlyd_1
X_1615_ _2750_/I _2735_/I _1567_/Z _1615_/Z VDD VDD VSS VSS gf180mcu_fd_sc_mcu7t5v0__xor3_1
XFILLER_114_865 VDD VDD VSS VSS gf180mcu_fd_sc_mcu7t5v0__fill_1
Xoutput546 _1527_/Z tl_d_dmem_o[44] VDD VDD VSS VSS gf180mcu_fd_sc_mcu7t5v0__dlyd_1
Xoutput557 _1537_/Z tl_d_dmem_o[54] VDD VDD VSS VSS gf180mcu_fd_sc_mcu7t5v0__dlyd_1
Xoutput568 _2651_/Z tl_d_dmem_o[64] VDD VDD VSS VSS gf180mcu_fd_sc_mcu7t5v0__dlyd_1
X_1546_ _1860_/B2 _1550_/A2 _1546_/Z VDD VDD VSS VSS gf180mcu_fd_sc_mcu7t5v0__or2_1
XTAP_TAPCELL_ROW_74_1142 VDD VSS gf180mcu_fd_sc_mcu7t5v0__filltie
Xoutput579 _2661_/Z tl_d_dmem_o[74] VDD VDD VSS VSS gf180mcu_fd_sc_mcu7t5v0__dlyd_1
XFILLER_99_576 VDD VDD VSS VSS gf180mcu_fd_sc_mcu7t5v0__fill_1
X_1477_ _1477_/I _1478_/B1 VDD VDD VSS VSS gf180mcu_fd_sc_mcu7t5v0__clkinv_1
XFILLER_39_142 VDD VDD VSS VSS gf180mcu_fd_sc_mcu7t5v0__fillcap_4
XFILLER_55_602 VDD VDD VSS VSS gf180mcu_fd_sc_mcu7t5v0__fillcap_4
XFILLER_27_337 VDD VDD VSS VSS gf180mcu_fd_sc_mcu7t5v0__fillcap_8
XFILLER_82_454 VDD VDD VSS VSS gf180mcu_fd_sc_mcu7t5v0__fill_1
XFILLER_54_167 VDD VDD VSS VSS gf180mcu_fd_sc_mcu7t5v0__fillcap_8
XFILLER_82_476 VDD VDD VSS VSS gf180mcu_fd_sc_mcu7t5v0__fillcap_32
XFILLER_24_14 VDD VDD VSS VSS gf180mcu_fd_sc_mcu7t5v0__fill_2
X_2029_ _2029_/I _2029_/ZN VDD VDD VSS VSS gf180mcu_fd_sc_mcu7t5v0__clkinv_1
XTAP_TAPCELL_ROW_85_1282 VDD VSS gf180mcu_fd_sc_mcu7t5v0__filltie
XTAP_TAPCELL_ROW_85_1271 VDD VSS gf180mcu_fd_sc_mcu7t5v0__filltie
XFILLER_50_373 VDD VDD VSS VSS gf180mcu_fd_sc_mcu7t5v0__fillcap_8
XFILLER_50_395 VDD VDD VSS VSS gf180mcu_fd_sc_mcu7t5v0__fillcap_16
XFILLER_78_727 VDD VDD VSS VSS gf180mcu_fd_sc_mcu7t5v0__fill_2
XFILLER_77_226 VDD VDD VSS VSS gf180mcu_fd_sc_mcu7t5v0__fill_1
XFILLER_93_719 VDD VDD VSS VSS gf180mcu_fd_sc_mcu7t5v0__fillcap_4
XFILLER_58_473 VDD VDD VSS VSS gf180mcu_fd_sc_mcu7t5v0__fillcap_4
XFILLER_92_229 VDD VDD VSS VSS gf180mcu_fd_sc_mcu7t5v0__fill_1
XFILLER_14_521 VDD VDD VSS VSS gf180mcu_fd_sc_mcu7t5v0__fillcap_4
XFILLER_54_690 VDD VDD VSS VSS gf180mcu_fd_sc_mcu7t5v0__fillcap_16
XTAP_TAPCELL_ROW_52_880 VDD VSS gf180mcu_fd_sc_mcu7t5v0__filltie
X_1400_ _1400_/A1 _1496_/A2 _2325_/A2 VDD VDD VSS VSS gf180mcu_fd_sc_mcu7t5v0__nand2_1
X_2380_ _2380_/A1 _2380_/A2 _2380_/B _2380_/ZN VDD VDD VSS VSS gf180mcu_fd_sc_mcu7t5v0__aoi21_1
XFILLER_96_513 VDD VDD VSS VSS gf180mcu_fd_sc_mcu7t5v0__fill_2
X_1331_ _1491_/A1 _1329_/Z _1331_/B _1332_/B1 VDD VDD VSS VSS gf180mcu_fd_sc_mcu7t5v0__oai21_1
XFILLER_68_259 VDD VDD VSS VSS gf180mcu_fd_sc_mcu7t5v0__fill_2
X_1262_ _1262_/A1 _1398_/A2 _1262_/B1 _2146_/C _1263_/A2 VDD VDD VSS VSS gf180mcu_fd_sc_mcu7t5v0__aoi22_1
XFILLER_37_602 VDD VDD VSS VSS gf180mcu_fd_sc_mcu7t5v0__fill_2
Xinput6 tl_d_dmem_i[13] input6/Z VDD VDD VSS VSS gf180mcu_fd_sc_mcu7t5v0__dlyd_1
X_1193_ _1226_/A1 _1196_/A2 _1194_/A2 VDD VDD VSS VSS gf180mcu_fd_sc_mcu7t5v0__nor2_1
XTAP_TAPCELL_ROW_108_1547 VDD VSS gf180mcu_fd_sc_mcu7t5v0__filltie
XTAP_TAPCELL_ROW_108_1558 VDD VSS gf180mcu_fd_sc_mcu7t5v0__filltie
XFILLER_51_137 VDD VDD VSS VSS gf180mcu_fd_sc_mcu7t5v0__fill_2
XFILLER_32_384 VDD VDD VSS VSS gf180mcu_fd_sc_mcu7t5v0__fill_1
XTAP_TAPCELL_ROW_22_519 VDD VSS gf180mcu_fd_sc_mcu7t5v0__filltie
XFILLER_32_395 VDD VDD VSS VSS gf180mcu_fd_sc_mcu7t5v0__fill_1
XPHY_EDGE_ROW_89_Left_208 VDD VSS gf180mcu_fd_sc_mcu7t5v0__endcap
X_2716_ _2716_/I _2716_/Z VDD VDD VSS VSS gf180mcu_fd_sc_mcu7t5v0__buf_1
XFILLER_10_16 VDD VDD VSS VSS gf180mcu_fd_sc_mcu7t5v0__fill_1
XFILLER_118_478 VDD VDD VSS VSS gf180mcu_fd_sc_mcu7t5v0__fill_1
X_2647_ _2719_/I _2647_/Z VDD VDD VSS VSS gf180mcu_fd_sc_mcu7t5v0__buf_1
X_2578_ _2578_/D _2601_/RN clkload5/I _2578_/Q VDD VDD VSS VSS gf180mcu_fd_sc_mcu7t5v0__dffrnq_1
XFILLER_99_340 VDD VDD VSS VSS gf180mcu_fd_sc_mcu7t5v0__fill_1
X_1529_ _1946_/B2 _1533_/A2 _1529_/Z VDD VDD VSS VSS gf180mcu_fd_sc_mcu7t5v0__or2_1
XTAP_TAPCELL_ROW_87_1300 VDD VSS gf180mcu_fd_sc_mcu7t5v0__filltie
XPHY_EDGE_ROW_98_Left_217 VDD VSS gf180mcu_fd_sc_mcu7t5v0__endcap
XFILLER_28_657 VDD VDD VSS VSS gf180mcu_fd_sc_mcu7t5v0__fillcap_8
XTAP_TAPCELL_ROW_2_277 VDD VSS gf180mcu_fd_sc_mcu7t5v0__filltie
XFILLER_27_189 VDD VDD VSS VSS gf180mcu_fd_sc_mcu7t5v0__fillcap_8
XFILLER_82_273 VDD VDD VSS VSS gf180mcu_fd_sc_mcu7t5v0__fill_2
XFILLER_70_457 VDD VDD VSS VSS gf180mcu_fd_sc_mcu7t5v0__fillcap_32
XPHY_EDGE_ROW_14_Right_14 VDD VSS gf180mcu_fd_sc_mcu7t5v0__endcap
XFILLER_109_489 VDD VDD VSS VSS gf180mcu_fd_sc_mcu7t5v0__fill_1
XFILLER_4_2 VDD VDD VSS VSS gf180mcu_fd_sc_mcu7t5v0__fillcap_32
XPHY_EDGE_ROW_23_Right_23 VDD VSS gf180mcu_fd_sc_mcu7t5v0__endcap
XFILLER_78_524 VDD VDD VSS VSS gf180mcu_fd_sc_mcu7t5v0__fill_1
XFILLER_74_730 VDD VDD VSS VSS gf180mcu_fd_sc_mcu7t5v0__fillcap_4
XFILLER_15_863 VDD VDD VSS VSS gf180mcu_fd_sc_mcu7t5v0__fill_2
XPHY_EDGE_ROW_32_Right_32 VDD VSS gf180mcu_fd_sc_mcu7t5v0__endcap
XFILLER_14_384 VDD VDD VSS VSS gf180mcu_fd_sc_mcu7t5v0__fill_1
X_1880_ _1880_/A1 _1914_/A2 _1914_/B1 _1880_/B2 _1881_/I VDD VDD VSS VSS gf180mcu_fd_sc_mcu7t5v0__aoi22_1
XTAP_TAPCELL_ROW_103_1488 VDD VSS gf180mcu_fd_sc_mcu7t5v0__filltie
X_2501_ _2593_/Q _2517_/B _2511_/A1 VDD VDD VSS VSS gf180mcu_fd_sc_mcu7t5v0__nand2_1
Xoutput1004 _2300_/ZN tl_h_i_o[27] VDD VDD VSS VSS gf180mcu_fd_sc_mcu7t5v0__dlyd_1
Xoutput1015 _2340_/ZN tl_h_i_o[37] VDD VDD VSS VSS gf180mcu_fd_sc_mcu7t5v0__dlyd_1
Xoutput1026 _2380_/ZN tl_h_i_o[47] VDD VDD VSS VSS gf180mcu_fd_sc_mcu7t5v0__dlyd_1
Xoutput1037 _2103_/ZN tl_h_i_o[57] VDD VDD VSS VSS gf180mcu_fd_sc_mcu7t5v0__dlyd_1
Xoutput1048 _2059_/ZN tl_h_i_o[7] VDD VDD VSS VSS gf180mcu_fd_sc_mcu7t5v0__dlyd_1
X_2432_ _2439_/A2 _2451_/B _2432_/B _2563_/D VDD VDD VSS VSS gf180mcu_fd_sc_mcu7t5v0__aoi21_1
XTAP_TAPCELL_ROW_71_1112 VDD VSS gf180mcu_fd_sc_mcu7t5v0__filltie
XPHY_EDGE_ROW_41_Right_41 VDD VSS gf180mcu_fd_sc_mcu7t5v0__endcap
X_2363_ _2363_/A1 _2363_/A2 _2363_/A3 _2364_/A2 VDD VDD VSS VSS gf180mcu_fd_sc_mcu7t5v0__nand3_1
XFILLER_96_310 VDD VDD VSS VSS gf180mcu_fd_sc_mcu7t5v0__fillcap_4
XFILLER_69_535 VDD VDD VSS VSS gf180mcu_fd_sc_mcu7t5v0__fill_2
X_1314_ input83/Z _2116_/B1 _2259_/A3 _1315_/B VDD VDD VSS VSS gf180mcu_fd_sc_mcu7t5v0__nand3_1
X_2294_ _2358_/A1 _2294_/A2 _2296_/A1 VDD VDD VSS VSS gf180mcu_fd_sc_mcu7t5v0__nand2_1
XFILLER_96_387 VDD VDD VSS VSS gf180mcu_fd_sc_mcu7t5v0__fillcap_32
XFILLER_84_527 VDD VDD VSS VSS gf180mcu_fd_sc_mcu7t5v0__fillcap_64
X_1245_ _1245_/I _1245_/ZN VDD VDD VSS VSS gf180mcu_fd_sc_mcu7t5v0__clkinv_1
XFILLER_37_454 VDD VDD VSS VSS gf180mcu_fd_sc_mcu7t5v0__fillcap_4
X_1176_ _2566_/Q _2565_/Q _2567_/Q _1179_/A1 VDD VDD VSS VSS gf180mcu_fd_sc_mcu7t5v0__nor3_1
XFILLER_37_487 VDD VDD VSS VSS gf180mcu_fd_sc_mcu7t5v0__fill_2
XTAP_TAPCELL_ROW_69_1085 VDD VSS gf180mcu_fd_sc_mcu7t5v0__filltie
XPHY_EDGE_ROW_50_Right_50 VDD VSS gf180mcu_fd_sc_mcu7t5v0__endcap
XFILLER_52_457 VDD VDD VSS VSS gf180mcu_fd_sc_mcu7t5v0__fillcap_64
XTAP_TAPCELL_ROW_82_1241 VDD VSS gf180mcu_fd_sc_mcu7t5v0__filltie
XTAP_TAPCELL_ROW_35_677 VDD VSS gf180mcu_fd_sc_mcu7t5v0__filltie
XANTENNA_11 _2204_/ZN VDD VDD VSS VSS gf180mcu_fd_sc_mcu7t5v0__antenna
XANTENNA_22 _1295_/ZN VDD VDD VSS VSS gf180mcu_fd_sc_mcu7t5v0__antenna
XFILLER_32_181 VDD VDD VSS VSS gf180mcu_fd_sc_mcu7t5v0__fill_2
XANTENNA_33 _2718_/I VDD VDD VSS VSS gf180mcu_fd_sc_mcu7t5v0__antenna
XANTENNA_44 _1512_/Z VDD VDD VSS VSS gf180mcu_fd_sc_mcu7t5v0__antenna
XFILLER_20_387 VDD VDD VSS VSS gf180mcu_fd_sc_mcu7t5v0__fillcap_8
XTAP_TAPCELL_ROW_93_1370 VDD VSS gf180mcu_fd_sc_mcu7t5v0__filltie
XTAP_TAPCELL_ROW_7_336 VDD VSS gf180mcu_fd_sc_mcu7t5v0__filltie
XFILLER_87_343 VDD VDD VSS VSS gf180mcu_fd_sc_mcu7t5v0__fillcap_4
XFILLER_48_719 VDD VDD VSS VSS gf180mcu_fd_sc_mcu7t5v0__fill_1
XFILLER_46_12 VDD VDD VSS VSS gf180mcu_fd_sc_mcu7t5v0__fill_1
XFILLER_71_766 VDD VDD VSS VSS gf180mcu_fd_sc_mcu7t5v0__fillcap_4
XFILLER_70_232 VDD VDD VSS VSS gf180mcu_fd_sc_mcu7t5v0__fillcap_8
XFILLER_11_332 VDD VDD VSS VSS gf180mcu_fd_sc_mcu7t5v0__fillcap_16
XFILLER_66_527 VDD VDD VSS VSS gf180mcu_fd_sc_mcu7t5v0__fillcap_32
XFILLER_93_313 VDD VDD VSS VSS gf180mcu_fd_sc_mcu7t5v0__fill_2
XFILLER_62_733 VDD VDD VSS VSS gf180mcu_fd_sc_mcu7t5v0__fill_2
XTAP_TAPCELL_ROW_105_1517 VDD VSS gf180mcu_fd_sc_mcu7t5v0__filltie
XFILLER_34_457 VDD VDD VSS VSS gf180mcu_fd_sc_mcu7t5v0__fillcap_16
XFILLER_61_232 VDD VDD VSS VSS gf180mcu_fd_sc_mcu7t5v0__fill_2
XFILLER_30_641 VDD VDD VSS VSS gf180mcu_fd_sc_mcu7t5v0__fillcap_16
X_1932_ _1932_/A1 _1938_/A2 _2537_/A2 _1932_/B2 _1933_/I VDD VDD VSS VSS gf180mcu_fd_sc_mcu7t5v0__aoi22_1
XTAP_TAPCELL_ROW_32_636 VDD VSS gf180mcu_fd_sc_mcu7t5v0__filltie
X_1863_ _1863_/I _1863_/ZN VDD VDD VSS VSS gf180mcu_fd_sc_mcu7t5v0__clkinv_1
XTAP_TAPCELL_ROW_60_978 VDD VSS gf180mcu_fd_sc_mcu7t5v0__filltie
Xinput20 tl_d_dmem_i[26] input20/Z VDD VDD VSS VSS gf180mcu_fd_sc_mcu7t5v0__dlyd_1
Xinput31 tl_d_dmem_i[36] input31/Z VDD VDD VSS VSS gf180mcu_fd_sc_mcu7t5v0__dlyd_1
Xinput42 tl_d_dmem_i[46] input42/Z VDD VDD VSS VSS gf180mcu_fd_sc_mcu7t5v0__dlyd_1
Xinput53 tl_d_dmem_i[56] input53/Z VDD VDD VSS VSS gf180mcu_fd_sc_mcu7t5v0__dlyd_1
Xinput64 tl_d_dmem_i[6] input64/Z VDD VDD VSS VSS gf180mcu_fd_sc_mcu7t5v0__dlyd_1
X_1794_ _1984_/A1 _1826_/A2 _1814_/B1 _2724_/I _1795_/I VDD VDD VSS VSS gf180mcu_fd_sc_mcu7t5v0__aoi22_1
Xinput75 tl_d_esram_i[16] input75/Z VDD VDD VSS VSS gf180mcu_fd_sc_mcu7t5v0__dlyd_1
Xinput86 tl_d_esram_i[26] input86/Z VDD VDD VSS VSS gf180mcu_fd_sc_mcu7t5v0__dlyd_1
Xinput97 tl_d_esram_i[36] input97/Z VDD VDD VSS VSS gf180mcu_fd_sc_mcu7t5v0__dlyd_1
XTAP_TAPCELL_ROW_116_1646 VDD VSS gf180mcu_fd_sc_mcu7t5v0__filltie
X_2415_ _2406_/Z _2415_/A2 _2415_/B _2439_/A3 VDD VDD VSS VSS gf180mcu_fd_sc_mcu7t5v0__oai21_1
XTAP_TAPCELL_ROW_4_306 VDD VSS gf180mcu_fd_sc_mcu7t5v0__filltie
XFILLER_29_207 VDD VDD VSS VSS gf180mcu_fd_sc_mcu7t5v0__fill_2
X_2346_ _2346_/A1 _2346_/A2 _2348_/A1 VDD VDD VSS VSS gf180mcu_fd_sc_mcu7t5v0__nand2_1
XFILLER_111_484 VDD VDD VSS VSS gf180mcu_fd_sc_mcu7t5v0__fill_2
X_2277_ _2277_/A1 _2277_/A2 _2278_/A2 VDD VDD VSS VSS gf180mcu_fd_sc_mcu7t5v0__nand2_1
X_1228_ _2467_/A2 _1228_/A2 _1228_/B1 _1228_/B2 _2703_/I VDD VDD VSS VSS gf180mcu_fd_sc_mcu7t5v0__oai22_1
XFILLER_37_295 VDD VDD VSS VSS gf180mcu_fd_sc_mcu7t5v0__fill_1
XFILLER_52_243 VDD VDD VSS VSS gf180mcu_fd_sc_mcu7t5v0__fill_2
XFILLER_53_766 VDD VDD VSS VSS gf180mcu_fd_sc_mcu7t5v0__fillcap_4
X_1159_ _2535_/A1 _2601_/Q _1200_/A1 VDD VDD VSS VSS gf180mcu_fd_sc_mcu7t5v0__nand2_1
XFILLER_40_449 VDD VDD VSS VSS gf180mcu_fd_sc_mcu7t5v0__fillcap_4
XFILLER_21_696 VDD VDD VSS VSS gf180mcu_fd_sc_mcu7t5v0__fillcap_4
XFILLER_0_512 VDD VDD VSS VSS gf180mcu_fd_sc_mcu7t5v0__fillcap_32
Xinput402 tl_h_i_i[17] _2387_/I0 VDD VDD VSS VSS gf180mcu_fd_sc_mcu7t5v0__dlyd_1
XFILLER_102_451 VDD VDD VSS VSS gf180mcu_fd_sc_mcu7t5v0__fillcap_4
XFILLER_48_527 VDD VDD VSS VSS gf180mcu_fd_sc_mcu7t5v0__fillcap_16
Xinput413 tl_h_i_i[27] _1908_/A1 VDD VDD VSS VSS gf180mcu_fd_sc_mcu7t5v0__dlyd_1
Xinput424 tl_h_i_i[37] _1928_/A1 VDD VDD VSS VSS gf180mcu_fd_sc_mcu7t5v0__dlyd_1
Xinput435 tl_h_i_i[47] _1948_/A1 VDD VDD VSS VSS gf180mcu_fd_sc_mcu7t5v0__dlyd_1
Xinput446 tl_h_i_i[57] _1968_/A1 VDD VDD VSS VSS gf180mcu_fd_sc_mcu7t5v0__dlyd_1
XFILLER_102_484 VDD VDD VSS VSS gf180mcu_fd_sc_mcu7t5v0__fillcap_32
Xinput457 tl_h_i_i[67] _1988_/A1 VDD VDD VSS VSS gf180mcu_fd_sc_mcu7t5v0__dlyd_1
Xinput468 tl_h_i_i[77] _2008_/A1 VDD VDD VSS VSS gf180mcu_fd_sc_mcu7t5v0__dlyd_1
Xinput479 tl_h_i_i[87] _1165_/A2 VDD VDD VSS VSS gf180mcu_fd_sc_mcu7t5v0__dlyd_1
XFILLER_87_195 VDD VDD VSS VSS gf180mcu_fd_sc_mcu7t5v0__fill_1
XFILLER_75_346 VDD VDD VSS VSS gf180mcu_fd_sc_mcu7t5v0__fillcap_4
XFILLER_75_357 VDD VDD VSS VSS gf180mcu_fd_sc_mcu7t5v0__fillcap_4
XFILLER_16_457 VDD VDD VSS VSS gf180mcu_fd_sc_mcu7t5v0__fillcap_64
XFILLER_31_438 VDD VDD VSS VSS gf180mcu_fd_sc_mcu7t5v0__fill_2
XTAP_TAPCELL_ROW_100_1458 VDD VSS gf180mcu_fd_sc_mcu7t5v0__filltie
Xoutput909 _2750_/Z tl_d_uart_o[91] VDD VDD VSS VSS gf180mcu_fd_sc_mcu7t5v0__dlyd_1
XFILLER_98_73 VDD VDD VSS VSS gf180mcu_fd_sc_mcu7t5v0__fillcap_32
XFILLER_98_427 VDD VDD VSS VSS gf180mcu_fd_sc_mcu7t5v0__fillcap_4
X_2200_ _2584_/Q _2140_/B _2201_/A3 VDD VDD VSS VSS gf180mcu_fd_sc_mcu7t5v0__nand2_1
XFILLER_98_449 VDD VDD VSS VSS gf180mcu_fd_sc_mcu7t5v0__fillcap_4
Xfanout1140 _2380_/B _2348_/B VDD VDD VSS VSS gf180mcu_fd_sc_mcu7t5v0__dlyd_1
XTAP_TAPCELL_ROW_111_1587 VDD VSS gf180mcu_fd_sc_mcu7t5v0__filltie
XFILLER_14_4 VDD VDD VSS VSS gf180mcu_fd_sc_mcu7t5v0__fill_1
XFILLER_67_858 VDD VDD VSS VSS gf180mcu_fd_sc_mcu7t5v0__fillcap_8
X_2131_ input64/Z _2154_/A2 _2132_/A2 VDD VDD VSS VSS gf180mcu_fd_sc_mcu7t5v0__nor2_1
XFILLER_94_633 VDD VDD VSS VSS gf180mcu_fd_sc_mcu7t5v0__fill_2
Xfanout1184 _2371_/A2 _2315_/A2 VDD VDD VSS VSS gf180mcu_fd_sc_mcu7t5v0__dlyd_1
Xfanout1195 _2235_/B _2202_/B VDD VDD VSS VSS gf180mcu_fd_sc_mcu7t5v0__dlyd_1
X_2062_ _2549_/Q _2550_/Q _2076_/A2 _2063_/A2 VDD VDD VSS VSS gf180mcu_fd_sc_mcu7t5v0__xnor3_1
XTAP_TAPCELL_ROW_37_706 VDD VSS gf180mcu_fd_sc_mcu7t5v0__filltie
XFILLER_19_262 VDD VDD VSS VSS gf180mcu_fd_sc_mcu7t5v0__fillcap_16
XFILLER_35_766 VDD VDD VSS VSS gf180mcu_fd_sc_mcu7t5v0__fillcap_4
XTAP_TAPCELL_ROW_66_1044 VDD VSS gf180mcu_fd_sc_mcu7t5v0__filltie
XTAP_TAPCELL_ROW_17_463 VDD VSS gf180mcu_fd_sc_mcu7t5v0__filltie
XFILLER_22_449 VDD VDD VSS VSS gf180mcu_fd_sc_mcu7t5v0__fill_1
XTAP_TAPCELL_ROW_45_794 VDD VSS gf180mcu_fd_sc_mcu7t5v0__filltie
X_1915_ _1915_/I _1915_/ZN VDD VDD VSS VSS gf180mcu_fd_sc_mcu7t5v0__clkinv_1
X_1846_ _2036_/A1 _1854_/A2 _1850_/B1 _2767_/I _1847_/I VDD VDD VSS VSS gf180mcu_fd_sc_mcu7t5v0__aoi22_1
X_1777_ _1777_/I _1777_/ZN VDD VDD VSS VSS gf180mcu_fd_sc_mcu7t5v0__clkinv_1
XTAP_TAPCELL_ROW_77_1184 VDD VSS gf180mcu_fd_sc_mcu7t5v0__filltie
XPHY_EDGE_ROW_4_Right_4 VDD VSS gf180mcu_fd_sc_mcu7t5v0__endcap
XFILLER_89_416 VDD VDD VSS VSS gf180mcu_fd_sc_mcu7t5v0__fillcap_4
XTAP_TAPCELL_ROW_90_1340 VDD VSS gf180mcu_fd_sc_mcu7t5v0__filltie
X_2329_ _2373_/A1 _2329_/A2 _2330_/A2 VDD VDD VSS VSS gf180mcu_fd_sc_mcu7t5v0__nand2_1
XFILLER_69_184 VDD VDD VSS VSS gf180mcu_fd_sc_mcu7t5v0__fillcap_8
XFILLER_57_346 VDD VDD VSS VSS gf180mcu_fd_sc_mcu7t5v0__fillcap_4
XFILLER_85_677 VDD VDD VSS VSS gf180mcu_fd_sc_mcu7t5v0__fill_1
XFILLER_85_666 VDD VDD VSS VSS gf180mcu_fd_sc_mcu7t5v0__fill_1
XFILLER_13_416 VDD VDD VSS VSS gf180mcu_fd_sc_mcu7t5v0__fillcap_4
XPHY_EDGE_ROW_80_Left_199 VDD VSS gf180mcu_fd_sc_mcu7t5v0__endcap
XFILLER_0_342 VDD VDD VSS VSS gf180mcu_fd_sc_mcu7t5v0__fillcap_16
Xinput210 tl_d_uart_i[19] _1286_/A1 VDD VDD VSS VSS gf180mcu_fd_sc_mcu7t5v0__dlyd_1
Xxbar_tlul_2to4_1258 tl_d_esram_o[87] VDD VDD VSS VSS gf180mcu_fd_sc_mcu7t5v0__tiel
XFILLER_95_419 VDD VDD VSS VSS gf180mcu_fd_sc_mcu7t5v0__fill_1
XFILLER_49_858 VDD VDD VSS VSS gf180mcu_fd_sc_mcu7t5v0__fillcap_8
Xinput221 tl_d_uart_i[29] _1366_/A1 VDD VDD VSS VSS gf180mcu_fd_sc_mcu7t5v0__dlyd_1
Xinput232 tl_d_uart_i[39] _1446_/A1 VDD VDD VSS VSS gf180mcu_fd_sc_mcu7t5v0__dlyd_1
Xinput243 tl_d_uart_i[49] _1096_/I VDD VDD VSS VSS gf180mcu_fd_sc_mcu7t5v0__dlyd_1
Xinput254 tl_d_uart_i[59] _2239_/A1 VDD VDD VSS VSS gf180mcu_fd_sc_mcu7t5v0__dlyd_1
Xxbar_tlul_2to4_1269 tl_d_rom_o[91] VDD VDD VSS VSS gf180mcu_fd_sc_mcu7t5v0__tiel
Xinput265 tl_d_uart_i[9] _2144_/A1 VDD VDD VSS VSS gf180mcu_fd_sc_mcu7t5v0__dlyd_1
Xinput276 tl_h_d_i[109] _2768_/I VDD VDD VSS VSS gf180mcu_fd_sc_mcu7t5v0__dlyd_1
Xinput287 tl_h_d_i[16] _1886_/B2 VDD VDD VSS VSS gf180mcu_fd_sc_mcu7t5v0__clkbuf_2
XFILLER_48_379 VDD VDD VSS VSS gf180mcu_fd_sc_mcu7t5v0__fill_1
Xinput298 tl_h_d_i[26] _2717_/I VDD VDD VSS VSS gf180mcu_fd_sc_mcu7t5v0__dlyd_1
XFILLER_17_766 VDD VDD VSS VSS gf180mcu_fd_sc_mcu7t5v0__fillcap_4
XTAP_TAPCELL_ROW_14_422 VDD VSS gf180mcu_fd_sc_mcu7t5v0__filltie
XFILLER_32_769 VDD VDD VSS VSS gf180mcu_fd_sc_mcu7t5v0__fill_2
XTAP_TAPCELL_ROW_42_764 VDD VSS gf180mcu_fd_sc_mcu7t5v0__filltie
XFILLER_31_279 VDD VDD VSS VSS gf180mcu_fd_sc_mcu7t5v0__fill_1
X_2680_ _2752_/I _2680_/Z VDD VDD VSS VSS gf180mcu_fd_sc_mcu7t5v0__buf_1
X_1700_ _2388_/I0 _1728_/A2 _1722_/B1 _1700_/B2 _1701_/I VDD VDD VSS VSS gf180mcu_fd_sc_mcu7t5v0__aoi22_1
X_1631_ _1934_/B2 _1641_/A2 _1631_/Z VDD VDD VSS VSS gf180mcu_fd_sc_mcu7t5v0__or2_1
Xoutput717 _1849_/ZN tl_d_rom_o[109] VDD VDD VSS VSS gf180mcu_fd_sc_mcu7t5v0__dlyd_1
Xoutput706 _1873_/ZN tl_d_esram_o[9] VDD VDD VSS VSS gf180mcu_fd_sc_mcu7t5v0__dlyd_1
Xoutput739 _1717_/ZN tl_d_rom_o[26] VDD VDD VSS VSS gf180mcu_fd_sc_mcu7t5v0__dlyd_1
Xoutput728 _1697_/ZN tl_d_rom_o[16] VDD VDD VSS VSS gf180mcu_fd_sc_mcu7t5v0__dlyd_1
X_1562_ _2725_/I _2729_/I _1561_/Z _1562_/Z VDD VDD VSS VSS gf180mcu_fd_sc_mcu7t5v0__xor3_1
XTAP_TAPCELL_ROW_113_1616 VDD VSS gf180mcu_fd_sc_mcu7t5v0__filltie
X_1493_ _1493_/I _1494_/B1 VDD VDD VSS VSS gf180mcu_fd_sc_mcu7t5v0__clkinv_1
XFILLER_99_769 VDD VDD VSS VSS gf180mcu_fd_sc_mcu7t5v0__fill_1
XFILLER_39_368 VDD VDD VSS VSS gf180mcu_fd_sc_mcu7t5v0__fill_2
X_2114_ _2114_/A1 _2172_/A2 _2154_/A2 _2114_/B2 _2114_/C _2114_/ZN VDD VDD VSS VSS
+ gf180mcu_fd_sc_mcu7t5v0__aoi221_2
X_2045_ _2045_/I _2045_/ZN VDD VDD VSS VSS gf180mcu_fd_sc_mcu7t5v0__clkinv_1
XFILLER_62_382 VDD VDD VSS VSS gf180mcu_fd_sc_mcu7t5v0__fill_2
XFILLER_10_419 VDD VDD VSS VSS gf180mcu_fd_sc_mcu7t5v0__fill_2
XTAP_TAPCELL_ROW_79_1202 VDD VSS gf180mcu_fd_sc_mcu7t5v0__filltie
X_1829_ _1829_/I _1829_/ZN VDD VDD VSS VSS gf180mcu_fd_sc_mcu7t5v0__clkinv_1
XFILLER_116_384 VDD VDD VSS VSS gf180mcu_fd_sc_mcu7t5v0__fill_1
XFILLER_45_305 VDD VDD VSS VSS gf180mcu_fd_sc_mcu7t5v0__fillcap_8
XFILLER_57_154 VDD VDD VSS VSS gf180mcu_fd_sc_mcu7t5v0__fillcap_32
XPHY_EDGE_ROW_79_Right_79 VDD VSS gf180mcu_fd_sc_mcu7t5v0__endcap
XFILLER_73_625 VDD VDD VSS VSS gf180mcu_fd_sc_mcu7t5v0__fillcap_4
XFILLER_45_349 VDD VDD VSS VSS gf180mcu_fd_sc_mcu7t5v0__fill_1
XFILLER_72_135 VDD VDD VSS VSS gf180mcu_fd_sc_mcu7t5v0__fill_2
XFILLER_54_34 VDD VDD VSS VSS gf180mcu_fd_sc_mcu7t5v0__fill_1
XFILLER_13_246 VDD VDD VSS VSS gf180mcu_fd_sc_mcu7t5v0__fillcap_16
XFILLER_14_769 VDD VDD VSS VSS gf180mcu_fd_sc_mcu7t5v0__fill_2
XPHY_EDGE_ROW_109_Left_228 VDD VSS gf180mcu_fd_sc_mcu7t5v0__endcap
XPHY_EDGE_ROW_88_Right_88 VDD VSS gf180mcu_fd_sc_mcu7t5v0__endcap
XFILLER_107_373 VDD VDD VSS VSS gf180mcu_fd_sc_mcu7t5v0__fill_1
XPHY_EDGE_ROW_118_Left_237 VDD VSS gf180mcu_fd_sc_mcu7t5v0__endcap
XFILLER_0_172 VDD VDD VSS VSS gf180mcu_fd_sc_mcu7t5v0__fillcap_32
XPHY_EDGE_ROW_97_Right_97 VDD VSS gf180mcu_fd_sc_mcu7t5v0__endcap
XTAP_TAPCELL_ROW_47_823 VDD VSS gf180mcu_fd_sc_mcu7t5v0__filltie
XFILLER_91_400 VDD VDD VSS VSS gf180mcu_fd_sc_mcu7t5v0__fillcap_16
XFILLER_63_124 VDD VDD VSS VSS gf180mcu_fd_sc_mcu7t5v0__fill_2
Xload_slew1150 _2358_/A1 _2282_/A1 VDD VDD VSS VSS gf180mcu_fd_sc_mcu7t5v0__buf_2
Xload_slew1161 _2246_/B1 _2238_/B1 VDD VDD VSS VSS gf180mcu_fd_sc_mcu7t5v0__clkbuf_4
Xload_slew1194 _1508_/B2 _2247_/A2 VDD VDD VSS VSS gf180mcu_fd_sc_mcu7t5v0__buf_4
XFILLER_91_488 VDD VDD VSS VSS gf180mcu_fd_sc_mcu7t5v0__fill_2
XFILLER_60_831 VDD VDD VSS VSS gf180mcu_fd_sc_mcu7t5v0__fill_1
XTAP_TAPCELL_ROW_63_1014 VDD VSS gf180mcu_fd_sc_mcu7t5v0__filltie
XTAP_TAPCELL_ROW_27_580 VDD VSS gf180mcu_fd_sc_mcu7t5v0__filltie
X_2732_ _2732_/I _2732_/Z VDD VDD VSS VSS gf180mcu_fd_sc_mcu7t5v0__buf_1
X_2663_ _2735_/I _2663_/Z VDD VDD VSS VSS gf180mcu_fd_sc_mcu7t5v0__buf_1
X_2594_ _2594_/D _2594_/RN _2596_/CLK _2594_/Q VDD VDD VSS VSS gf180mcu_fd_sc_mcu7t5v0__dffrnq_1
Xoutput503 _2695_/Z tl_d_dmem_o[108] VDD VDD VSS VSS gf180mcu_fd_sc_mcu7t5v0__dlyd_1
Xoutput514 _2634_/Z tl_d_dmem_o[15] VDD VDD VSS VSS gf180mcu_fd_sc_mcu7t5v0__dlyd_1
Xoutput525 _2644_/Z tl_d_dmem_o[25] VDD VDD VSS VSS gf180mcu_fd_sc_mcu7t5v0__dlyd_1
Xoutput536 _1518_/Z tl_d_dmem_o[35] VDD VDD VSS VSS gf180mcu_fd_sc_mcu7t5v0__dlyd_1
X_1614_ _2754_/I _2706_/I _1614_/A3 _1614_/Z VDD VDD VSS VSS gf180mcu_fd_sc_mcu7t5v0__xor3_1
Xoutput547 _1528_/Z tl_d_dmem_o[45] VDD VDD VSS VSS gf180mcu_fd_sc_mcu7t5v0__dlyd_1
Xoutput558 _1538_/Z tl_d_dmem_o[55] VDD VDD VSS VSS gf180mcu_fd_sc_mcu7t5v0__dlyd_1
Xoutput569 _2652_/Z tl_d_dmem_o[65] VDD VDD VSS VSS gf180mcu_fd_sc_mcu7t5v0__dlyd_1
X_1545_ _1653_/A1 _1550_/A2 _1545_/ZN VDD VDD VSS VSS gf180mcu_fd_sc_mcu7t5v0__nor2_1
XTAP_TAPCELL_ROW_74_1143 VDD VSS gf180mcu_fd_sc_mcu7t5v0__filltie
XFILLER_99_544 VDD VDD VSS VSS gf180mcu_fd_sc_mcu7t5v0__fillcap_4
X_1476_ input39/Z _1500_/A2 _1476_/B1 _1476_/B2 _1477_/I VDD VDD VSS VSS gf180mcu_fd_sc_mcu7t5v0__aoi22_1
XFILLER_67_430 VDD VDD VSS VSS gf180mcu_fd_sc_mcu7t5v0__fill_2
XFILLER_27_349 VDD VDD VSS VSS gf180mcu_fd_sc_mcu7t5v0__fill_1
XFILLER_82_444 VDD VDD VSS VSS gf180mcu_fd_sc_mcu7t5v0__fillcap_8
X_2028_ _2401_/I0 _2044_/A2 _2038_/B1 _2762_/I _2029_/I VDD VDD VSS VSS gf180mcu_fd_sc_mcu7t5v0__aoi22_1
XFILLER_51_842 VDD VDD VSS VSS gf180mcu_fd_sc_mcu7t5v0__fillcap_16
XTAP_TAPCELL_ROW_85_1272 VDD VSS gf180mcu_fd_sc_mcu7t5v0__filltie
XFILLER_40_14 VDD VDD VSS VSS gf180mcu_fd_sc_mcu7t5v0__fill_2
XFILLER_104_354 VDD VDD VSS VSS gf180mcu_fd_sc_mcu7t5v0__fillcap_16
XFILLER_104_387 VDD VDD VSS VSS gf180mcu_fd_sc_mcu7t5v0__fillcap_16
XFILLER_86_761 VDD VDD VSS VSS gf180mcu_fd_sc_mcu7t5v0__fill_2
XFILLER_100_593 VDD VDD VSS VSS gf180mcu_fd_sc_mcu7t5v0__fill_2
XFILLER_18_349 VDD VDD VSS VSS gf180mcu_fd_sc_mcu7t5v0__fill_2
XFILLER_85_282 VDD VDD VSS VSS gf180mcu_fd_sc_mcu7t5v0__fillcap_8
XFILLER_73_422 VDD VDD VSS VSS gf180mcu_fd_sc_mcu7t5v0__fillcap_64
XFILLER_61_617 VDD VDD VSS VSS gf180mcu_fd_sc_mcu7t5v0__fillcap_8
XFILLER_42_831 VDD VDD VSS VSS gf180mcu_fd_sc_mcu7t5v0__fill_1
XFILLER_41_352 VDD VDD VSS VSS gf180mcu_fd_sc_mcu7t5v0__fillcap_16
XTAP_TAPCELL_ROW_52_881 VDD VSS gf180mcu_fd_sc_mcu7t5v0__filltie
XTAP_TAPCELL_ROW_24_550 VDD VSS gf180mcu_fd_sc_mcu7t5v0__filltie
X_1330_ input85/Z _1418_/A2 _2311_/A3 _1331_/B VDD VDD VSS VSS gf180mcu_fd_sc_mcu7t5v0__nand3_1
XFILLER_111_858 VDD VDD VSS VSS gf180mcu_fd_sc_mcu7t5v0__fillcap_8
XFILLER_49_430 VDD VDD VSS VSS gf180mcu_fd_sc_mcu7t5v0__fillcap_4
X_1261_ _1261_/I _1262_/B1 VDD VDD VSS VSS gf180mcu_fd_sc_mcu7t5v0__clkinv_1
Xinput7 tl_d_dmem_i[14] input7/Z VDD VDD VSS VSS gf180mcu_fd_sc_mcu7t5v0__dlyd_1
X_1192_ _2531_/B2 _2599_/Q _1196_/A2 VDD VDD VSS VSS gf180mcu_fd_sc_mcu7t5v0__nand2_1
XTAP_TAPCELL_ROW_108_1548 VDD VSS gf180mcu_fd_sc_mcu7t5v0__filltie
XFILLER_92_720 VDD VDD VSS VSS gf180mcu_fd_sc_mcu7t5v0__fillcap_4
XFILLER_36_168 VDD VDD VSS VSS gf180mcu_fd_sc_mcu7t5v0__fillcap_4
XFILLER_64_488 VDD VDD VSS VSS gf180mcu_fd_sc_mcu7t5v0__fillcap_32
XFILLER_33_842 VDD VDD VSS VSS gf180mcu_fd_sc_mcu7t5v0__fillcap_16
XFILLER_60_661 VDD VDD VSS VSS gf180mcu_fd_sc_mcu7t5v0__fillcap_4
XFILLER_9_570 VDD VDD VSS VSS gf180mcu_fd_sc_mcu7t5v0__fill_2
X_2715_ _2715_/I _2715_/Z VDD VDD VSS VSS gf180mcu_fd_sc_mcu7t5v0__buf_1
X_2646_ _2718_/I _2646_/Z VDD VDD VSS VSS gf180mcu_fd_sc_mcu7t5v0__buf_1
X_2577_ _2577_/D _2582_/RN _2596_/CLK _2577_/Q VDD VDD VSS VSS gf180mcu_fd_sc_mcu7t5v0__dffsnq_1
XFILLER_101_313 VDD VDD VSS VSS gf180mcu_fd_sc_mcu7t5v0__fill_2
X_1528_ _1944_/B2 _1533_/A2 _1528_/Z VDD VDD VSS VSS gf180mcu_fd_sc_mcu7t5v0__or2_1
X_1459_ _1467_/A1 _1457_/Z _1459_/B _1460_/B1 VDD VDD VSS VSS gf180mcu_fd_sc_mcu7t5v0__oai21_1
XFILLER_87_547 VDD VDD VSS VSS gf180mcu_fd_sc_mcu7t5v0__fillcap_8
XTAP_TAPCELL_ROW_87_1301 VDD VSS gf180mcu_fd_sc_mcu7t5v0__filltie
XFILLER_55_422 VDD VDD VSS VSS gf180mcu_fd_sc_mcu7t5v0__fill_2
XFILLER_67_282 VDD VDD VSS VSS gf180mcu_fd_sc_mcu7t5v0__fillcap_32
XFILLER_95_580 VDD VDD VSS VSS gf180mcu_fd_sc_mcu7t5v0__fillcap_16
XTAP_TAPCELL_ROW_2_278 VDD VSS gf180mcu_fd_sc_mcu7t5v0__filltie
XFILLER_24_831 VDD VDD VSS VSS gf180mcu_fd_sc_mcu7t5v0__fill_1
XFILLER_55_488 VDD VDD VSS VSS gf180mcu_fd_sc_mcu7t5v0__fill_2
XFILLER_82_285 VDD VDD VSS VSS gf180mcu_fd_sc_mcu7t5v0__fillcap_16
XFILLER_82_263 VDD VDD VSS VSS gf180mcu_fd_sc_mcu7t5v0__fill_1
XFILLER_23_341 VDD VDD VSS VSS gf180mcu_fd_sc_mcu7t5v0__fillcap_8
XFILLER_23_396 VDD VDD VSS VSS gf180mcu_fd_sc_mcu7t5v0__fillcap_16
XTAP_TAPCELL_ROW_98_1430 VDD VSS gf180mcu_fd_sc_mcu7t5v0__filltie
XFILLER_109_479 VDD VDD VSS VSS gf180mcu_fd_sc_mcu7t5v0__fillcap_8
XFILLER_78_503 VDD VDD VSS VSS gf180mcu_fd_sc_mcu7t5v0__fill_1
XFILLER_59_772 VDD VDD VSS VSS gf180mcu_fd_sc_mcu7t5v0__fillcap_32
XFILLER_46_433 VDD VDD VSS VSS gf180mcu_fd_sc_mcu7t5v0__fillcap_8
XFILLER_93_539 VDD VDD VSS VSS gf180mcu_fd_sc_mcu7t5v0__fillcap_8
XTAP_TAPCELL_ROW_57_940 VDD VSS gf180mcu_fd_sc_mcu7t5v0__filltie
XFILLER_61_403 VDD VDD VSS VSS gf180mcu_fd_sc_mcu7t5v0__fill_2
XFILLER_15_842 VDD VDD VSS VSS gf180mcu_fd_sc_mcu7t5v0__fill_1
XFILLER_14_341 VDD VDD VSS VSS gf180mcu_fd_sc_mcu7t5v0__fill_2
XFILLER_14_352 VDD VDD VSS VSS gf180mcu_fd_sc_mcu7t5v0__fillcap_32
XFILLER_30_801 VDD VDD VSS VSS gf180mcu_fd_sc_mcu7t5v0__fillcap_4
XFILLER_30_823 VDD VDD VSS VSS gf180mcu_fd_sc_mcu7t5v0__fillcap_8
XTAP_TAPCELL_ROW_103_1489 VDD VSS gf180mcu_fd_sc_mcu7t5v0__filltie
X_2500_ _2499_/Z _2592_/Q _2507_/B _2592_/D VDD VDD VSS VSS gf180mcu_fd_sc_mcu7t5v0__mux2_2
Xoutput1005 _2304_/ZN tl_h_i_o[28] VDD VDD VSS VSS gf180mcu_fd_sc_mcu7t5v0__dlyd_1
X_2431_ _2451_/B _2431_/A2 _2432_/B VDD VDD VSS VSS gf180mcu_fd_sc_mcu7t5v0__nor2_1
Xoutput1016 _2344_/ZN tl_h_i_o[38] VDD VDD VSS VSS gf180mcu_fd_sc_mcu7t5v0__dlyd_1
Xoutput1027 _2081_/ZN tl_h_i_o[48] VDD VDD VSS VSS gf180mcu_fd_sc_mcu7t5v0__dlyd_1
Xoutput1038 _2105_/ZN tl_h_i_o[58] VDD VDD VSS VSS gf180mcu_fd_sc_mcu7t5v0__dlyd_1
Xoutput1049 _2061_/ZN tl_h_i_o[8] VDD VDD VSS VSS gf180mcu_fd_sc_mcu7t5v0__dlyd_1
X_2362_ _2362_/A1 _2362_/A2 _2364_/A1 VDD VDD VSS VSS gf180mcu_fd_sc_mcu7t5v0__nand2_1
XTAP_TAPCELL_ROW_71_1113 VDD VSS gf180mcu_fd_sc_mcu7t5v0__filltie
X_2293_ _2293_/A1 _2293_/A2 _2294_/A2 VDD VDD VSS VSS gf180mcu_fd_sc_mcu7t5v0__nand2_1
X_1313_ _1393_/A1 _2281_/A2 _1313_/Z VDD VDD VSS VSS gf180mcu_fd_sc_mcu7t5v0__and2_1
X_1244_ _1257_/A3 _2371_/A2 _2369_/A1 _1251_/A3 _1245_/I VDD VDD VSS VSS gf180mcu_fd_sc_mcu7t5v0__aoi22_1
XFILLER_37_422 VDD VDD VSS VSS gf180mcu_fd_sc_mcu7t5v0__fillcap_32
XFILLER_49_282 VDD VDD VSS VSS gf180mcu_fd_sc_mcu7t5v0__fillcap_4
XFILLER_64_252 VDD VDD VSS VSS gf180mcu_fd_sc_mcu7t5v0__fillcap_4
X_1175_ _1175_/A1 _1175_/A2 _1175_/A3 _1175_/A4 _1190_/A1 VDD VDD VSS VSS gf180mcu_fd_sc_mcu7t5v0__nand4_1
XTAP_TAPCELL_ROW_69_1086 VDD VSS gf180mcu_fd_sc_mcu7t5v0__filltie
XFILLER_92_594 VDD VDD VSS VSS gf180mcu_fd_sc_mcu7t5v0__fill_1
XFILLER_92_583 VDD VDD VSS VSS gf180mcu_fd_sc_mcu7t5v0__fill_2
XFILLER_80_734 VDD VDD VSS VSS gf180mcu_fd_sc_mcu7t5v0__fill_1
XTAP_TAPCELL_ROW_82_1242 VDD VSS gf180mcu_fd_sc_mcu7t5v0__filltie
XTAP_TAPCELL_ROW_35_678 VDD VSS gf180mcu_fd_sc_mcu7t5v0__filltie
XANTENNA_12 _2128_/ZN VDD VDD VSS VSS gf180mcu_fd_sc_mcu7t5v0__antenna
XANTENNA_23 input1/Z VDD VDD VSS VSS gf180mcu_fd_sc_mcu7t5v0__antenna
XFILLER_20_311 VDD VDD VSS VSS gf180mcu_fd_sc_mcu7t5v0__fillcap_4
XFILLER_32_193 VDD VDD VSS VSS gf180mcu_fd_sc_mcu7t5v0__fillcap_32
XANTENNA_34 _2719_/I VDD VDD VSS VSS gf180mcu_fd_sc_mcu7t5v0__antenna
XANTENNA_45 tl_h_i_i[16] VDD VDD VSS VSS gf180mcu_fd_sc_mcu7t5v0__antenna
XFILLER_20_399 VDD VDD VSS VSS gf180mcu_fd_sc_mcu7t5v0__fill_2
XTAP_TAPCELL_ROW_93_1371 VDD VSS gf180mcu_fd_sc_mcu7t5v0__filltie
XTAP_TAPCELL_ROW_7_337 VDD VSS gf180mcu_fd_sc_mcu7t5v0__filltie
XFILLER_88_823 VDD VDD VSS VSS gf180mcu_fd_sc_mcu7t5v0__fillcap_8
XFILLER_87_311 VDD VDD VSS VSS gf180mcu_fd_sc_mcu7t5v0__fillcap_32
XFILLER_47_208 VDD VDD VSS VSS gf180mcu_fd_sc_mcu7t5v0__fill_2
XFILLER_87_366 VDD VDD VSS VSS gf180mcu_fd_sc_mcu7t5v0__fill_1
XFILLER_56_731 VDD VDD VSS VSS gf180mcu_fd_sc_mcu7t5v0__fillcap_4
XTAP_TAPCELL_ROW_54_910 VDD VSS gf180mcu_fd_sc_mcu7t5v0__filltie
XFILLER_70_244 VDD VDD VSS VSS gf180mcu_fd_sc_mcu7t5v0__fill_1
XFILLER_24_661 VDD VDD VSS VSS gf180mcu_fd_sc_mcu7t5v0__fillcap_4
XFILLER_62_34 VDD VDD VSS VSS gf180mcu_fd_sc_mcu7t5v0__fill_1
XFILLER_11_322 VDD VDD VSS VSS gf180mcu_fd_sc_mcu7t5v0__fill_2
XFILLER_12_823 VDD VDD VSS VSS gf180mcu_fd_sc_mcu7t5v0__fillcap_8
XFILLER_93_303 VDD VDD VSS VSS gf180mcu_fd_sc_mcu7t5v0__fill_2
XFILLER_19_422 VDD VDD VSS VSS gf180mcu_fd_sc_mcu7t5v0__fillcap_64
XFILLER_46_241 VDD VDD VSS VSS gf180mcu_fd_sc_mcu7t5v0__fillcap_4
XFILLER_47_742 VDD VDD VSS VSS gf180mcu_fd_sc_mcu7t5v0__fillcap_4
XTAP_TAPCELL_ROW_105_1518 VDD VSS gf180mcu_fd_sc_mcu7t5v0__filltie
X_1931_ _1931_/I _1931_/ZN VDD VDD VSS VSS gf180mcu_fd_sc_mcu7t5v0__clkinv_1
XTAP_TAPCELL_ROW_32_637 VDD VSS gf180mcu_fd_sc_mcu7t5v0__filltie
X_1862_ _1862_/A1 _1900_/A2 _1900_/B1 _1085_/I _1863_/I VDD VDD VSS VSS gf180mcu_fd_sc_mcu7t5v0__aoi22_1
XTAP_TAPCELL_ROW_60_979 VDD VSS gf180mcu_fd_sc_mcu7t5v0__filltie
Xinput10 tl_d_dmem_i[17] input10/Z VDD VDD VSS VSS gf180mcu_fd_sc_mcu7t5v0__dlyd_1
Xinput21 tl_d_dmem_i[27] input21/Z VDD VDD VSS VSS gf180mcu_fd_sc_mcu7t5v0__dlyd_1
Xinput32 tl_d_dmem_i[37] input32/Z VDD VDD VSS VSS gf180mcu_fd_sc_mcu7t5v0__dlyd_1
Xinput43 tl_d_dmem_i[47] input43/Z VDD VDD VSS VSS gf180mcu_fd_sc_mcu7t5v0__dlyd_1
Xinput54 tl_d_dmem_i[57] input54/Z VDD VDD VSS VSS gf180mcu_fd_sc_mcu7t5v0__dlyd_1
X_1793_ _1793_/I _1793_/ZN VDD VDD VSS VSS gf180mcu_fd_sc_mcu7t5v0__clkinv_1
Xinput65 tl_d_dmem_i[7] input65/Z VDD VDD VSS VSS gf180mcu_fd_sc_mcu7t5v0__dlyd_1
Xinput76 tl_d_esram_i[17] input76/Z VDD VDD VSS VSS gf180mcu_fd_sc_mcu7t5v0__dlyd_1
Xinput87 tl_d_esram_i[27] input87/Z VDD VDD VSS VSS gf180mcu_fd_sc_mcu7t5v0__dlyd_1
Xinput98 tl_d_esram_i[37] input98/Z VDD VDD VSS VSS gf180mcu_fd_sc_mcu7t5v0__dlyd_1
XTAP_TAPCELL_ROW_116_1647 VDD VSS gf180mcu_fd_sc_mcu7t5v0__filltie
X_2414_ _2406_/Z _2415_/A2 _2416_/A2 VDD VDD VSS VSS gf180mcu_fd_sc_mcu7t5v0__nor2_1
X_2345_ _2345_/A1 _2345_/A2 _2346_/A2 VDD VDD VSS VSS gf180mcu_fd_sc_mcu7t5v0__nand2_1
XTAP_TAPCELL_ROW_4_307 VDD VSS gf180mcu_fd_sc_mcu7t5v0__filltie
XFILLER_84_303 VDD VDD VSS VSS gf180mcu_fd_sc_mcu7t5v0__fill_2
XFILLER_38_731 VDD VDD VSS VSS gf180mcu_fd_sc_mcu7t5v0__fillcap_4
X_2276_ _2276_/A1 _2276_/A2 _2296_/B _2276_/ZN VDD VDD VSS VSS gf180mcu_fd_sc_mcu7t5v0__aoi21_1
XFILLER_65_550 VDD VDD VSS VSS gf180mcu_fd_sc_mcu7t5v0__fillcap_8
X_1227_ _1082_/I _2403_/A1 _1228_/B1 VDD VDD VSS VSS gf180mcu_fd_sc_mcu7t5v0__nand2_1
XFILLER_37_252 VDD VDD VSS VSS gf180mcu_fd_sc_mcu7t5v0__fillcap_8
X_1158_ _1201_/B _1204_/B _1158_/Z VDD VDD VSS VSS gf180mcu_fd_sc_mcu7t5v0__or2_1
XFILLER_25_458 VDD VDD VSS VSS gf180mcu_fd_sc_mcu7t5v0__fill_1
XFILLER_92_391 VDD VDD VSS VSS gf180mcu_fd_sc_mcu7t5v0__fill_2
XFILLER_92_380 VDD VDD VSS VSS gf180mcu_fd_sc_mcu7t5v0__fillcap_4
XFILLER_52_255 VDD VDD VSS VSS gf180mcu_fd_sc_mcu7t5v0__fillcap_4
X_1089_ _1089_/I _2114_/A1 VDD VDD VSS VSS gf180mcu_fd_sc_mcu7t5v0__clkinv_1
XFILLER_80_575 VDD VDD VSS VSS gf180mcu_fd_sc_mcu7t5v0__fillcap_16
XFILLER_52_288 VDD VDD VSS VSS gf180mcu_fd_sc_mcu7t5v0__fill_1
XFILLER_80_597 VDD VDD VSS VSS gf180mcu_fd_sc_mcu7t5v0__fillcap_16
XFILLER_32_37 VDD VDD VSS VSS gf180mcu_fd_sc_mcu7t5v0__fillcap_4
XTAP_TAPCELL_ROW_95_1400 VDD VSS gf180mcu_fd_sc_mcu7t5v0__filltie
XFILLER_0_546 VDD VDD VSS VSS gf180mcu_fd_sc_mcu7t5v0__fillcap_16
Xinput403 tl_h_i_i[18] _2388_/I0 VDD VDD VSS VSS gf180mcu_fd_sc_mcu7t5v0__dlyd_1
Xinput414 tl_h_i_i[28] _1910_/A1 VDD VDD VSS VSS gf180mcu_fd_sc_mcu7t5v0__dlyd_1
Xinput425 tl_h_i_i[38] _1930_/A1 VDD VDD VSS VSS gf180mcu_fd_sc_mcu7t5v0__dlyd_1
Xinput436 tl_h_i_i[48] _1950_/A1 VDD VDD VSS VSS gf180mcu_fd_sc_mcu7t5v0__dlyd_1
Xinput447 tl_h_i_i[58] _1970_/A1 VDD VDD VSS VSS gf180mcu_fd_sc_mcu7t5v0__dlyd_1
Xinput458 tl_h_i_i[68] _1990_/A1 VDD VDD VSS VSS gf180mcu_fd_sc_mcu7t5v0__dlyd_1
Xinput469 tl_h_i_i[78] _2010_/A1 VDD VDD VSS VSS gf180mcu_fd_sc_mcu7t5v0__dlyd_1
XFILLER_56_583 VDD VDD VSS VSS gf180mcu_fd_sc_mcu7t5v0__fillcap_8
XFILLER_90_317 VDD VDD VSS VSS gf180mcu_fd_sc_mcu7t5v0__fillcap_8
XFILLER_31_417 VDD VDD VSS VSS gf180mcu_fd_sc_mcu7t5v0__fill_2
XTAP_TAPCELL_ROW_100_1459 VDD VSS gf180mcu_fd_sc_mcu7t5v0__filltie
XFILLER_67_804 VDD VDD VSS VSS gf180mcu_fd_sc_mcu7t5v0__fill_2
Xfanout1130 _1768_/B1 _1736_/B1 VDD VDD VSS VSS gf180mcu_fd_sc_mcu7t5v0__dlyd_1
XTAP_TAPCELL_ROW_111_1588 VDD VSS gf180mcu_fd_sc_mcu7t5v0__filltie
XFILLER_79_664 VDD VDD VSS VSS gf180mcu_fd_sc_mcu7t5v0__fillcap_8
XFILLER_78_152 VDD VDD VSS VSS gf180mcu_fd_sc_mcu7t5v0__fill_2
Xfanout1152 _2157_/B _1213_/B VDD VDD VSS VSS gf180mcu_fd_sc_mcu7t5v0__dlyd_1
Xfanout1163 _1110_/ZN _2233_/A2 VDD VDD VSS VSS gf180mcu_fd_sc_mcu7t5v0__dlyd_1
Xfanout1174 wire1177/I _2231_/C VDD VDD VSS VSS gf180mcu_fd_sc_mcu7t5v0__dlyd_1
X_2130_ _2130_/A1 _2238_/A2 _2238_/B1 _2130_/B2 _2178_/C _2132_/A1 VDD VDD VSS VSS
+ gf180mcu_fd_sc_mcu7t5v0__aoi221_2
XFILLER_78_196 VDD VDD VSS VSS gf180mcu_fd_sc_mcu7t5v0__fillcap_32
XFILLER_78_185 VDD VDD VSS VSS gf180mcu_fd_sc_mcu7t5v0__fillcap_4
XFILLER_78_174 VDD VDD VSS VSS gf180mcu_fd_sc_mcu7t5v0__fill_1
XFILLER_19_230 VDD VDD VSS VSS gf180mcu_fd_sc_mcu7t5v0__fillcap_32
XFILLER_54_509 VDD VDD VSS VSS gf180mcu_fd_sc_mcu7t5v0__fillcap_16
X_2061_ _2061_/I _2061_/ZN VDD VDD VSS VSS gf180mcu_fd_sc_mcu7t5v0__clkinv_1
XFILLER_82_807 VDD VDD VSS VSS gf180mcu_fd_sc_mcu7t5v0__fillcap_16
XFILLER_81_328 VDD VDD VSS VSS gf180mcu_fd_sc_mcu7t5v0__fillcap_16
XFILLER_34_222 VDD VDD VSS VSS gf180mcu_fd_sc_mcu7t5v0__fillcap_8
XTAP_TAPCELL_ROW_66_1045 VDD VSS gf180mcu_fd_sc_mcu7t5v0__filltie
XFILLER_34_244 VDD VDD VSS VSS gf180mcu_fd_sc_mcu7t5v0__fill_1
XTAP_TAPCELL_ROW_17_464 VDD VSS gf180mcu_fd_sc_mcu7t5v0__filltie
XFILLER_50_737 VDD VDD VSS VSS gf180mcu_fd_sc_mcu7t5v0__fillcap_64
XFILLER_62_597 VDD VDD VSS VSS gf180mcu_fd_sc_mcu7t5v0__fillcap_16
XTAP_TAPCELL_ROW_45_795 VDD VSS gf180mcu_fd_sc_mcu7t5v0__filltie
X_1914_ _1914_/A1 _1914_/A2 _1914_/B1 _1914_/B2 _1915_/I VDD VDD VSS VSS gf180mcu_fd_sc_mcu7t5v0__aoi22_1
X_1845_ _1845_/I _1845_/ZN VDD VDD VSS VSS gf180mcu_fd_sc_mcu7t5v0__clkinv_1
X_1776_ _1966_/A1 _1818_/A2 _1814_/B1 _1966_/B2 _1777_/I VDD VDD VSS VSS gf180mcu_fd_sc_mcu7t5v0__aoi22_1
XTAP_TAPCELL_ROW_77_1185 VDD VSS gf180mcu_fd_sc_mcu7t5v0__filltie
XTAP_TAPCELL_ROW_90_1341 VDD VSS gf180mcu_fd_sc_mcu7t5v0__filltie
XFILLER_69_130 VDD VDD VSS VSS gf180mcu_fd_sc_mcu7t5v0__fillcap_4
X_2328_ _2328_/A1 _2328_/A2 _2376_/B _2328_/ZN VDD VDD VSS VSS gf180mcu_fd_sc_mcu7t5v0__aoi21_1
X_2259_ input76/Z _2323_/A2 _2259_/A3 _2260_/A2 VDD VDD VSS VSS gf180mcu_fd_sc_mcu7t5v0__nand3_1
XFILLER_84_177 VDD VDD VSS VSS gf180mcu_fd_sc_mcu7t5v0__fillcap_4
XFILLER_72_317 VDD VDD VSS VSS gf180mcu_fd_sc_mcu7t5v0__fillcap_16
XFILLER_25_244 VDD VDD VSS VSS gf180mcu_fd_sc_mcu7t5v0__fillcap_16
XFILLER_80_383 VDD VDD VSS VSS gf180mcu_fd_sc_mcu7t5v0__fill_2
XFILLER_40_247 VDD VDD VSS VSS gf180mcu_fd_sc_mcu7t5v0__fillcap_16
XFILLER_21_450 VDD VDD VSS VSS gf180mcu_fd_sc_mcu7t5v0__fill_2
XFILLER_68_22 VDD VDD VSS VSS gf180mcu_fd_sc_mcu7t5v0__fillcap_8
Xinput200 tl_d_uart_i[0] _1070_/I VDD VDD VSS VSS gf180mcu_fd_sc_mcu7t5v0__dlyd_1
Xinput211 tl_d_uart_i[1] _1089_/I VDD VDD VSS VSS gf180mcu_fd_sc_mcu7t5v0__dlyd_1
Xxbar_tlul_2to4_1259 tl_d_esram_o[86] VDD VDD VSS VSS gf180mcu_fd_sc_mcu7t5v0__tiel
XFILLER_0_376 VDD VDD VSS VSS gf180mcu_fd_sc_mcu7t5v0__fill_2
XFILLER_48_314 VDD VDD VSS VSS gf180mcu_fd_sc_mcu7t5v0__fill_1
Xinput222 tl_d_uart_i[2] _2115_/A1 VDD VDD VSS VSS gf180mcu_fd_sc_mcu7t5v0__dlyd_1
Xinput233 tl_d_uart_i[3] _2120_/A1 VDD VDD VSS VSS gf180mcu_fd_sc_mcu7t5v0__dlyd_1
Xinput244 tl_d_uart_i[4] _2122_/A1 VDD VDD VSS VSS gf180mcu_fd_sc_mcu7t5v0__dlyd_1
XFILLER_36_509 VDD VDD VSS VSS gf180mcu_fd_sc_mcu7t5v0__fillcap_16
XFILLER_64_807 VDD VDD VSS VSS gf180mcu_fd_sc_mcu7t5v0__fillcap_16
Xinput255 tl_d_uart_i[5] _1090_/I VDD VDD VSS VSS gf180mcu_fd_sc_mcu7t5v0__dlyd_1
Xinput266 tl_h_d_i[0] _2705_/I VDD VDD VSS VSS gf180mcu_fd_sc_mcu7t5v0__clkbuf_2
Xinput277 tl_h_d_i[10] _1874_/B2 VDD VDD VSS VSS gf180mcu_fd_sc_mcu7t5v0__dlyd_1
Xinput288 tl_h_d_i[17] _1698_/B2 VDD VDD VSS VSS gf180mcu_fd_sc_mcu7t5v0__clkbuf_2
XFILLER_76_667 VDD VDD VSS VSS gf180mcu_fd_sc_mcu7t5v0__fillcap_16
XFILLER_76_656 VDD VDD VSS VSS gf180mcu_fd_sc_mcu7t5v0__fillcap_8
Xinput299 tl_h_d_i[27] _2718_/I VDD VDD VSS VSS gf180mcu_fd_sc_mcu7t5v0__dlyd_1
XFILLER_91_626 VDD VDD VSS VSS gf180mcu_fd_sc_mcu7t5v0__fillcap_4
XFILLER_44_520 VDD VDD VSS VSS gf180mcu_fd_sc_mcu7t5v0__fillcap_4
XFILLER_91_659 VDD VDD VSS VSS gf180mcu_fd_sc_mcu7t5v0__fillcap_16
XFILLER_91_648 VDD VDD VSS VSS gf180mcu_fd_sc_mcu7t5v0__fill_2
XFILLER_32_737 VDD VDD VSS VSS gf180mcu_fd_sc_mcu7t5v0__fillcap_32
XFILLER_44_597 VDD VDD VSS VSS gf180mcu_fd_sc_mcu7t5v0__fillcap_16
XTAP_TAPCELL_ROW_42_765 VDD VSS gf180mcu_fd_sc_mcu7t5v0__filltie
XTAP_TAPCELL_ROW_14_423 VDD VSS gf180mcu_fd_sc_mcu7t5v0__filltie
X_1630_ _1932_/B2 _1641_/A2 _1630_/Z VDD VDD VSS VSS gf180mcu_fd_sc_mcu7t5v0__or2_1
Xoutput718 _1685_/ZN tl_d_rom_o[10] VDD VDD VSS VSS gf180mcu_fd_sc_mcu7t5v0__dlyd_1
Xoutput707 _2703_/Z tl_d_rom_o[0] VDD VDD VSS VSS gf180mcu_fd_sc_mcu7t5v0__dlyd_1
Xoutput729 _1699_/ZN tl_d_rom_o[17] VDD VDD VSS VSS gf180mcu_fd_sc_mcu7t5v0__dlyd_1
X_1561_ _2726_/I _2728_/I _2727_/I _1561_/Z VDD VDD VSS VSS gf180mcu_fd_sc_mcu7t5v0__xor3_1
XTAP_TAPCELL_ROW_113_1617 VDD VSS gf180mcu_fd_sc_mcu7t5v0__filltie
X_1492_ input41/Z _1500_/A2 _1492_/B1 _1508_/B2 _1493_/I VDD VDD VSS VSS gf180mcu_fd_sc_mcu7t5v0__aoi22_1
XFILLER_67_623 VDD VDD VSS VSS gf180mcu_fd_sc_mcu7t5v0__fillcap_4
XFILLER_12_2 VDD VDD VSS VSS gf180mcu_fd_sc_mcu7t5v0__fillcap_8
X_2113_ input13/Z _2154_/A2 _2114_/C VDD VDD VSS VSS gf180mcu_fd_sc_mcu7t5v0__nor2_1
XFILLER_54_317 VDD VDD VSS VSS gf180mcu_fd_sc_mcu7t5v0__fillcap_64
XFILLER_66_177 VDD VDD VSS VSS gf180mcu_fd_sc_mcu7t5v0__fillcap_64
X_2044_ _2391_/I0 _2044_/A2 _2044_/B1 _2771_/I _2045_/I VDD VDD VSS VSS gf180mcu_fd_sc_mcu7t5v0__aoi22_1
XFILLER_94_497 VDD VDD VSS VSS gf180mcu_fd_sc_mcu7t5v0__fill_1
XFILLER_81_147 VDD VDD VSS VSS gf180mcu_fd_sc_mcu7t5v0__fillcap_16
XFILLER_22_214 VDD VDD VSS VSS gf180mcu_fd_sc_mcu7t5v0__fill_1
XTAP_TAPCELL_ROW_79_1203 VDD VSS gf180mcu_fd_sc_mcu7t5v0__filltie
X_1828_ _2396_/I0 _1830_/A2 _2533_/A2 _2757_/I _1829_/I VDD VDD VSS VSS gf180mcu_fd_sc_mcu7t5v0__aoi22_1
XPHY_EDGE_ROW_111_Right_111 VDD VSS gf180mcu_fd_sc_mcu7t5v0__endcap
XFILLER_116_352 VDD VDD VSS VSS gf180mcu_fd_sc_mcu7t5v0__fillcap_32
X_1759_ _1759_/I _1759_/ZN VDD VDD VSS VSS gf180mcu_fd_sc_mcu7t5v0__clkinv_1
XFILLER_38_14 VDD VDD VSS VSS gf180mcu_fd_sc_mcu7t5v0__fill_2
XFILLER_46_807 VDD VDD VSS VSS gf180mcu_fd_sc_mcu7t5v0__fillcap_16
XFILLER_58_645 VDD VDD VSS VSS gf180mcu_fd_sc_mcu7t5v0__fillcap_16
XFILLER_58_667 VDD VDD VSS VSS gf180mcu_fd_sc_mcu7t5v0__fillcap_64
XFILLER_14_737 VDD VDD VSS VSS gf180mcu_fd_sc_mcu7t5v0__fillcap_32
XFILLER_26_597 VDD VDD VSS VSS gf180mcu_fd_sc_mcu7t5v0__fillcap_64
XFILLER_70_45 VDD VDD VSS VSS gf180mcu_fd_sc_mcu7t5v0__fill_1
XFILLER_108_831 VDD VDD VSS VSS gf180mcu_fd_sc_mcu7t5v0__fill_1
XFILLER_107_352 VDD VDD VSS VSS gf180mcu_fd_sc_mcu7t5v0__fill_1
XFILLER_110_506 VDD VDD VSS VSS gf180mcu_fd_sc_mcu7t5v0__fill_1
XFILLER_0_140 VDD VDD VSS VSS gf180mcu_fd_sc_mcu7t5v0__fill_1
XFILLER_48_177 VDD VDD VSS VSS gf180mcu_fd_sc_mcu7t5v0__fillcap_64
Xload_slew1151 _2378_/A1 _2358_/A1 VDD VDD VSS VSS gf180mcu_fd_sc_mcu7t5v0__buf_2
Xload_slew1162 _2207_/B _2230_/A2 VDD VDD VSS VSS gf180mcu_fd_sc_mcu7t5v0__clkbuf_2
XTAP_TAPCELL_ROW_47_824 VDD VSS gf180mcu_fd_sc_mcu7t5v0__filltie
Xload_slew1173 _1217_/C _2208_/B VDD VDD VSS VSS gf180mcu_fd_sc_mcu7t5v0__buf_4
XFILLER_44_361 VDD VDD VSS VSS gf180mcu_fd_sc_mcu7t5v0__fillcap_4
XTAP_TAPCELL_ROW_63_1015 VDD VSS gf180mcu_fd_sc_mcu7t5v0__filltie
XFILLER_44_394 VDD VDD VSS VSS gf180mcu_fd_sc_mcu7t5v0__fill_1
XTAP_TAPCELL_ROW_27_581 VDD VSS gf180mcu_fd_sc_mcu7t5v0__filltie
XFILLER_71_180 VDD VDD VSS VSS gf180mcu_fd_sc_mcu7t5v0__fill_2
X_2731_ _2731_/I _2731_/Z VDD VDD VSS VSS gf180mcu_fd_sc_mcu7t5v0__buf_1
X_2662_ _2734_/I _2662_/Z VDD VDD VSS VSS gf180mcu_fd_sc_mcu7t5v0__buf_1
X_2593_ _2593_/D _2594_/RN clkload6/I _2593_/Q VDD VDD VSS VSS gf180mcu_fd_sc_mcu7t5v0__dffrnq_1
Xoutput504 _2696_/Z tl_d_dmem_o[109] VDD VDD VSS VSS gf180mcu_fd_sc_mcu7t5v0__dlyd_1
Xoutput515 _2635_/Z tl_d_dmem_o[16] VDD VDD VSS VSS gf180mcu_fd_sc_mcu7t5v0__dlyd_1
Xoutput526 _2645_/Z tl_d_dmem_o[26] VDD VDD VSS VSS gf180mcu_fd_sc_mcu7t5v0__dlyd_1
X_1613_ _2697_/I _2725_/I _2728_/I _1613_/Z VDD VDD VSS VSS gf180mcu_fd_sc_mcu7t5v0__xor3_1
Xoutput537 _1519_/Z tl_d_dmem_o[36] VDD VDD VSS VSS gf180mcu_fd_sc_mcu7t5v0__dlyd_1
Xoutput548 _1529_/Z tl_d_dmem_o[46] VDD VDD VSS VSS gf180mcu_fd_sc_mcu7t5v0__dlyd_1
Xoutput559 _1539_/Z tl_d_dmem_o[56] VDD VDD VSS VSS gf180mcu_fd_sc_mcu7t5v0__dlyd_1
X_1544_ _1856_/B2 _1550_/A2 _1544_/Z VDD VDD VSS VSS gf180mcu_fd_sc_mcu7t5v0__or2_1
XTAP_TAPCELL_ROW_74_1144 VDD VSS gf180mcu_fd_sc_mcu7t5v0__filltie
X_1475_ _1475_/A1 _1473_/Z _1475_/B _1476_/B1 VDD VDD VSS VSS gf180mcu_fd_sc_mcu7t5v0__oai21_1
XFILLER_28_807 VDD VDD VSS VSS gf180mcu_fd_sc_mcu7t5v0__fillcap_16
XFILLER_67_486 VDD VDD VSS VSS gf180mcu_fd_sc_mcu7t5v0__fillcap_4
X_2027_ _2027_/I _2027_/ZN VDD VDD VSS VSS gf180mcu_fd_sc_mcu7t5v0__clkinv_1
XTAP_TAPCELL_ROW_85_1273 VDD VSS gf180mcu_fd_sc_mcu7t5v0__filltie
XFILLER_23_556 VDD VDD VSS VSS gf180mcu_fd_sc_mcu7t5v0__fillcap_4
XFILLER_24_16 VDD VDD VSS VSS gf180mcu_fd_sc_mcu7t5v0__fill_1
XFILLER_40_26 VDD VDD VSS VSS gf180mcu_fd_sc_mcu7t5v0__fill_1
XFILLER_18_317 VDD VDD VSS VSS gf180mcu_fd_sc_mcu7t5v0__fillcap_32
XFILLER_26_361 VDD VDD VSS VSS gf180mcu_fd_sc_mcu7t5v0__fillcap_4
XFILLER_26_372 VDD VDD VSS VSS gf180mcu_fd_sc_mcu7t5v0__fillcap_8
XFILLER_61_629 VDD VDD VSS VSS gf180mcu_fd_sc_mcu7t5v0__fill_1
XTAP_TAPCELL_ROW_24_540 VDD VSS gf180mcu_fd_sc_mcu7t5v0__filltie
XTAP_TAPCELL_ROW_52_882 VDD VSS gf180mcu_fd_sc_mcu7t5v0__filltie
XFILLER_68_217 VDD VDD VSS VSS gf180mcu_fd_sc_mcu7t5v0__fillcap_16
XFILLER_96_515 VDD VDD VSS VSS gf180mcu_fd_sc_mcu7t5v0__fill_1
X_1260_ input9/Z _1348_/A2 _1260_/B1 _2155_/B1 _1261_/I VDD VDD VSS VSS gf180mcu_fd_sc_mcu7t5v0__aoi22_1
Xinput8 tl_d_dmem_i[15] input8/Z VDD VDD VSS VSS gf180mcu_fd_sc_mcu7t5v0__dlyd_1
X_1191_ _1191_/A1 _2383_/A1 _1209_/A1 _1226_/A2 VDD VDD VSS VSS gf180mcu_fd_sc_mcu7t5v0__nand3_1
XFILLER_83_209 VDD VDD VSS VSS gf180mcu_fd_sc_mcu7t5v0__fill_1
XTAP_TAPCELL_ROW_108_1549 VDD VSS gf180mcu_fd_sc_mcu7t5v0__filltie
XFILLER_51_139 VDD VDD VSS VSS gf180mcu_fd_sc_mcu7t5v0__fill_1
X_2714_ _2714_/I _2714_/Z VDD VDD VSS VSS gf180mcu_fd_sc_mcu7t5v0__buf_1
X_2645_ _2717_/I _2645_/Z VDD VDD VSS VSS gf180mcu_fd_sc_mcu7t5v0__buf_1
X_2576_ _2576_/D _2582_/RN _2596_/CLK _2576_/Q VDD VDD VSS VSS gf180mcu_fd_sc_mcu7t5v0__dffrnq_1
X_1527_ _1942_/B2 _1533_/A2 _1527_/Z VDD VDD VSS VSS gf180mcu_fd_sc_mcu7t5v0__or2_1
XFILLER_87_515 VDD VDD VSS VSS gf180mcu_fd_sc_mcu7t5v0__fillcap_32
X_1458_ _2355_/A1 _2238_/B1 _2355_/A3 _1459_/B VDD VDD VSS VSS gf180mcu_fd_sc_mcu7t5v0__nand3_1
XFILLER_87_559 VDD VDD VSS VSS gf180mcu_fd_sc_mcu7t5v0__fill_1
XTAP_TAPCELL_ROW_87_1302 VDD VSS gf180mcu_fd_sc_mcu7t5v0__filltie
XFILLER_95_570 VDD VDD VSS VSS gf180mcu_fd_sc_mcu7t5v0__fill_1
X_1389_ _1389_/I _1390_/B1 VDD VDD VSS VSS gf180mcu_fd_sc_mcu7t5v0__clkinv_1
XTAP_TAPCELL_ROW_2_279 VDD VSS gf180mcu_fd_sc_mcu7t5v0__filltie
XFILLER_82_242 VDD VDD VSS VSS gf180mcu_fd_sc_mcu7t5v0__fill_2
XFILLER_43_629 VDD VDD VSS VSS gf180mcu_fd_sc_mcu7t5v0__fill_1
XFILLER_82_275 VDD VDD VSS VSS gf180mcu_fd_sc_mcu7t5v0__fill_1
XFILLER_23_364 VDD VDD VSS VSS gf180mcu_fd_sc_mcu7t5v0__fillcap_32
XTAP_TAPCELL_ROW_21_510 VDD VSS gf180mcu_fd_sc_mcu7t5v0__filltie
XTAP_TAPCELL_ROW_98_1431 VDD VSS gf180mcu_fd_sc_mcu7t5v0__filltie
Xoutput890 _2733_/Z tl_d_uart_o[74] VDD VDD VSS VSS gf180mcu_fd_sc_mcu7t5v0__dlyd_1
XFILLER_76_33 VDD VDD VSS VSS gf180mcu_fd_sc_mcu7t5v0__fill_2
XFILLER_93_507 VDD VDD VSS VSS gf180mcu_fd_sc_mcu7t5v0__fillcap_32
XFILLER_19_626 VDD VDD VSS VSS gf180mcu_fd_sc_mcu7t5v0__fillcap_4
XFILLER_58_283 VDD VDD VSS VSS gf180mcu_fd_sc_mcu7t5v0__fillcap_8
XTAP_TAPCELL_ROW_29_610 VDD VSS gf180mcu_fd_sc_mcu7t5v0__filltie
XTAP_TAPCELL_ROW_57_941 VDD VSS gf180mcu_fd_sc_mcu7t5v0__filltie
XFILLER_15_865 VDD VDD VSS VSS gf180mcu_fd_sc_mcu7t5v0__fill_1
XFILLER_41_150 VDD VDD VSS VSS gf180mcu_fd_sc_mcu7t5v0__fill_1
XFILLER_42_662 VDD VDD VSS VSS gf180mcu_fd_sc_mcu7t5v0__fill_2
XFILLER_10_581 VDD VDD VSS VSS gf180mcu_fd_sc_mcu7t5v0__fillcap_8
XFILLER_41_80 VDD VDD VSS VSS gf180mcu_fd_sc_mcu7t5v0__fill_2
Xoutput1006 _2308_/ZN tl_h_i_o[29] VDD VDD VSS VSS gf180mcu_fd_sc_mcu7t5v0__dlyd_1
X_2430_ _2429_/B _2430_/A2 _2431_/A2 VDD VDD VSS VSS gf180mcu_fd_sc_mcu7t5v0__xnor2_1
Xoutput1017 _2348_/ZN tl_h_i_o[39] VDD VDD VSS VSS gf180mcu_fd_sc_mcu7t5v0__dlyd_1
Xoutput1028 _2084_/ZN tl_h_i_o[49] VDD VDD VSS VSS gf180mcu_fd_sc_mcu7t5v0__dlyd_1
Xoutput1039 _2107_/ZN tl_h_i_o[59] VDD VDD VSS VSS gf180mcu_fd_sc_mcu7t5v0__dlyd_1
XTAP_TAPCELL_ROW_71_1103 VDD VSS gf180mcu_fd_sc_mcu7t5v0__filltie
X_2361_ _2369_/A1 _2361_/A2 _2362_/A2 VDD VDD VSS VSS gf180mcu_fd_sc_mcu7t5v0__nand2_1
XTAP_TAPCELL_ROW_71_1114 VDD VSS gf180mcu_fd_sc_mcu7t5v0__filltie
X_2292_ _2292_/A1 _2292_/A2 _2348_/B _2292_/ZN VDD VDD VSS VSS gf180mcu_fd_sc_mcu7t5v0__aoi21_1
X_1312_ _1312_/A1 _1368_/A2 _2281_/A2 VDD VDD VSS VSS gf180mcu_fd_sc_mcu7t5v0__nand2_1
XFILLER_69_537 VDD VDD VSS VSS gf180mcu_fd_sc_mcu7t5v0__fill_1
X_1243_ _1243_/I _1243_/ZN VDD VDD VSS VSS gf180mcu_fd_sc_mcu7t5v0__clkinv_1
XFILLER_64_242 VDD VDD VSS VSS gf180mcu_fd_sc_mcu7t5v0__fill_2
X_1174_ _1058_/I _2382_/A1 _1174_/A3 _1166_/Z _1175_/A4 VDD VDD VSS VSS gf180mcu_fd_sc_mcu7t5v0__nand4_1
XFILLER_37_489 VDD VDD VSS VSS gf180mcu_fd_sc_mcu7t5v0__fill_1
XTAP_TAPCELL_ROW_69_1087 VDD VSS gf180mcu_fd_sc_mcu7t5v0__filltie
XFILLER_80_724 VDD VDD VSS VSS gf180mcu_fd_sc_mcu7t5v0__fillcap_8
XTAP_TAPCELL_ROW_82_1243 VDD VSS gf180mcu_fd_sc_mcu7t5v0__filltie
XTAP_TAPCELL_ROW_35_679 VDD VSS gf180mcu_fd_sc_mcu7t5v0__filltie
XANTENNA_13 _1992_/A1 VDD VDD VSS VSS gf180mcu_fd_sc_mcu7t5v0__antenna
XFILLER_32_183 VDD VDD VSS VSS gf180mcu_fd_sc_mcu7t5v0__fill_1
XANTENNA_24 _2643_/Z VDD VDD VSS VSS gf180mcu_fd_sc_mcu7t5v0__antenna
XANTENNA_35 _2719_/I VDD VDD VSS VSS gf180mcu_fd_sc_mcu7t5v0__antenna
XANTENNA_46 _2147_/ZN VDD VDD VSS VSS gf180mcu_fd_sc_mcu7t5v0__antenna
XFILLER_118_211 VDD VDD VSS VSS gf180mcu_fd_sc_mcu7t5v0__fill_2
XFILLER_102_601 VDD VDD VSS VSS gf180mcu_fd_sc_mcu7t5v0__fill_1
X_2559_ _2559_/D _2567_/RN clkload2/I _2559_/Q VDD VDD VSS VSS gf180mcu_fd_sc_mcu7t5v0__dffrnq_1
XTAP_TAPCELL_ROW_93_1372 VDD VSS gf180mcu_fd_sc_mcu7t5v0__filltie
XTAP_TAPCELL_ROW_7_338 VDD VSS gf180mcu_fd_sc_mcu7t5v0__filltie
XFILLER_87_356 VDD VDD VSS VSS gf180mcu_fd_sc_mcu7t5v0__fill_2
XFILLER_55_220 VDD VDD VSS VSS gf180mcu_fd_sc_mcu7t5v0__fillcap_4
XTAP_TAPCELL_ROW_54_900 VDD VSS gf180mcu_fd_sc_mcu7t5v0__filltie
XFILLER_83_562 VDD VDD VSS VSS gf180mcu_fd_sc_mcu7t5v0__fillcap_32
XFILLER_71_702 VDD VDD VSS VSS gf180mcu_fd_sc_mcu7t5v0__fillcap_64
XFILLER_51_492 VDD VDD VSS VSS gf180mcu_fd_sc_mcu7t5v0__fillcap_32
XPHY_EDGE_ROW_12_Left_131 VDD VSS gf180mcu_fd_sc_mcu7t5v0__endcap
XFILLER_38_209 VDD VDD VSS VSS gf180mcu_fd_sc_mcu7t5v0__fillcap_8
XFILLER_78_367 VDD VDD VSS VSS gf180mcu_fd_sc_mcu7t5v0__fill_2
XPHY_EDGE_ROW_21_Left_140 VDD VSS gf180mcu_fd_sc_mcu7t5v0__endcap
XFILLER_93_315 VDD VDD VSS VSS gf180mcu_fd_sc_mcu7t5v0__fill_1
XFILLER_47_754 VDD VDD VSS VSS gf180mcu_fd_sc_mcu7t5v0__fillcap_16
XTAP_TAPCELL_ROW_105_1519 VDD VSS gf180mcu_fd_sc_mcu7t5v0__filltie
XFILLER_61_212 VDD VDD VSS VSS gf180mcu_fd_sc_mcu7t5v0__fillcap_16
XFILLER_61_234 VDD VDD VSS VSS gf180mcu_fd_sc_mcu7t5v0__fill_1
XFILLER_42_481 VDD VDD VSS VSS gf180mcu_fd_sc_mcu7t5v0__fill_2
XFILLER_61_289 VDD VDD VSS VSS gf180mcu_fd_sc_mcu7t5v0__fillcap_32
X_1930_ _1930_/A1 _1964_/A2 _1930_/B1 _1930_/B2 _1931_/I VDD VDD VSS VSS gf180mcu_fd_sc_mcu7t5v0__aoi22_1
XTAP_TAPCELL_ROW_32_638 VDD VSS gf180mcu_fd_sc_mcu7t5v0__filltie
X_1861_ _1861_/I _1861_/ZN VDD VDD VSS VSS gf180mcu_fd_sc_mcu7t5v0__clkinv_1
Xinput11 tl_d_dmem_i[18] input11/Z VDD VDD VSS VSS gf180mcu_fd_sc_mcu7t5v0__dlyd_1
Xinput22 tl_d_dmem_i[28] input22/Z VDD VDD VSS VSS gf180mcu_fd_sc_mcu7t5v0__dlyd_1
Xinput33 tl_d_dmem_i[38] input33/Z VDD VDD VSS VSS gf180mcu_fd_sc_mcu7t5v0__dlyd_1
Xinput44 tl_d_dmem_i[48] input44/Z VDD VDD VSS VSS gf180mcu_fd_sc_mcu7t5v0__dlyd_1
Xinput55 tl_d_dmem_i[58] input55/Z VDD VDD VSS VSS gf180mcu_fd_sc_mcu7t5v0__dlyd_1
X_1792_ _1982_/A1 _1822_/A2 _1814_/B1 _2723_/I _1793_/I VDD VDD VSS VSS gf180mcu_fd_sc_mcu7t5v0__aoi22_1
XTAP_TAPCELL_ROW_12_395 VDD VSS gf180mcu_fd_sc_mcu7t5v0__filltie
Xinput66 tl_d_dmem_i[8] input66/Z VDD VDD VSS VSS gf180mcu_fd_sc_mcu7t5v0__dlyd_1
Xinput77 tl_d_esram_i[18] input77/Z VDD VDD VSS VSS gf180mcu_fd_sc_mcu7t5v0__dlyd_1
Xinput88 tl_d_esram_i[28] input88/Z VDD VDD VSS VSS gf180mcu_fd_sc_mcu7t5v0__dlyd_1
XTAP_TAPCELL_ROW_116_1648 VDD VSS gf180mcu_fd_sc_mcu7t5v0__filltie
Xinput99 tl_d_esram_i[38] input99/Z VDD VDD VSS VSS gf180mcu_fd_sc_mcu7t5v0__dlyd_1
XFILLER_42_2 VDD VDD VSS VSS gf180mcu_fd_sc_mcu7t5v0__fillcap_8
X_2413_ _2561_/Q _2434_/B _2415_/B VDD VDD VSS VSS gf180mcu_fd_sc_mcu7t5v0__xor2_1
X_2344_ _2344_/A1 _2344_/A2 _2348_/B _2344_/ZN VDD VDD VSS VSS gf180mcu_fd_sc_mcu7t5v0__aoi21_1
XFILLER_29_209 VDD VDD VSS VSS gf180mcu_fd_sc_mcu7t5v0__fill_1
XTAP_TAPCELL_ROW_4_308 VDD VSS gf180mcu_fd_sc_mcu7t5v0__filltie
X_2275_ input81/Z _2363_/A2 _2295_/A3 _2276_/A2 VDD VDD VSS VSS gf180mcu_fd_sc_mcu7t5v0__nand3_1
X_1226_ _1226_/A1 _1226_/A2 _2704_/I VDD VDD VSS VSS gf180mcu_fd_sc_mcu7t5v0__nand2_1
XFILLER_84_359 VDD VDD VSS VSS gf180mcu_fd_sc_mcu7t5v0__fill_2
XFILLER_37_264 VDD VDD VSS VSS gf180mcu_fd_sc_mcu7t5v0__fill_2
XFILLER_53_702 VDD VDD VSS VSS gf180mcu_fd_sc_mcu7t5v0__fillcap_64
XFILLER_65_562 VDD VDD VSS VSS gf180mcu_fd_sc_mcu7t5v0__fillcap_8
X_1157_ _1076_/I _1221_/A2 _1204_/B VDD VDD VSS VSS gf180mcu_fd_sc_mcu7t5v0__nand2_1
XFILLER_37_286 VDD VDD VSS VSS gf180mcu_fd_sc_mcu7t5v0__fill_1
XFILLER_80_532 VDD VDD VSS VSS gf180mcu_fd_sc_mcu7t5v0__fillcap_16
X_1088_ _1088_/I _2230_/A1 VDD VDD VSS VSS gf180mcu_fd_sc_mcu7t5v0__clkinv_1
XFILLER_21_632 VDD VDD VSS VSS gf180mcu_fd_sc_mcu7t5v0__fillcap_64
XFILLER_33_492 VDD VDD VSS VSS gf180mcu_fd_sc_mcu7t5v0__fillcap_16
XTAP_TAPCELL_ROW_95_1401 VDD VSS gf180mcu_fd_sc_mcu7t5v0__filltie
XFILLER_48_507 VDD VDD VSS VSS gf180mcu_fd_sc_mcu7t5v0__fill_2
Xinput404 tl_h_i_i[19] _1892_/A1 VDD VDD VSS VSS gf180mcu_fd_sc_mcu7t5v0__dlyd_1
Xinput415 tl_h_i_i[29] _1912_/A1 VDD VDD VSS VSS gf180mcu_fd_sc_mcu7t5v0__dlyd_1
Xinput426 tl_h_i_i[39] _1932_/A1 VDD VDD VSS VSS gf180mcu_fd_sc_mcu7t5v0__dlyd_1
Xinput437 tl_h_i_i[49] _1952_/A1 VDD VDD VSS VSS gf180mcu_fd_sc_mcu7t5v0__dlyd_1
XFILLER_102_475 VDD VDD VSS VSS gf180mcu_fd_sc_mcu7t5v0__fillcap_4
Xinput448 tl_h_i_i[59] _1972_/A1 VDD VDD VSS VSS gf180mcu_fd_sc_mcu7t5v0__dlyd_1
Xinput459 tl_h_i_i[69] _1992_/A1 VDD VDD VSS VSS gf180mcu_fd_sc_mcu7t5v0__dlyd_1
XFILLER_28_242 VDD VDD VSS VSS gf180mcu_fd_sc_mcu7t5v0__fill_2
XFILLER_28_253 VDD VDD VSS VSS gf180mcu_fd_sc_mcu7t5v0__fillcap_8
XFILLER_28_286 VDD VDD VSS VSS gf180mcu_fd_sc_mcu7t5v0__fill_1
XFILLER_71_554 VDD VDD VSS VSS gf180mcu_fd_sc_mcu7t5v0__fillcap_4
XFILLER_43_278 VDD VDD VSS VSS gf180mcu_fd_sc_mcu7t5v0__fill_2
XFILLER_4_831 VDD VDD VSS VSS gf180mcu_fd_sc_mcu7t5v0__fill_1
XFILLER_79_632 VDD VDD VSS VSS gf180mcu_fd_sc_mcu7t5v0__fillcap_32
XFILLER_79_621 VDD VDD VSS VSS gf180mcu_fd_sc_mcu7t5v0__fill_1
XFILLER_79_676 VDD VDD VSS VSS gf180mcu_fd_sc_mcu7t5v0__fill_2
Xfanout1142 _2364_/B _2380_/B VDD VDD VSS VSS gf180mcu_fd_sc_mcu7t5v0__dlyd_1
XTAP_TAPCELL_ROW_111_1589 VDD VSS gf180mcu_fd_sc_mcu7t5v0__filltie
XFILLER_94_635 VDD VDD VSS VSS gf180mcu_fd_sc_mcu7t5v0__fill_1
XFILLER_79_698 VDD VDD VSS VSS gf180mcu_fd_sc_mcu7t5v0__fill_2
Xfanout1186 _2379_/A2 _2371_/A2 VDD VDD VSS VSS gf180mcu_fd_sc_mcu7t5v0__dlyd_1
X_2060_ _2136_/B2 _2315_/A2 _2277_/A1 _2136_/A1 _2061_/I VDD VDD VSS VSS gf180mcu_fd_sc_mcu7t5v0__aoi22_1
XFILLER_35_702 VDD VDD VSS VSS gf180mcu_fd_sc_mcu7t5v0__fillcap_64
XFILLER_47_562 VDD VDD VSS VSS gf180mcu_fd_sc_mcu7t5v0__fillcap_16
XFILLER_34_234 VDD VDD VSS VSS gf180mcu_fd_sc_mcu7t5v0__fill_1
XFILLER_22_407 VDD VDD VSS VSS gf180mcu_fd_sc_mcu7t5v0__fill_1
XTAP_TAPCELL_ROW_66_1046 VDD VSS gf180mcu_fd_sc_mcu7t5v0__filltie
XTAP_TAPCELL_ROW_45_796 VDD VSS gf180mcu_fd_sc_mcu7t5v0__filltie
XTAP_TAPCELL_ROW_17_465 VDD VSS gf180mcu_fd_sc_mcu7t5v0__filltie
XFILLER_15_492 VDD VDD VSS VSS gf180mcu_fd_sc_mcu7t5v0__fillcap_64
XFILLER_30_440 VDD VDD VSS VSS gf180mcu_fd_sc_mcu7t5v0__fill_2
X_1913_ _1913_/I _1913_/ZN VDD VDD VSS VSS gf180mcu_fd_sc_mcu7t5v0__clkinv_1
X_1844_ _2034_/A1 _1854_/A2 _1850_/B1 _2766_/I _1845_/I VDD VDD VSS VSS gf180mcu_fd_sc_mcu7t5v0__aoi22_1
X_1775_ _1775_/I _1775_/ZN VDD VDD VSS VSS gf180mcu_fd_sc_mcu7t5v0__clkinv_1
XTAP_TAPCELL_ROW_77_1186 VDD VSS gf180mcu_fd_sc_mcu7t5v0__filltie
XTAP_TAPCELL_ROW_77_1175 VDD VSS gf180mcu_fd_sc_mcu7t5v0__filltie
XTAP_TAPCELL_ROW_90_1342 VDD VSS gf180mcu_fd_sc_mcu7t5v0__filltie
XTAP_TAPCELL_ROW_90_1331 VDD VSS gf180mcu_fd_sc_mcu7t5v0__filltie
XFILLER_69_142 VDD VDD VSS VSS gf180mcu_fd_sc_mcu7t5v0__fill_1
X_2327_ input95/Z _2343_/A2 _2375_/A3 _2328_/A2 VDD VDD VSS VSS gf180mcu_fd_sc_mcu7t5v0__nand3_1
X_2258_ _2358_/A1 _2258_/A2 _2260_/A1 VDD VDD VSS VSS gf180mcu_fd_sc_mcu7t5v0__nand2_1
X_1209_ _1209_/A1 _1209_/A2 _1209_/A3 _2383_/A2 VDD VDD VSS VSS gf180mcu_fd_sc_mcu7t5v0__nand3_2
XFILLER_25_212 VDD VDD VSS VSS gf180mcu_fd_sc_mcu7t5v0__fillcap_32
X_2189_ _1116_/B _2189_/A2 _2189_/A3 _2190_/C VDD VDD VSS VSS gf180mcu_fd_sc_mcu7t5v0__nand3_1
XFILLER_81_852 VDD VDD VSS VSS gf180mcu_fd_sc_mcu7t5v0__fillcap_8
XFILLER_68_34 VDD VDD VSS VSS gf180mcu_fd_sc_mcu7t5v0__fill_1
Xinput201 tl_d_uart_i[10] _1092_/I VDD VDD VSS VSS gf180mcu_fd_sc_mcu7t5v0__dlyd_1
XFILLER_0_366 VDD VDD VSS VSS gf180mcu_fd_sc_mcu7t5v0__fill_2
Xinput212 tl_d_uart_i[20] _1294_/A1 VDD VDD VSS VSS gf180mcu_fd_sc_mcu7t5v0__dlyd_1
Xinput223 tl_d_uart_i[30] _1374_/A1 VDD VDD VSS VSS gf180mcu_fd_sc_mcu7t5v0__dlyd_1
Xinput234 tl_d_uart_i[40] _1454_/A1 VDD VDD VSS VSS gf180mcu_fd_sc_mcu7t5v0__dlyd_1
Xinput245 tl_d_uart_i[50] _1097_/I VDD VDD VSS VSS gf180mcu_fd_sc_mcu7t5v0__dlyd_1
XFILLER_76_613 VDD VDD VSS VSS gf180mcu_fd_sc_mcu7t5v0__fillcap_8
Xinput256 tl_d_uart_i[60] _2241_/A1 VDD VDD VSS VSS gf180mcu_fd_sc_mcu7t5v0__dlyd_1
Xinput267 tl_h_d_i[100] _2759_/I VDD VDD VSS VSS gf180mcu_fd_sc_mcu7t5v0__dlyd_1
Xinput278 tl_h_d_i[110] _2769_/I VDD VDD VSS VSS gf180mcu_fd_sc_mcu7t5v0__clkbuf_2
XFILLER_17_702 VDD VDD VSS VSS gf180mcu_fd_sc_mcu7t5v0__fillcap_64
XFILLER_29_562 VDD VDD VSS VSS gf180mcu_fd_sc_mcu7t5v0__fillcap_4
Xinput289 tl_h_d_i[18] _1700_/B2 VDD VDD VSS VSS gf180mcu_fd_sc_mcu7t5v0__clkbuf_2
XFILLER_44_543 VDD VDD VSS VSS gf180mcu_fd_sc_mcu7t5v0__fillcap_4
XFILLER_71_340 VDD VDD VSS VSS gf180mcu_fd_sc_mcu7t5v0__fillcap_8
XFILLER_44_587 VDD VDD VSS VSS gf180mcu_fd_sc_mcu7t5v0__fillcap_8
XFILLER_71_384 VDD VDD VSS VSS gf180mcu_fd_sc_mcu7t5v0__fillcap_8
XTAP_TAPCELL_ROW_42_755 VDD VSS gf180mcu_fd_sc_mcu7t5v0__filltie
XTAP_TAPCELL_ROW_14_424 VDD VSS gf180mcu_fd_sc_mcu7t5v0__filltie
XFILLER_12_451 VDD VDD VSS VSS gf180mcu_fd_sc_mcu7t5v0__fillcap_4
XTAP_TAPCELL_ROW_42_766 VDD VSS gf180mcu_fd_sc_mcu7t5v0__filltie
Xoutput708 _1831_/ZN tl_d_rom_o[100] VDD VDD VSS VSS gf180mcu_fd_sc_mcu7t5v0__dlyd_1
X_1560_ _2730_/I _2731_/I _1560_/Z VDD VDD VSS VSS gf180mcu_fd_sc_mcu7t5v0__xor2_1
Xoutput719 _1851_/ZN tl_d_rom_o[110] VDD VDD VSS VSS gf180mcu_fd_sc_mcu7t5v0__dlyd_1
XTAP_TAPCELL_ROW_113_1618 VDD VSS gf180mcu_fd_sc_mcu7t5v0__filltie
XTAP_TAPCELL_ROW_113_1607 VDD VSS gf180mcu_fd_sc_mcu7t5v0__filltie
X_1491_ _1491_/A1 _1489_/Z _1491_/B _1492_/B1 VDD VDD VSS VSS gf180mcu_fd_sc_mcu7t5v0__oai21_1
X_2112_ _2112_/A1 _2153_/A2 _2142_/B input79/Z _2114_/B2 VDD VDD VSS VSS gf180mcu_fd_sc_mcu7t5v0__oai22_1
X_2043_ _2043_/I _2043_/ZN VDD VDD VSS VSS gf180mcu_fd_sc_mcu7t5v0__clkinv_1
XFILLER_81_137 VDD VDD VSS VSS gf180mcu_fd_sc_mcu7t5v0__fill_2
XFILLER_62_384 VDD VDD VSS VSS gf180mcu_fd_sc_mcu7t5v0__fill_1
XFILLER_50_535 VDD VDD VSS VSS gf180mcu_fd_sc_mcu7t5v0__fillcap_4
XFILLER_50_579 VDD VDD VSS VSS gf180mcu_fd_sc_mcu7t5v0__fill_1
XTAP_TAPCELL_ROW_79_1204 VDD VSS gf180mcu_fd_sc_mcu7t5v0__filltie
X_1827_ _1827_/I _1827_/ZN VDD VDD VSS VSS gf180mcu_fd_sc_mcu7t5v0__clkinv_1
X_1758_ _1948_/A1 _1768_/A2 _1768_/B1 _1948_/B2 _1759_/I VDD VDD VSS VSS gf180mcu_fd_sc_mcu7t5v0__aoi22_1
X_1689_ _1689_/I _1689_/ZN VDD VDD VSS VSS gf180mcu_fd_sc_mcu7t5v0__clkinv_1
XFILLER_58_613 VDD VDD VSS VSS gf180mcu_fd_sc_mcu7t5v0__fillcap_8
XFILLER_97_292 VDD VDD VSS VSS gf180mcu_fd_sc_mcu7t5v0__fill_1
XFILLER_85_487 VDD VDD VSS VSS gf180mcu_fd_sc_mcu7t5v0__fill_2
XFILLER_85_454 VDD VDD VSS VSS gf180mcu_fd_sc_mcu7t5v0__fillcap_16
XFILLER_38_381 VDD VDD VSS VSS gf180mcu_fd_sc_mcu7t5v0__fillcap_4
XFILLER_72_137 VDD VDD VSS VSS gf180mcu_fd_sc_mcu7t5v0__fill_1
XFILLER_21_270 VDD VDD VSS VSS gf180mcu_fd_sc_mcu7t5v0__fillcap_8
XFILLER_76_443 VDD VDD VSS VSS gf180mcu_fd_sc_mcu7t5v0__fillcap_8
XFILLER_48_156 VDD VDD VSS VSS gf180mcu_fd_sc_mcu7t5v0__fillcap_16
XFILLER_63_104 VDD VDD VSS VSS gf180mcu_fd_sc_mcu7t5v0__fillcap_16
XFILLER_64_638 VDD VDD VSS VSS gf180mcu_fd_sc_mcu7t5v0__fillcap_16
Xload_slew1141 _2348_/B _2376_/B VDD VDD VSS VSS gf180mcu_fd_sc_mcu7t5v0__buf_4
XTAP_TAPCELL_ROW_47_825 VDD VSS gf180mcu_fd_sc_mcu7t5v0__filltie
XFILLER_45_852 VDD VDD VSS VSS gf180mcu_fd_sc_mcu7t5v0__fillcap_8
XFILLER_63_159 VDD VDD VSS VSS gf180mcu_fd_sc_mcu7t5v0__fillcap_4
Xload_slew1185 _2315_/A2 _2323_/A2 VDD VDD VSS VSS gf180mcu_fd_sc_mcu7t5v0__buf_4
Xload_slew1196 _2215_/B _2170_/C VDD VDD VSS VSS gf180mcu_fd_sc_mcu7t5v0__buf_4
XTAP_TAPCELL_ROW_63_1016 VDD VSS gf180mcu_fd_sc_mcu7t5v0__filltie
XTAP_TAPCELL_ROW_27_582 VDD VSS gf180mcu_fd_sc_mcu7t5v0__filltie
XPHY_EDGE_ROW_4_Left_123 VDD VSS gf180mcu_fd_sc_mcu7t5v0__endcap
X_2730_ _2730_/I _2730_/Z VDD VDD VSS VSS gf180mcu_fd_sc_mcu7t5v0__buf_1
X_2661_ _2733_/I _2661_/Z VDD VDD VSS VSS gf180mcu_fd_sc_mcu7t5v0__buf_1
X_1612_ _2744_/I _2746_/I _1611_/Z _1612_/Z VDD VDD VSS VSS gf180mcu_fd_sc_mcu7t5v0__xor3_1
X_2592_ _2592_/D _2594_/RN clkload6/I _2592_/Q VDD VDD VSS VSS gf180mcu_fd_sc_mcu7t5v0__dffrnq_1
Xoutput505 _1580_/Z tl_d_dmem_o[10] VDD VDD VSS VSS gf180mcu_fd_sc_mcu7t5v0__dlyd_1
Xoutput516 _2636_/Z tl_d_dmem_o[17] VDD VDD VSS VSS gf180mcu_fd_sc_mcu7t5v0__dlyd_1
Xoutput527 _2646_/Z tl_d_dmem_o[27] VDD VDD VSS VSS gf180mcu_fd_sc_mcu7t5v0__dlyd_1
Xoutput538 _1520_/Z tl_d_dmem_o[37] VDD VDD VSS VSS gf180mcu_fd_sc_mcu7t5v0__dlyd_1
Xoutput549 _1530_/Z tl_d_dmem_o[47] VDD VDD VSS VSS gf180mcu_fd_sc_mcu7t5v0__dlyd_1
X_1543_ _1974_/B2 _1619_/S _1543_/Z VDD VDD VSS VSS gf180mcu_fd_sc_mcu7t5v0__or2_1
XTAP_TAPCELL_ROW_74_1145 VDD VSS gf180mcu_fd_sc_mcu7t5v0__filltie
X_1474_ _2363_/A1 _1490_/A2 _2363_/A3 _1475_/B VDD VDD VSS VSS gf180mcu_fd_sc_mcu7t5v0__nand3_1
XFILLER_39_189 VDD VDD VSS VSS gf180mcu_fd_sc_mcu7t5v0__fillcap_16
X_2026_ _2400_/I0 _2044_/A2 _2038_/B1 _2761_/I _2027_/I VDD VDD VSS VSS gf180mcu_fd_sc_mcu7t5v0__aoi22_1
XFILLER_82_457 VDD VDD VSS VSS gf180mcu_fd_sc_mcu7t5v0__fill_2
XTAP_TAPCELL_ROW_85_1274 VDD VSS gf180mcu_fd_sc_mcu7t5v0__filltie
XPHY_EDGE_ROW_59_Left_178 VDD VSS gf180mcu_fd_sc_mcu7t5v0__endcap
XFILLER_104_312 VDD VDD VSS VSS gf180mcu_fd_sc_mcu7t5v0__fill_2
XFILLER_104_334 VDD VDD VSS VSS gf180mcu_fd_sc_mcu7t5v0__fill_2
XPHY_EDGE_ROW_68_Left_187 VDD VSS gf180mcu_fd_sc_mcu7t5v0__endcap
XFILLER_77_207 VDD VDD VSS VSS gf180mcu_fd_sc_mcu7t5v0__fill_2
XFILLER_86_763 VDD VDD VSS VSS gf180mcu_fd_sc_mcu7t5v0__fill_1
XFILLER_60_107 VDD VDD VSS VSS gf180mcu_fd_sc_mcu7t5v0__fillcap_64
XPHY_EDGE_ROW_77_Left_196 VDD VSS gf180mcu_fd_sc_mcu7t5v0__endcap
XFILLER_26_384 VDD VDD VSS VSS gf180mcu_fd_sc_mcu7t5v0__fill_1
XFILLER_41_332 VDD VDD VSS VSS gf180mcu_fd_sc_mcu7t5v0__fill_2
XTAP_TAPCELL_ROW_24_541 VDD VSS gf180mcu_fd_sc_mcu7t5v0__filltie
XTAP_TAPCELL_ROW_52_883 VDD VSS gf180mcu_fd_sc_mcu7t5v0__filltie
XFILLER_96_527 VDD VDD VSS VSS gf180mcu_fd_sc_mcu7t5v0__fillcap_16
X_1190_ _1190_/A1 _1190_/A2 _1190_/B _1190_/C _1195_/B VDD VDD VSS VSS gf180mcu_fd_sc_mcu7t5v0__aoi211_1
XFILLER_37_627 VDD VDD VSS VSS gf180mcu_fd_sc_mcu7t5v0__fill_2
XFILLER_49_487 VDD VDD VSS VSS gf180mcu_fd_sc_mcu7t5v0__fill_2
Xinput9 tl_d_dmem_i[16] input9/Z VDD VDD VSS VSS gf180mcu_fd_sc_mcu7t5v0__dlyd_1
XFILLER_64_457 VDD VDD VSS VSS gf180mcu_fd_sc_mcu7t5v0__fillcap_4
XFILLER_91_298 VDD VDD VSS VSS gf180mcu_fd_sc_mcu7t5v0__fillcap_8
XFILLER_20_527 VDD VDD VSS VSS gf180mcu_fd_sc_mcu7t5v0__fillcap_64
XFILLER_32_387 VDD VDD VSS VSS gf180mcu_fd_sc_mcu7t5v0__fillcap_8
XFILLER_72_2 VDD VDD VSS VSS gf180mcu_fd_sc_mcu7t5v0__fillcap_8
X_2713_ _2713_/I _2713_/Z VDD VDD VSS VSS gf180mcu_fd_sc_mcu7t5v0__buf_1
XFILLER_9_572 VDD VDD VSS VSS gf180mcu_fd_sc_mcu7t5v0__fill_1
X_2644_ _2716_/I _2644_/Z VDD VDD VSS VSS gf180mcu_fd_sc_mcu7t5v0__buf_1
X_2575_ _2575_/D _2582_/RN _2596_/CLK _2575_/Q VDD VDD VSS VSS gf180mcu_fd_sc_mcu7t5v0__dffrnq_1
X_1526_ _1940_/B2 _1533_/A2 _1526_/Z VDD VDD VSS VSS gf180mcu_fd_sc_mcu7t5v0__or2_1
XFILLER_102_827 VDD VDD VSS VSS gf180mcu_fd_sc_mcu7t5v0__fillcap_4
XFILLER_59_207 VDD VDD VSS VSS gf180mcu_fd_sc_mcu7t5v0__fill_2
XFILLER_59_218 VDD VDD VSS VSS gf180mcu_fd_sc_mcu7t5v0__fillcap_32
XFILLER_101_315 VDD VDD VSS VSS gf180mcu_fd_sc_mcu7t5v0__fill_1
X_1457_ _2199_/A2 _2353_/A2 _1457_/Z VDD VDD VSS VSS gf180mcu_fd_sc_mcu7t5v0__and2_1
X_1388_ input27/Z _1468_/A2 _1388_/B1 _2160_/A2 _1389_/I VDD VDD VSS VSS gf180mcu_fd_sc_mcu7t5v0__aoi22_1
XTAP_TAPCELL_ROW_87_1303 VDD VSS gf180mcu_fd_sc_mcu7t5v0__filltie
XFILLER_83_766 VDD VDD VSS VSS gf180mcu_fd_sc_mcu7t5v0__fillcap_4
X_2009_ _2009_/I _2009_/ZN VDD VDD VSS VSS gf180mcu_fd_sc_mcu7t5v0__clkinv_1
XFILLER_50_173 VDD VDD VSS VSS gf180mcu_fd_sc_mcu7t5v0__fill_2
XFILLER_51_696 VDD VDD VSS VSS gf180mcu_fd_sc_mcu7t5v0__fillcap_4
XTAP_TAPCELL_ROW_21_511 VDD VSS gf180mcu_fd_sc_mcu7t5v0__filltie
XTAP_TAPCELL_ROW_98_1432 VDD VSS gf180mcu_fd_sc_mcu7t5v0__filltie
Xoutput891 _2734_/Z tl_d_uart_o[75] VDD VDD VSS VSS gf180mcu_fd_sc_mcu7t5v0__dlyd_1
Xoutput880 _2724_/Z tl_d_uart_o[65] VDD VDD VSS VSS gf180mcu_fd_sc_mcu7t5v0__dlyd_1
XFILLER_78_527 VDD VDD VSS VSS gf180mcu_fd_sc_mcu7t5v0__fillcap_16
XTAP_TAPCELL_ROW_29_600 VDD VSS gf180mcu_fd_sc_mcu7t5v0__filltie
XFILLER_46_457 VDD VDD VSS VSS gf180mcu_fd_sc_mcu7t5v0__fillcap_64
XFILLER_58_295 VDD VDD VSS VSS gf180mcu_fd_sc_mcu7t5v0__fill_2
XTAP_TAPCELL_ROW_57_942 VDD VSS gf180mcu_fd_sc_mcu7t5v0__filltie
XPHY_EDGE_ROW_85_Left_204 VDD VSS gf180mcu_fd_sc_mcu7t5v0__endcap
XFILLER_15_855 VDD VDD VSS VSS gf180mcu_fd_sc_mcu7t5v0__fillcap_8
XFILLER_14_343 VDD VDD VSS VSS gf180mcu_fd_sc_mcu7t5v0__fill_1
XFILLER_14_387 VDD VDD VSS VSS gf180mcu_fd_sc_mcu7t5v0__fillcap_64
XPHY_EDGE_ROW_94_Left_213 VDD VSS gf180mcu_fd_sc_mcu7t5v0__endcap
XFILLER_10_593 VDD VDD VSS VSS gf180mcu_fd_sc_mcu7t5v0__fill_2
XTAP_TAPCELL_ROW_118_1690 VDD VSS gf180mcu_fd_sc_mcu7t5v0__filltie
Xoutput1007 _2049_/ZN tl_h_i_o[2] VDD VDD VSS VSS gf180mcu_fd_sc_mcu7t5v0__dlyd_1
Xoutput1018 _2051_/ZN tl_h_i_o[3] VDD VDD VSS VSS gf180mcu_fd_sc_mcu7t5v0__dlyd_1
Xoutput1029 _2053_/ZN tl_h_i_o[4] VDD VDD VSS VSS gf180mcu_fd_sc_mcu7t5v0__dlyd_1
X_2360_ _2360_/A1 _2360_/A2 _2360_/B _2360_/ZN VDD VDD VSS VSS gf180mcu_fd_sc_mcu7t5v0__aoi21_1
XTAP_TAPCELL_ROW_71_1104 VDD VSS gf180mcu_fd_sc_mcu7t5v0__filltie
X_2291_ input85/Z _2291_/A2 _2311_/A3 _2292_/A2 VDD VDD VSS VSS gf180mcu_fd_sc_mcu7t5v0__nand3_1
X_1311_ _1487_/A1 _1311_/A2 _1311_/ZN VDD VDD VSS VSS gf180mcu_fd_sc_mcu7t5v0__nor2_1
X_1242_ _1257_/A2 _2371_/A2 _2373_/A1 _1251_/A2 _1243_/I VDD VDD VSS VSS gf180mcu_fd_sc_mcu7t5v0__aoi22_1
XPHY_EDGE_ROW_10_Right_10 VDD VSS gf180mcu_fd_sc_mcu7t5v0__endcap
XFILLER_49_273 VDD VDD VSS VSS gf180mcu_fd_sc_mcu7t5v0__fillcap_4
X_1173_ _1164_/Z _1173_/A2 _2067_/B _1175_/A3 VDD VDD VSS VSS gf180mcu_fd_sc_mcu7t5v0__oai21_1
XTAP_TAPCELL_ROW_69_1088 VDD VSS gf180mcu_fd_sc_mcu7t5v0__filltie
XTAP_TAPCELL_ROW_82_1244 VDD VSS gf180mcu_fd_sc_mcu7t5v0__filltie
XANTENNA_14 _2300_/ZN VDD VDD VSS VSS gf180mcu_fd_sc_mcu7t5v0__antenna
XFILLER_33_696 VDD VDD VSS VSS gf180mcu_fd_sc_mcu7t5v0__fillcap_4
XANTENNA_25 _2645_/Z VDD VDD VSS VSS gf180mcu_fd_sc_mcu7t5v0__antenna
XANTENNA_36 _1930_/B2 VDD VDD VSS VSS gf180mcu_fd_sc_mcu7t5v0__antenna
XFILLER_21_858 VDD VDD VSS VSS gf180mcu_fd_sc_mcu7t5v0__fillcap_8
XFILLER_20_379 VDD VDD VSS VSS gf180mcu_fd_sc_mcu7t5v0__fillcap_4
X_2558_ _2558_/D _2558_/RN clkload0/I _2558_/Q VDD VDD VSS VSS gf180mcu_fd_sc_mcu7t5v0__dffrnq_1
XTAP_TAPCELL_ROW_93_1373 VDD VSS gf180mcu_fd_sc_mcu7t5v0__filltie
XTAP_TAPCELL_ROW_7_339 VDD VSS gf180mcu_fd_sc_mcu7t5v0__filltie
X_2489_ _2491_/A1 _2773_/I _2497_/B VDD VDD VSS VSS gf180mcu_fd_sc_mcu7t5v0__nor2_1
X_1509_ _1509_/I _1510_/B1 VDD VDD VSS VSS gf180mcu_fd_sc_mcu7t5v0__clkinv_1
XFILLER_68_560 VDD VDD VSS VSS gf180mcu_fd_sc_mcu7t5v0__fillcap_4
XFILLER_68_593 VDD VDD VSS VSS gf180mcu_fd_sc_mcu7t5v0__fill_2
XFILLER_28_457 VDD VDD VSS VSS gf180mcu_fd_sc_mcu7t5v0__fill_2
XFILLER_55_243 VDD VDD VSS VSS gf180mcu_fd_sc_mcu7t5v0__fill_2
XPHY_EDGE_ROW_106_Right_106 VDD VSS gf180mcu_fd_sc_mcu7t5v0__endcap
XFILLER_102_10 VDD VDD VSS VSS gf180mcu_fd_sc_mcu7t5v0__fill_1
XTAP_TAPCELL_ROW_54_901 VDD VSS gf180mcu_fd_sc_mcu7t5v0__filltie
XTAP_TAPCELL_ROW_102_1480 VDD VSS gf180mcu_fd_sc_mcu7t5v0__filltie
XFILLER_8_807 VDD VDD VSS VSS gf180mcu_fd_sc_mcu7t5v0__fillcap_16
XFILLER_2_2 VDD VDD VSS VSS gf180mcu_fd_sc_mcu7t5v0__fillcap_32
XFILLER_79_858 VDD VDD VSS VSS gf180mcu_fd_sc_mcu7t5v0__fillcap_8
XFILLER_78_313 VDD VDD VSS VSS gf180mcu_fd_sc_mcu7t5v0__fill_2
XFILLER_19_402 VDD VDD VSS VSS gf180mcu_fd_sc_mcu7t5v0__fillcap_16
XFILLER_34_427 VDD VDD VSS VSS gf180mcu_fd_sc_mcu7t5v0__fillcap_16
XFILLER_46_287 VDD VDD VSS VSS gf180mcu_fd_sc_mcu7t5v0__fillcap_4
XFILLER_15_696 VDD VDD VSS VSS gf180mcu_fd_sc_mcu7t5v0__fillcap_4
XTAP_TAPCELL_ROW_32_639 VDD VSS gf180mcu_fd_sc_mcu7t5v0__filltie
X_1860_ _1860_/A1 _2534_/A2 _2537_/A2 _1860_/B2 _1861_/I VDD VDD VSS VSS gf180mcu_fd_sc_mcu7t5v0__aoi22_1
Xinput12 tl_d_dmem_i[19] input12/Z VDD VDD VSS VSS gf180mcu_fd_sc_mcu7t5v0__dlyd_1
X_1791_ _1791_/I _1791_/ZN VDD VDD VSS VSS gf180mcu_fd_sc_mcu7t5v0__clkinv_1
Xinput23 tl_d_dmem_i[29] input23/Z VDD VDD VSS VSS gf180mcu_fd_sc_mcu7t5v0__dlyd_1
Xinput34 tl_d_dmem_i[39] input34/Z VDD VDD VSS VSS gf180mcu_fd_sc_mcu7t5v0__dlyd_1
Xinput45 tl_d_dmem_i[49] input45/Z VDD VDD VSS VSS gf180mcu_fd_sc_mcu7t5v0__dlyd_1
XTAP_TAPCELL_ROW_12_396 VDD VSS gf180mcu_fd_sc_mcu7t5v0__filltie
Xinput56 tl_d_dmem_i[59] input56/Z VDD VDD VSS VSS gf180mcu_fd_sc_mcu7t5v0__dlyd_1
Xinput67 tl_d_dmem_i[9] input67/Z VDD VDD VSS VSS gf180mcu_fd_sc_mcu7t5v0__dlyd_1
Xinput78 tl_d_esram_i[19] input78/Z VDD VDD VSS VSS gf180mcu_fd_sc_mcu7t5v0__dlyd_1
Xinput89 tl_d_esram_i[29] input89/Z VDD VDD VSS VSS gf180mcu_fd_sc_mcu7t5v0__dlyd_1
XTAP_TAPCELL_ROW_116_1649 VDD VSS gf180mcu_fd_sc_mcu7t5v0__filltie
X_2412_ _2561_/Q _2434_/B _2422_/A1 VDD VDD VSS VSS gf180mcu_fd_sc_mcu7t5v0__nand2_1
X_2343_ input99/Z _2343_/A2 _2379_/A3 _2344_/A2 VDD VDD VSS VSS gf180mcu_fd_sc_mcu7t5v0__nand3_1
XFILLER_57_508 VDD VDD VSS VSS gf180mcu_fd_sc_mcu7t5v0__fillcap_32
XTAP_TAPCELL_ROW_4_309 VDD VSS gf180mcu_fd_sc_mcu7t5v0__filltie
X_2274_ _2282_/A1 _2274_/A2 _2276_/A1 VDD VDD VSS VSS gf180mcu_fd_sc_mcu7t5v0__nand2_1
XFILLER_84_305 VDD VDD VSS VSS gf180mcu_fd_sc_mcu7t5v0__fill_1
X_1225_ _1228_/B2 _1225_/A2 _2102_/B2 _1225_/B _2776_/I VDD VDD VSS VSS gf180mcu_fd_sc_mcu7t5v0__oai31_2
X_1156_ _1151_/Z _1152_/Z _1153_/Z _1156_/B _1221_/A2 VDD VDD VSS VSS gf180mcu_fd_sc_mcu7t5v0__oai31_1
XFILLER_92_360 VDD VDD VSS VSS gf180mcu_fd_sc_mcu7t5v0__fill_2
XFILLER_92_393 VDD VDD VSS VSS gf180mcu_fd_sc_mcu7t5v0__fill_1
X_1087_ _1087_/I _2068_/A1 VDD VDD VSS VSS gf180mcu_fd_sc_mcu7t5v0__clkinv_1
X_1989_ _1989_/I _1989_/ZN VDD VDD VSS VSS gf180mcu_fd_sc_mcu7t5v0__clkinv_1
XTAP_TAPCELL_ROW_95_1402 VDD VSS gf180mcu_fd_sc_mcu7t5v0__filltie
XFILLER_102_432 VDD VDD VSS VSS gf180mcu_fd_sc_mcu7t5v0__fillcap_4
XFILLER_102_443 VDD VDD VSS VSS gf180mcu_fd_sc_mcu7t5v0__fillcap_8
Xinput405 tl_h_i_i[1] _1856_/A1 VDD VDD VSS VSS gf180mcu_fd_sc_mcu7t5v0__dlyd_1
Xinput416 tl_h_i_i[2] _1858_/A1 VDD VDD VSS VSS gf180mcu_fd_sc_mcu7t5v0__dlyd_1
Xinput427 tl_h_i_i[3] _1860_/A1 VDD VDD VSS VSS gf180mcu_fd_sc_mcu7t5v0__dlyd_1
XFILLER_102_465 VDD VDD VSS VSS gf180mcu_fd_sc_mcu7t5v0__fill_1
Xinput438 tl_h_i_i[4] _1862_/A1 VDD VDD VSS VSS gf180mcu_fd_sc_mcu7t5v0__dlyd_1
Xinput449 tl_h_i_i[5] _1864_/A1 VDD VDD VSS VSS gf180mcu_fd_sc_mcu7t5v0__dlyd_1
XFILLER_88_699 VDD VDD VSS VSS gf180mcu_fd_sc_mcu7t5v0__fillcap_4
XFILLER_87_165 VDD VDD VSS VSS gf180mcu_fd_sc_mcu7t5v0__fill_2
XFILLER_28_232 VDD VDD VSS VSS gf180mcu_fd_sc_mcu7t5v0__fill_2
XFILLER_56_541 VDD VDD VSS VSS gf180mcu_fd_sc_mcu7t5v0__fillcap_8
XFILLER_29_766 VDD VDD VSS VSS gf180mcu_fd_sc_mcu7t5v0__fillcap_4
XFILLER_71_500 VDD VDD VSS VSS gf180mcu_fd_sc_mcu7t5v0__fillcap_4
XFILLER_44_769 VDD VDD VSS VSS gf180mcu_fd_sc_mcu7t5v0__fill_2
XFILLER_31_419 VDD VDD VSS VSS gf180mcu_fd_sc_mcu7t5v0__fill_1
XFILLER_98_419 VDD VDD VSS VSS gf180mcu_fd_sc_mcu7t5v0__fillcap_8
Xfanout1110 _1535_/A2 _1534_/A2 VDD VDD VSS VSS gf180mcu_fd_sc_mcu7t5v0__dlyd_1
Xfanout1132 _2533_/A2 _1812_/B1 VDD VDD VSS VSS gf180mcu_fd_sc_mcu7t5v0__dlyd_1
XFILLER_78_132 VDD VDD VSS VSS gf180mcu_fd_sc_mcu7t5v0__fillcap_16
Xfanout1154 _1114_/Z _2157_/B VDD VDD VSS VSS gf180mcu_fd_sc_mcu7t5v0__dlyd_1
Xfanout1165 _1110_/ZN _2218_/A2 VDD VDD VSS VSS gf180mcu_fd_sc_mcu7t5v0__dlyd_1
XFILLER_78_154 VDD VDD VSS VSS gf180mcu_fd_sc_mcu7t5v0__fill_1
Xfanout1176 _1105_/Z wire1177/I VDD VDD VSS VSS gf180mcu_fd_sc_mcu7t5v0__dlyd_1
Xfanout1198 _2246_/C _2230_/B VDD VDD VSS VSS gf180mcu_fd_sc_mcu7t5v0__dlyd_1
XFILLER_90_831 VDD VDD VSS VSS gf180mcu_fd_sc_mcu7t5v0__fill_1
XTAP_TAPCELL_ROW_66_1047 VDD VSS gf180mcu_fd_sc_mcu7t5v0__filltie
XTAP_TAPCELL_ROW_17_455 VDD VSS gf180mcu_fd_sc_mcu7t5v0__filltie
XFILLER_34_279 VDD VDD VSS VSS gf180mcu_fd_sc_mcu7t5v0__fillcap_16
XTAP_TAPCELL_ROW_45_797 VDD VSS gf180mcu_fd_sc_mcu7t5v0__filltie
XTAP_TAPCELL_ROW_17_466 VDD VSS gf180mcu_fd_sc_mcu7t5v0__filltie
X_1912_ _1912_/A1 _1912_/A2 _1958_/B1 _1912_/B2 _1913_/I VDD VDD VSS VSS gf180mcu_fd_sc_mcu7t5v0__aoi22_1
X_1843_ _1843_/I _1843_/ZN VDD VDD VSS VSS gf180mcu_fd_sc_mcu7t5v0__clkinv_1
X_1774_ _1964_/A1 _1826_/A2 _1814_/B1 _1964_/B2 _1775_/I VDD VDD VSS VSS gf180mcu_fd_sc_mcu7t5v0__aoi22_1
XTAP_TAPCELL_ROW_77_1176 VDD VSS gf180mcu_fd_sc_mcu7t5v0__filltie
XTAP_TAPCELL_ROW_90_1332 VDD VSS gf180mcu_fd_sc_mcu7t5v0__filltie
XFILLER_97_430 VDD VDD VSS VSS gf180mcu_fd_sc_mcu7t5v0__fillcap_4
X_2326_ _2374_/A1 _2326_/A2 _2328_/A1 VDD VDD VSS VSS gf180mcu_fd_sc_mcu7t5v0__nand2_1
XFILLER_57_338 VDD VDD VSS VSS gf180mcu_fd_sc_mcu7t5v0__fillcap_8
X_2257_ _2277_/A1 _2257_/A2 _2258_/A2 VDD VDD VSS VSS gf180mcu_fd_sc_mcu7t5v0__nand2_1
XFILLER_38_563 VDD VDD VSS VSS gf180mcu_fd_sc_mcu7t5v0__fillcap_32
X_1208_ _2548_/Q _2383_/A1 _2531_/A2 _1208_/B2 _1208_/C _1209_/A3 VDD VDD VSS VSS
+ gf180mcu_fd_sc_mcu7t5v0__oai221_1
X_2188_ _2582_/Q _2140_/B _2189_/A3 VDD VDD VSS VSS gf180mcu_fd_sc_mcu7t5v0__nand2_1
XFILLER_81_842 VDD VDD VSS VSS gf180mcu_fd_sc_mcu7t5v0__fillcap_4
X_1139_ _2740_/I _2741_/I _1143_/A3 _1143_/A4 _1146_/A2 VDD VDD VSS VSS gf180mcu_fd_sc_mcu7t5v0__nand4_1
XPHY_EDGE_ROW_40_Left_159 VDD VSS gf180mcu_fd_sc_mcu7t5v0__endcap
XFILLER_81_864 VDD VDD VSS VSS gf180mcu_fd_sc_mcu7t5v0__fill_2
XFILLER_25_268 VDD VDD VSS VSS gf180mcu_fd_sc_mcu7t5v0__fill_2
XFILLER_25_279 VDD VDD VSS VSS gf180mcu_fd_sc_mcu7t5v0__fill_1
XFILLER_53_588 VDD VDD VSS VSS gf180mcu_fd_sc_mcu7t5v0__fillcap_32
XFILLER_0_334 VDD VDD VSS VSS gf180mcu_fd_sc_mcu7t5v0__fillcap_4
Xinput202 tl_d_uart_i[11] _1093_/I VDD VDD VSS VSS gf180mcu_fd_sc_mcu7t5v0__dlyd_1
XFILLER_88_452 VDD VDD VSS VSS gf180mcu_fd_sc_mcu7t5v0__fill_2
Xinput213 tl_d_uart_i[21] _1302_/A1 VDD VDD VSS VSS gf180mcu_fd_sc_mcu7t5v0__dlyd_1
Xinput224 tl_d_uart_i[31] _1382_/A1 VDD VDD VSS VSS gf180mcu_fd_sc_mcu7t5v0__dlyd_1
Xinput235 tl_d_uart_i[41] _1462_/A1 VDD VDD VSS VSS gf180mcu_fd_sc_mcu7t5v0__dlyd_1
XFILLER_88_474 VDD VDD VSS VSS gf180mcu_fd_sc_mcu7t5v0__fillcap_16
XFILLER_68_79 VDD VDD VSS VSS gf180mcu_fd_sc_mcu7t5v0__fillcap_4
XFILLER_48_349 VDD VDD VSS VSS gf180mcu_fd_sc_mcu7t5v0__fillcap_16
Xinput246 tl_d_uart_i[51] _1098_/I VDD VDD VSS VSS gf180mcu_fd_sc_mcu7t5v0__dlyd_1
Xinput257 tl_d_uart_i[61] _2245_/A1 VDD VDD VSS VSS gf180mcu_fd_sc_mcu7t5v0__dlyd_1
Xinput268 tl_h_d_i[101] _2760_/I VDD VDD VSS VSS gf180mcu_fd_sc_mcu7t5v0__dlyd_1
Xinput279 tl_h_d_i[111] _2770_/I VDD VDD VSS VSS gf180mcu_fd_sc_mcu7t5v0__clkbuf_2
XFILLER_72_831 VDD VDD VSS VSS gf180mcu_fd_sc_mcu7t5v0__fill_1
XFILLER_71_352 VDD VDD VSS VSS gf180mcu_fd_sc_mcu7t5v0__fillcap_32
XFILLER_31_249 VDD VDD VSS VSS gf180mcu_fd_sc_mcu7t5v0__fillcap_16
XTAP_TAPCELL_ROW_42_756 VDD VSS gf180mcu_fd_sc_mcu7t5v0__filltie
XTAP_TAPCELL_ROW_14_425 VDD VSS gf180mcu_fd_sc_mcu7t5v0__filltie
XFILLER_71_396 VDD VDD VSS VSS gf180mcu_fd_sc_mcu7t5v0__fillcap_16
Xoutput709 _1833_/ZN tl_d_rom_o[101] VDD VDD VSS VSS gf180mcu_fd_sc_mcu7t5v0__dlyd_1
XTAP_TAPCELL_ROW_113_1608 VDD VSS gf180mcu_fd_sc_mcu7t5v0__filltie
X_1490_ _2371_/A1 _1490_/A2 _2375_/A3 _1491_/B VDD VDD VSS VSS gf180mcu_fd_sc_mcu7t5v0__nand3_1
X_2111_ _2111_/I _2111_/ZN VDD VDD VSS VSS gf180mcu_fd_sc_mcu7t5v0__clkinv_1
XFILLER_54_308 VDD VDD VSS VSS gf180mcu_fd_sc_mcu7t5v0__fillcap_4
X_2042_ _2390_/I0 _2044_/A2 _2044_/B1 _2770_/I _2043_/I VDD VDD VSS VSS gf180mcu_fd_sc_mcu7t5v0__aoi22_1
XFILLER_82_617 VDD VDD VSS VSS gf180mcu_fd_sc_mcu7t5v0__fill_1
XFILLER_62_341 VDD VDD VSS VSS gf180mcu_fd_sc_mcu7t5v0__fill_1
XFILLER_63_842 VDD VDD VSS VSS gf180mcu_fd_sc_mcu7t5v0__fillcap_16
XPHY_EDGE_ROW_8_Right_8 VDD VSS gf180mcu_fd_sc_mcu7t5v0__endcap
XFILLER_90_683 VDD VDD VSS VSS gf180mcu_fd_sc_mcu7t5v0__fill_1
XFILLER_15_290 VDD VDD VSS VSS gf180mcu_fd_sc_mcu7t5v0__fillcap_8
XFILLER_30_282 VDD VDD VSS VSS gf180mcu_fd_sc_mcu7t5v0__fillcap_16
XTAP_TAPCELL_ROW_79_1205 VDD VSS gf180mcu_fd_sc_mcu7t5v0__filltie
X_1826_ _2395_/I0 _1826_/A2 _2533_/A2 _2756_/I _1827_/I VDD VDD VSS VSS gf180mcu_fd_sc_mcu7t5v0__aoi22_1
X_1757_ _1757_/I _1757_/ZN VDD VDD VSS VSS gf180mcu_fd_sc_mcu7t5v0__clkinv_1
X_1688_ _1878_/A1 _1722_/A2 _1722_/B1 _1878_/B2 _1689_/I VDD VDD VSS VSS gf180mcu_fd_sc_mcu7t5v0__aoi22_1
XPHY_EDGE_ROW_39_Right_39 VDD VSS gf180mcu_fd_sc_mcu7t5v0__endcap
XFILLER_38_16 VDD VDD VSS VSS gf180mcu_fd_sc_mcu7t5v0__fill_1
X_2309_ _2345_/A1 _2309_/A2 _2310_/A2 VDD VDD VSS VSS gf180mcu_fd_sc_mcu7t5v0__nand2_1
XFILLER_97_282 VDD VDD VSS VSS gf180mcu_fd_sc_mcu7t5v0__fill_2
XFILLER_85_422 VDD VDD VSS VSS gf180mcu_fd_sc_mcu7t5v0__fillcap_32
XFILLER_73_617 VDD VDD VSS VSS gf180mcu_fd_sc_mcu7t5v0__fillcap_8
XFILLER_26_522 VDD VDD VSS VSS gf180mcu_fd_sc_mcu7t5v0__fill_2
XFILLER_54_831 VDD VDD VSS VSS gf180mcu_fd_sc_mcu7t5v0__fill_1
XFILLER_53_352 VDD VDD VSS VSS gf180mcu_fd_sc_mcu7t5v0__fillcap_64
XFILLER_81_672 VDD VDD VSS VSS gf180mcu_fd_sc_mcu7t5v0__fill_1
XFILLER_41_558 VDD VDD VSS VSS gf180mcu_fd_sc_mcu7t5v0__fill_2
XPHY_EDGE_ROW_48_Right_48 VDD VSS gf180mcu_fd_sc_mcu7t5v0__endcap
XFILLER_81_694 VDD VDD VSS VSS gf180mcu_fd_sc_mcu7t5v0__fillcap_4
XFILLER_21_282 VDD VDD VSS VSS gf180mcu_fd_sc_mcu7t5v0__fillcap_4
XFILLER_107_387 VDD VDD VSS VSS gf180mcu_fd_sc_mcu7t5v0__fillcap_16
XPHY_EDGE_ROW_57_Right_57 VDD VSS gf180mcu_fd_sc_mcu7t5v0__endcap
XFILLER_49_625 VDD VDD VSS VSS gf180mcu_fd_sc_mcu7t5v0__fillcap_4
XFILLER_49_636 VDD VDD VSS VSS gf180mcu_fd_sc_mcu7t5v0__fill_2
XFILLER_64_617 VDD VDD VSS VSS gf180mcu_fd_sc_mcu7t5v0__fill_2
XFILLER_29_360 VDD VDD VSS VSS gf180mcu_fd_sc_mcu7t5v0__fill_2
XFILLER_29_382 VDD VDD VSS VSS gf180mcu_fd_sc_mcu7t5v0__fillcap_4
Xload_slew1120 _1396_/A2 _1348_/A2 VDD VDD VSS VSS gf180mcu_fd_sc_mcu7t5v0__buf_4
Xload_slew1131 _1736_/B1 _1720_/B1 VDD VDD VSS VSS gf180mcu_fd_sc_mcu7t5v0__clkbuf_4
XTAP_TAPCELL_ROW_47_826 VDD VSS gf180mcu_fd_sc_mcu7t5v0__filltie
XTAP_TAPCELL_ROW_47_815 VDD VSS gf180mcu_fd_sc_mcu7t5v0__filltie
XFILLER_45_842 VDD VDD VSS VSS gf180mcu_fd_sc_mcu7t5v0__fill_2
XFILLER_45_864 VDD VDD VSS VSS gf180mcu_fd_sc_mcu7t5v0__fill_2
Xload_slew1164 _2233_/A2 _1441_/A1 VDD VDD VSS VSS gf180mcu_fd_sc_mcu7t5v0__buf_4
Xload_slew1175 _2231_/C _2224_/C VDD VDD VSS VSS gf180mcu_fd_sc_mcu7t5v0__buf_4
XFILLER_60_801 VDD VDD VSS VSS gf180mcu_fd_sc_mcu7t5v0__fillcap_4
XFILLER_60_823 VDD VDD VSS VSS gf180mcu_fd_sc_mcu7t5v0__fillcap_8
Xload_slew1197 _2202_/B _2215_/B VDD VDD VSS VSS gf180mcu_fd_sc_mcu7t5v0__buf_3
XTAP_TAPCELL_ROW_63_1017 VDD VSS gf180mcu_fd_sc_mcu7t5v0__filltie
XPHY_EDGE_ROW_66_Right_66 VDD VSS gf180mcu_fd_sc_mcu7t5v0__endcap
XFILLER_71_160 VDD VDD VSS VSS gf180mcu_fd_sc_mcu7t5v0__fillcap_16
XTAP_TAPCELL_ROW_27_583 VDD VSS gf180mcu_fd_sc_mcu7t5v0__filltie
XFILLER_71_182 VDD VDD VSS VSS gf180mcu_fd_sc_mcu7t5v0__fill_1
XFILLER_40_591 VDD VDD VSS VSS gf180mcu_fd_sc_mcu7t5v0__fillcap_4
X_2660_ _2732_/I _2660_/Z VDD VDD VSS VSS gf180mcu_fd_sc_mcu7t5v0__buf_1
X_1611_ _2747_/I _2741_/I _1611_/Z VDD VDD VSS VSS gf180mcu_fd_sc_mcu7t5v0__xor2_1
X_2591_ _2591_/D _2597_/RN clkload6/I _2591_/Q VDD VDD VSS VSS gf180mcu_fd_sc_mcu7t5v0__dffrnq_1
Xoutput506 _2697_/Z tl_d_dmem_o[110] VDD VDD VSS VSS gf180mcu_fd_sc_mcu7t5v0__dlyd_1
Xoutput517 _2637_/Z tl_d_dmem_o[18] VDD VDD VSS VSS gf180mcu_fd_sc_mcu7t5v0__dlyd_1
XPHY_EDGE_ROW_75_Right_75 VDD VSS gf180mcu_fd_sc_mcu7t5v0__endcap
Xoutput528 _2647_/Z tl_d_dmem_o[28] VDD VDD VSS VSS gf180mcu_fd_sc_mcu7t5v0__dlyd_1
Xoutput539 _1521_/Z tl_d_dmem_o[38] VDD VDD VSS VSS gf180mcu_fd_sc_mcu7t5v0__dlyd_1
X_1542_ _1972_/B2 _1619_/S _1542_/Z VDD VDD VSS VSS gf180mcu_fd_sc_mcu7t5v0__or2_1
XTAP_TAPCELL_ROW_74_1146 VDD VSS gf180mcu_fd_sc_mcu7t5v0__filltie
X_1473_ _2199_/A2 _2361_/A2 _1473_/Z VDD VDD VSS VSS gf180mcu_fd_sc_mcu7t5v0__and2_1
XPHY_EDGE_ROW_105_Left_224 VDD VSS gf180mcu_fd_sc_mcu7t5v0__endcap
XFILLER_79_260 VDD VDD VSS VSS gf180mcu_fd_sc_mcu7t5v0__fill_2
XFILLER_67_422 VDD VDD VSS VSS gf180mcu_fd_sc_mcu7t5v0__fillcap_8
XFILLER_39_146 VDD VDD VSS VSS gf180mcu_fd_sc_mcu7t5v0__fill_2
XFILLER_55_606 VDD VDD VSS VSS gf180mcu_fd_sc_mcu7t5v0__fill_1
XFILLER_36_831 VDD VDD VSS VSS gf180mcu_fd_sc_mcu7t5v0__fill_1
XPHY_EDGE_ROW_84_Right_84 VDD VSS gf180mcu_fd_sc_mcu7t5v0__endcap
XFILLER_82_403 VDD VDD VSS VSS gf180mcu_fd_sc_mcu7t5v0__fillcap_4
X_2025_ _2025_/I _2025_/ZN VDD VDD VSS VSS gf180mcu_fd_sc_mcu7t5v0__clkinv_1
XFILLER_35_352 VDD VDD VSS VSS gf180mcu_fd_sc_mcu7t5v0__fillcap_64
XTAP_TAPCELL_ROW_85_1275 VDD VSS gf180mcu_fd_sc_mcu7t5v0__filltie
XFILLER_50_311 VDD VDD VSS VSS gf180mcu_fd_sc_mcu7t5v0__fillcap_4
XFILLER_62_171 VDD VDD VSS VSS gf180mcu_fd_sc_mcu7t5v0__fillcap_4
XFILLER_62_193 VDD VDD VSS VSS gf180mcu_fd_sc_mcu7t5v0__fillcap_8
XPHY_EDGE_ROW_114_Left_233 VDD VSS gf180mcu_fd_sc_mcu7t5v0__endcap
XPHY_EDGE_ROW_93_Right_93 VDD VSS gf180mcu_fd_sc_mcu7t5v0__endcap
X_1809_ _1809_/I _1809_/ZN VDD VDD VSS VSS gf180mcu_fd_sc_mcu7t5v0__clkinv_1
XFILLER_86_753 VDD VDD VSS VSS gf180mcu_fd_sc_mcu7t5v0__fillcap_8
XFILLER_58_477 VDD VDD VSS VSS gf180mcu_fd_sc_mcu7t5v0__fill_2
XFILLER_27_842 VDD VDD VSS VSS gf180mcu_fd_sc_mcu7t5v0__fillcap_16
XFILLER_42_801 VDD VDD VSS VSS gf180mcu_fd_sc_mcu7t5v0__fillcap_4
XFILLER_42_823 VDD VDD VSS VSS gf180mcu_fd_sc_mcu7t5v0__fillcap_8
XFILLER_41_322 VDD VDD VSS VSS gf180mcu_fd_sc_mcu7t5v0__fill_1
XTAP_TAPCELL_ROW_24_542 VDD VSS gf180mcu_fd_sc_mcu7t5v0__filltie
XTAP_TAPCELL_ROW_52_884 VDD VSS gf180mcu_fd_sc_mcu7t5v0__filltie
XFILLER_22_591 VDD VDD VSS VSS gf180mcu_fd_sc_mcu7t5v0__fillcap_4
XFILLER_107_195 VDD VDD VSS VSS gf180mcu_fd_sc_mcu7t5v0__fill_1
XFILLER_49_422 VDD VDD VSS VSS gf180mcu_fd_sc_mcu7t5v0__fillcap_8
XFILLER_76_241 VDD VDD VSS VSS gf180mcu_fd_sc_mcu7t5v0__fillcap_4
XFILLER_64_425 VDD VDD VSS VSS gf180mcu_fd_sc_mcu7t5v0__fillcap_16
XFILLER_92_712 VDD VDD VSS VSS gf180mcu_fd_sc_mcu7t5v0__fillcap_8
XFILLER_76_263 VDD VDD VSS VSS gf180mcu_fd_sc_mcu7t5v0__fillcap_4
XFILLER_18_831 VDD VDD VSS VSS gf180mcu_fd_sc_mcu7t5v0__fill_1
XFILLER_17_352 VDD VDD VSS VSS gf180mcu_fd_sc_mcu7t5v0__fillcap_64
XFILLER_91_255 VDD VDD VSS VSS gf180mcu_fd_sc_mcu7t5v0__fillcap_16
X_2712_ _2712_/I _2712_/Z VDD VDD VSS VSS gf180mcu_fd_sc_mcu7t5v0__buf_1
XFILLER_9_562 VDD VDD VSS VSS gf180mcu_fd_sc_mcu7t5v0__fillcap_8
X_2643_ _2715_/I _2643_/Z VDD VDD VSS VSS gf180mcu_fd_sc_mcu7t5v0__buf_1
X_2574_ _2574_/D _2601_/RN clkload5/I _2574_/Q VDD VDD VSS VSS gf180mcu_fd_sc_mcu7t5v0__dffsnq_1
X_1525_ _1938_/B2 _1533_/A2 _1525_/Z VDD VDD VSS VSS gf180mcu_fd_sc_mcu7t5v0__or2_1
X_1456_ _1456_/A1 _1496_/A2 _2353_/A2 VDD VDD VSS VSS gf180mcu_fd_sc_mcu7t5v0__nand2_1
X_1387_ _1499_/A1 _1385_/Z _1387_/B _1388_/B1 VDD VDD VSS VSS gf180mcu_fd_sc_mcu7t5v0__oai21_1
XFILLER_55_414 VDD VDD VSS VSS gf180mcu_fd_sc_mcu7t5v0__fillcap_4
XTAP_TAPCELL_ROW_87_1304 VDD VSS gf180mcu_fd_sc_mcu7t5v0__filltie
XFILLER_82_244 VDD VDD VSS VSS gf180mcu_fd_sc_mcu7t5v0__fill_1
XFILLER_43_609 VDD VDD VSS VSS gf180mcu_fd_sc_mcu7t5v0__fillcap_16
XFILLER_24_823 VDD VDD VSS VSS gf180mcu_fd_sc_mcu7t5v0__fillcap_8
XFILLER_63_480 VDD VDD VSS VSS gf180mcu_fd_sc_mcu7t5v0__fillcap_8
X_2008_ _2008_/A1 _2044_/A2 _2038_/B1 _2736_/I _2009_/I VDD VDD VSS VSS gf180mcu_fd_sc_mcu7t5v0__aoi22_1
XFILLER_35_193 VDD VDD VSS VSS gf180mcu_fd_sc_mcu7t5v0__fillcap_4
XFILLER_50_130 VDD VDD VSS VSS gf180mcu_fd_sc_mcu7t5v0__fill_1
XTAP_TAPCELL_ROW_21_512 VDD VSS gf180mcu_fd_sc_mcu7t5v0__filltie
XFILLER_109_427 VDD VDD VSS VSS gf180mcu_fd_sc_mcu7t5v0__fill_2
XTAP_TAPCELL_ROW_98_1433 VDD VSS gf180mcu_fd_sc_mcu7t5v0__filltie
Xoutput881 _2725_/Z tl_d_uart_o[66] VDD VDD VSS VSS gf180mcu_fd_sc_mcu7t5v0__dlyd_1
Xoutput870 _1647_/Z tl_d_uart_o[56] VDD VDD VSS VSS gf180mcu_fd_sc_mcu7t5v0__dlyd_1
Xoutput892 _2735_/Z tl_d_uart_o[76] VDD VDD VSS VSS gf180mcu_fd_sc_mcu7t5v0__dlyd_1
XFILLER_59_742 VDD VDD VSS VSS gf180mcu_fd_sc_mcu7t5v0__fillcap_16
XFILLER_58_263 VDD VDD VSS VSS gf180mcu_fd_sc_mcu7t5v0__fillcap_4
XTAP_TAPCELL_ROW_29_601 VDD VSS gf180mcu_fd_sc_mcu7t5v0__filltie
XFILLER_74_734 VDD VDD VSS VSS gf180mcu_fd_sc_mcu7t5v0__fill_1
XFILLER_100_382 VDD VDD VSS VSS gf180mcu_fd_sc_mcu7t5v0__fill_2
XTAP_TAPCELL_ROW_57_943 VDD VSS gf180mcu_fd_sc_mcu7t5v0__filltie
XFILLER_34_609 VDD VDD VSS VSS gf180mcu_fd_sc_mcu7t5v0__fillcap_32
XTAP_TAPCELL_ROW_1_270 VDD VSS gf180mcu_fd_sc_mcu7t5v0__filltie
XTAP_TAPCELL_ROW_107_1540 VDD VSS gf180mcu_fd_sc_mcu7t5v0__filltie
XFILLER_92_34 VDD VDD VSS VSS gf180mcu_fd_sc_mcu7t5v0__fill_1
XFILLER_73_255 VDD VDD VSS VSS gf180mcu_fd_sc_mcu7t5v0__fill_2
XFILLER_14_333 VDD VDD VSS VSS gf180mcu_fd_sc_mcu7t5v0__fillcap_8
XFILLER_42_642 VDD VDD VSS VSS gf180mcu_fd_sc_mcu7t5v0__fillcap_16
XFILLER_42_664 VDD VDD VSS VSS gf180mcu_fd_sc_mcu7t5v0__fill_1
XTAP_TAPCELL_ROW_118_1680 VDD VSS gf180mcu_fd_sc_mcu7t5v0__filltie
Xoutput1008 _2312_/ZN tl_h_i_o[30] VDD VDD VSS VSS gf180mcu_fd_sc_mcu7t5v0__dlyd_1
Xoutput1019 _2352_/ZN tl_h_i_o[40] VDD VDD VSS VSS gf180mcu_fd_sc_mcu7t5v0__dlyd_1
XTAP_TAPCELL_ROW_118_1691 VDD VSS gf180mcu_fd_sc_mcu7t5v0__filltie
XTAP_TAPCELL_ROW_9_370 VDD VSS gf180mcu_fd_sc_mcu7t5v0__filltie
XTAP_TAPCELL_ROW_71_1105 VDD VSS gf180mcu_fd_sc_mcu7t5v0__filltie
X_2290_ _2302_/A1 _2290_/A2 _2292_/A1 VDD VDD VSS VSS gf180mcu_fd_sc_mcu7t5v0__nand2_1
X_1310_ _1310_/A1 _1406_/A2 _1310_/B1 _2146_/C _1311_/A2 VDD VDD VSS VSS gf180mcu_fd_sc_mcu7t5v0__aoi22_1
XFILLER_96_314 VDD VDD VSS VSS gf180mcu_fd_sc_mcu7t5v0__fill_1
X_1241_ _1241_/A1 _1249_/A2 _1241_/B _1246_/B VDD VDD VSS VSS gf180mcu_fd_sc_mcu7t5v0__oai21_1
XFILLER_37_403 VDD VDD VSS VSS gf180mcu_fd_sc_mcu7t5v0__fillcap_16
X_1172_ _1066_/I _1174_/A3 _1166_/Z _1175_/A2 VDD VDD VSS VSS gf180mcu_fd_sc_mcu7t5v0__nand3_1
XFILLER_37_458 VDD VDD VSS VSS gf180mcu_fd_sc_mcu7t5v0__fill_1
XFILLER_64_222 VDD VDD VSS VSS gf180mcu_fd_sc_mcu7t5v0__fillcap_16
XFILLER_65_734 VDD VDD VSS VSS gf180mcu_fd_sc_mcu7t5v0__fillcap_4
XFILLER_65_745 VDD VDD VSS VSS gf180mcu_fd_sc_mcu7t5v0__fillcap_16
XFILLER_77_594 VDD VDD VSS VSS gf180mcu_fd_sc_mcu7t5v0__fillcap_16
XFILLER_18_661 VDD VDD VSS VSS gf180mcu_fd_sc_mcu7t5v0__fillcap_4
XFILLER_64_244 VDD VDD VSS VSS gf180mcu_fd_sc_mcu7t5v0__fill_1
XFILLER_92_575 VDD VDD VSS VSS gf180mcu_fd_sc_mcu7t5v0__fillcap_8
XFILLER_52_428 VDD VDD VSS VSS gf180mcu_fd_sc_mcu7t5v0__fillcap_16
XTAP_TAPCELL_ROW_69_1089 VDD VSS gf180mcu_fd_sc_mcu7t5v0__filltie
XFILLER_92_597 VDD VDD VSS VSS gf180mcu_fd_sc_mcu7t5v0__fillcap_4
XFILLER_80_737 VDD VDD VSS VSS gf180mcu_fd_sc_mcu7t5v0__fillcap_64
XTAP_TAPCELL_ROW_82_1245 VDD VSS gf180mcu_fd_sc_mcu7t5v0__filltie
XANTENNA_15 tl_h_i_i[12] VDD VDD VSS VSS gf180mcu_fd_sc_mcu7t5v0__antenna
XANTENNA_26 _2647_/Z VDD VDD VSS VSS gf180mcu_fd_sc_mcu7t5v0__antenna
XANTENNA_37 _2168_/ZN VDD VDD VSS VSS gf180mcu_fd_sc_mcu7t5v0__antenna
XFILLER_20_325 VDD VDD VSS VSS gf180mcu_fd_sc_mcu7t5v0__fillcap_4
X_2557_ _2557_/D _2588_/RN clkload4/I _2557_/Q VDD VDD VSS VSS gf180mcu_fd_sc_mcu7t5v0__dffrnq_1
XTAP_TAPCELL_ROW_93_1374 VDD VSS gf180mcu_fd_sc_mcu7t5v0__filltie
X_2488_ _2507_/B _2486_/Z _2488_/B _2590_/D VDD VDD VSS VSS gf180mcu_fd_sc_mcu7t5v0__oai21_1
X_1508_ input43/Z _1508_/A2 _1508_/B1 _1508_/B2 _1509_/I VDD VDD VSS VSS gf180mcu_fd_sc_mcu7t5v0__aoi22_1
X_1439_ _1503_/A1 _1439_/A2 _1439_/ZN VDD VDD VSS VSS gf180mcu_fd_sc_mcu7t5v0__nor2_1
XFILLER_87_347 VDD VDD VSS VSS gf180mcu_fd_sc_mcu7t5v0__fill_2
XTAP_TAPCELL_ROW_54_902 VDD VSS gf180mcu_fd_sc_mcu7t5v0__filltie
XFILLER_36_480 VDD VDD VSS VSS gf180mcu_fd_sc_mcu7t5v0__fillcap_4
XFILLER_62_26 VDD VDD VSS VSS gf180mcu_fd_sc_mcu7t5v0__fillcap_8
XFILLER_70_247 VDD VDD VSS VSS gf180mcu_fd_sc_mcu7t5v0__fillcap_64
XFILLER_11_314 VDD VDD VSS VSS gf180mcu_fd_sc_mcu7t5v0__fillcap_8
XTAP_TAPCELL_ROW_34_670 VDD VSS gf180mcu_fd_sc_mcu7t5v0__filltie
XTAP_TAPCELL_ROW_102_1481 VDD VSS gf180mcu_fd_sc_mcu7t5v0__filltie
XFILLER_78_325 VDD VDD VSS VSS gf180mcu_fd_sc_mcu7t5v0__fill_1
XFILLER_94_807 VDD VDD VSS VSS gf180mcu_fd_sc_mcu7t5v0__fillcap_16
XFILLER_78_369 VDD VDD VSS VSS gf180mcu_fd_sc_mcu7t5v0__fill_1
XFILLER_47_734 VDD VDD VSS VSS gf180mcu_fd_sc_mcu7t5v0__fillcap_8
XFILLER_62_737 VDD VDD VSS VSS gf180mcu_fd_sc_mcu7t5v0__fillcap_64
XFILLER_74_597 VDD VDD VSS VSS gf180mcu_fd_sc_mcu7t5v0__fillcap_64
XFILLER_61_269 VDD VDD VSS VSS gf180mcu_fd_sc_mcu7t5v0__fill_2
XFILLER_30_667 VDD VDD VSS VSS gf180mcu_fd_sc_mcu7t5v0__fillcap_64
Xinput13 tl_d_dmem_i[1] input13/Z VDD VDD VSS VSS gf180mcu_fd_sc_mcu7t5v0__dlyd_1
X_1790_ _1980_/A1 _1826_/A2 _1814_/B1 _2722_/I _1791_/I VDD VDD VSS VSS gf180mcu_fd_sc_mcu7t5v0__aoi22_1
Xinput24 tl_d_dmem_i[2] input24/Z VDD VDD VSS VSS gf180mcu_fd_sc_mcu7t5v0__dlyd_1
Xinput35 tl_d_dmem_i[3] input35/Z VDD VDD VSS VSS gf180mcu_fd_sc_mcu7t5v0__dlyd_1
Xinput46 tl_d_dmem_i[4] input46/Z VDD VDD VSS VSS gf180mcu_fd_sc_mcu7t5v0__dlyd_1
Xinput57 tl_d_dmem_i[5] input57/Z VDD VDD VSS VSS gf180mcu_fd_sc_mcu7t5v0__dlyd_1
Xinput68 tl_d_esram_i[0] _1077_/I VDD VDD VSS VSS gf180mcu_fd_sc_mcu7t5v0__dlyd_1
Xinput79 tl_d_esram_i[1] input79/Z VDD VDD VSS VSS gf180mcu_fd_sc_mcu7t5v0__dlyd_1
XTAP_TAPCELL_ROW_12_397 VDD VSS gf180mcu_fd_sc_mcu7t5v0__filltie
X_2411_ _2451_/B _2415_/A2 _2409_/Z _2411_/B _2560_/D VDD VDD VSS VSS gf180mcu_fd_sc_mcu7t5v0__oai31_1
XFILLER_111_422 VDD VDD VSS VSS gf180mcu_fd_sc_mcu7t5v0__fillcap_4
X_2342_ _2346_/A1 _2342_/A2 _2344_/A1 VDD VDD VSS VSS gf180mcu_fd_sc_mcu7t5v0__nand2_1
XFILLER_28_2 VDD VDD VSS VSS gf180mcu_fd_sc_mcu7t5v0__fillcap_16
X_2273_ _2293_/A1 _2273_/A2 _2274_/A2 VDD VDD VSS VSS gf180mcu_fd_sc_mcu7t5v0__nand2_1
X_1224_ _1066_/I _2548_/Q _2375_/A2 _1231_/A2 _1225_/B VDD VDD VSS VSS gf180mcu_fd_sc_mcu7t5v0__aoi22_1
X_1155_ _1144_/Z _1155_/A2 _1155_/B _1200_/C VDD VDD VSS VSS gf180mcu_fd_sc_mcu7t5v0__aoi21_1
X_1086_ _1086_/I _1657_/A1 VDD VDD VSS VSS gf180mcu_fd_sc_mcu7t5v0__clkinv_1
XFILLER_92_372 VDD VDD VSS VSS gf180mcu_fd_sc_mcu7t5v0__fillcap_8
XFILLER_52_247 VDD VDD VSS VSS gf180mcu_fd_sc_mcu7t5v0__fillcap_8
X_1988_ _1988_/A1 _2022_/A2 _1998_/B1 _2726_/I _1989_/I VDD VDD VSS VSS gf180mcu_fd_sc_mcu7t5v0__aoi22_1
XFILLER_48_509 VDD VDD VSS VSS gf180mcu_fd_sc_mcu7t5v0__fill_1
Xinput406 tl_h_i_i[20] _1894_/A1 VDD VDD VSS VSS gf180mcu_fd_sc_mcu7t5v0__dlyd_1
Xinput417 tl_h_i_i[30] _1914_/A1 VDD VDD VSS VSS gf180mcu_fd_sc_mcu7t5v0__dlyd_1
Xinput428 tl_h_i_i[40] _1934_/A1 VDD VDD VSS VSS gf180mcu_fd_sc_mcu7t5v0__dlyd_1
XFILLER_88_667 VDD VDD VSS VSS gf180mcu_fd_sc_mcu7t5v0__fillcap_32
XFILLER_76_807 VDD VDD VSS VSS gf180mcu_fd_sc_mcu7t5v0__fillcap_16
Xinput439 tl_h_i_i[50] _1954_/A1 VDD VDD VSS VSS gf180mcu_fd_sc_mcu7t5v0__dlyd_1
XFILLER_28_244 VDD VDD VSS VSS gf180mcu_fd_sc_mcu7t5v0__fill_1
XFILLER_44_737 VDD VDD VSS VSS gf180mcu_fd_sc_mcu7t5v0__fillcap_32
XFILLER_56_597 VDD VDD VSS VSS gf180mcu_fd_sc_mcu7t5v0__fillcap_16
XTAP_TAPCELL_ROW_104_1510 VDD VSS gf180mcu_fd_sc_mcu7t5v0__filltie
XFILLER_24_450 VDD VDD VSS VSS gf180mcu_fd_sc_mcu7t5v0__fillcap_4
XFILLER_24_472 VDD VDD VSS VSS gf180mcu_fd_sc_mcu7t5v0__fillcap_32
XFILLER_12_667 VDD VDD VSS VSS gf180mcu_fd_sc_mcu7t5v0__fillcap_64
Xfanout1122 _1248_/ZN _1398_/A2 VDD VDD VSS VSS gf180mcu_fd_sc_mcu7t5v0__dlyd_1
XFILLER_78_177 VDD VDD VSS VSS gf180mcu_fd_sc_mcu7t5v0__fill_1
Xfanout1166 _2199_/A2 _1489_/A1 VDD VDD VSS VSS gf180mcu_fd_sc_mcu7t5v0__dlyd_1
Xfanout1188 _1444_/B2 _2155_/B1 VDD VDD VSS VSS gf180mcu_fd_sc_mcu7t5v0__dlyd_1
XFILLER_47_586 VDD VDD VSS VSS gf180mcu_fd_sc_mcu7t5v0__fillcap_4
XFILLER_62_523 VDD VDD VSS VSS gf180mcu_fd_sc_mcu7t5v0__fill_2
XFILLER_34_247 VDD VDD VSS VSS gf180mcu_fd_sc_mcu7t5v0__fillcap_32
XTAP_TAPCELL_ROW_66_1048 VDD VSS gf180mcu_fd_sc_mcu7t5v0__filltie
XTAP_TAPCELL_ROW_17_456 VDD VSS gf180mcu_fd_sc_mcu7t5v0__filltie
X_1911_ _1911_/I _1911_/ZN VDD VDD VSS VSS gf180mcu_fd_sc_mcu7t5v0__clkinv_1
XTAP_TAPCELL_ROW_45_798 VDD VSS gf180mcu_fd_sc_mcu7t5v0__filltie
XFILLER_30_442 VDD VDD VSS VSS gf180mcu_fd_sc_mcu7t5v0__fill_1
X_1842_ _2394_/I0 _1854_/A2 _2533_/A2 _2765_/I _1843_/I VDD VDD VSS VSS gf180mcu_fd_sc_mcu7t5v0__aoi22_1
XFILLER_30_475 VDD VDD VSS VSS gf180mcu_fd_sc_mcu7t5v0__fillcap_32
X_1773_ _1773_/I _1773_/ZN VDD VDD VSS VSS gf180mcu_fd_sc_mcu7t5v0__clkinv_1
XTAP_TAPCELL_ROW_77_1177 VDD VSS gf180mcu_fd_sc_mcu7t5v0__filltie
XTAP_TAPCELL_ROW_90_1333 VDD VSS gf180mcu_fd_sc_mcu7t5v0__filltie
XFILLER_58_807 VDD VDD VSS VSS gf180mcu_fd_sc_mcu7t5v0__fillcap_16
XFILLER_69_122 VDD VDD VSS VSS gf180mcu_fd_sc_mcu7t5v0__fillcap_8
XFILLER_57_306 VDD VDD VSS VSS gf180mcu_fd_sc_mcu7t5v0__fillcap_32
X_2325_ _2333_/A1 _2325_/A2 _2326_/A2 VDD VDD VSS VSS gf180mcu_fd_sc_mcu7t5v0__nand2_1
X_2256_ _2256_/A1 _2256_/A2 _2296_/B _2256_/ZN VDD VDD VSS VSS gf180mcu_fd_sc_mcu7t5v0__aoi21_1
X_1207_ _2534_/A1 _1207_/A2 _1207_/B _1209_/A2 VDD VDD VSS VSS gf180mcu_fd_sc_mcu7t5v0__oai21_1
XFILLER_25_203 VDD VDD VSS VSS gf180mcu_fd_sc_mcu7t5v0__fill_1
XFILLER_26_737 VDD VDD VSS VSS gf180mcu_fd_sc_mcu7t5v0__fillcap_64
XFILLER_38_597 VDD VDD VSS VSS gf180mcu_fd_sc_mcu7t5v0__fillcap_64
X_2187_ _2187_/A1 _2218_/A2 _2189_/A2 VDD VDD VSS VSS gf180mcu_fd_sc_mcu7t5v0__nand2_1
XFILLER_53_556 VDD VDD VSS VSS gf180mcu_fd_sc_mcu7t5v0__fillcap_4
X_1138_ _2740_/I _2741_/I _1143_/A3 _1143_/A4 _1138_/Z VDD VDD VSS VSS gf180mcu_fd_sc_mcu7t5v0__and4_1
X_1069_ _2591_/Q _2491_/A1 VDD VDD VSS VSS gf180mcu_fd_sc_mcu7t5v0__clkinv_1
XFILLER_80_375 VDD VDD VSS VSS gf180mcu_fd_sc_mcu7t5v0__fillcap_8
XFILLER_21_486 VDD VDD VSS VSS gf180mcu_fd_sc_mcu7t5v0__fillcap_4
XFILLER_108_10 VDD VDD VSS VSS gf180mcu_fd_sc_mcu7t5v0__fill_2
XFILLER_0_324 VDD VDD VSS VSS gf180mcu_fd_sc_mcu7t5v0__fillcap_4
XFILLER_1_858 VDD VDD VSS VSS gf180mcu_fd_sc_mcu7t5v0__fillcap_8
XFILLER_48_317 VDD VDD VSS VSS gf180mcu_fd_sc_mcu7t5v0__fillcap_32
Xinput203 tl_d_uart_i[12] _2161_/A1 VDD VDD VSS VSS gf180mcu_fd_sc_mcu7t5v0__dlyd_1
Xinput214 tl_d_uart_i[22] _1310_/A1 VDD VDD VSS VSS gf180mcu_fd_sc_mcu7t5v0__dlyd_1
Xinput225 tl_d_uart_i[32] _1390_/A1 VDD VDD VSS VSS gf180mcu_fd_sc_mcu7t5v0__dlyd_1
Xinput236 tl_d_uart_i[42] _1470_/A1 VDD VDD VSS VSS gf180mcu_fd_sc_mcu7t5v0__dlyd_1
Xinput247 tl_d_uart_i[52] _1099_/I VDD VDD VSS VSS gf180mcu_fd_sc_mcu7t5v0__dlyd_1
Xinput258 tl_d_uart_i[62] _1107_/A1 VDD VDD VSS VSS gf180mcu_fd_sc_mcu7t5v0__dlyd_1
Xinput269 tl_h_d_i[102] _2761_/I VDD VDD VSS VSS gf180mcu_fd_sc_mcu7t5v0__dlyd_1
XTAP_TAPCELL_ROW_110_1580 VDD VSS gf180mcu_fd_sc_mcu7t5v0__filltie
XFILLER_75_114 VDD VDD VSS VSS gf180mcu_fd_sc_mcu7t5v0__fillcap_16
XFILLER_56_383 VDD VDD VSS VSS gf180mcu_fd_sc_mcu7t5v0__fill_2
XFILLER_84_681 VDD VDD VSS VSS gf180mcu_fd_sc_mcu7t5v0__fill_1
XFILLER_16_247 VDD VDD VSS VSS gf180mcu_fd_sc_mcu7t5v0__fillcap_64
XFILLER_31_206 VDD VDD VSS VSS gf180mcu_fd_sc_mcu7t5v0__fillcap_4
XFILLER_31_228 VDD VDD VSS VSS gf180mcu_fd_sc_mcu7t5v0__fill_2
XTAP_TAPCELL_ROW_14_426 VDD VSS gf180mcu_fd_sc_mcu7t5v0__filltie
XTAP_TAPCELL_ROW_42_757 VDD VSS gf180mcu_fd_sc_mcu7t5v0__filltie
XFILLER_8_435 VDD VDD VSS VSS gf180mcu_fd_sc_mcu7t5v0__fillcap_16
XFILLER_8_457 VDD VDD VSS VSS gf180mcu_fd_sc_mcu7t5v0__fillcap_64
XTAP_TAPCELL_ROW_113_1609 VDD VSS gf180mcu_fd_sc_mcu7t5v0__filltie
XFILLER_67_615 VDD VDD VSS VSS gf180mcu_fd_sc_mcu7t5v0__fillcap_8
XFILLER_66_103 VDD VDD VSS VSS gf180mcu_fd_sc_mcu7t5v0__fill_2
X_2110_ _2246_/B2 _2371_/A2 _2373_/A1 _2246_/A1 _2111_/I VDD VDD VSS VSS gf180mcu_fd_sc_mcu7t5v0__aoi22_1
XFILLER_79_486 VDD VDD VSS VSS gf180mcu_fd_sc_mcu7t5v0__fillcap_4
X_2041_ _2041_/I _2041_/ZN VDD VDD VSS VSS gf180mcu_fd_sc_mcu7t5v0__clkinv_1
XFILLER_47_361 VDD VDD VSS VSS gf180mcu_fd_sc_mcu7t5v0__fillcap_8
XFILLER_94_489 VDD VDD VSS VSS gf180mcu_fd_sc_mcu7t5v0__fillcap_8
XFILLER_35_556 VDD VDD VSS VSS gf180mcu_fd_sc_mcu7t5v0__fillcap_4
XFILLER_81_139 VDD VDD VSS VSS gf180mcu_fd_sc_mcu7t5v0__fill_1
XFILLER_22_228 VDD VDD VSS VSS gf180mcu_fd_sc_mcu7t5v0__fillcap_4
XTAP_TAPCELL_ROW_79_1206 VDD VSS gf180mcu_fd_sc_mcu7t5v0__filltie
X_1825_ _1825_/I _1825_/ZN VDD VDD VSS VSS gf180mcu_fd_sc_mcu7t5v0__clkinv_1
X_1756_ _1946_/A1 _1768_/A2 _1768_/B1 _1946_/B2 _1757_/I VDD VDD VSS VSS gf180mcu_fd_sc_mcu7t5v0__aoi22_1
X_1687_ _1687_/I _1687_/ZN VDD VDD VSS VSS gf180mcu_fd_sc_mcu7t5v0__clkinv_1
XFILLER_89_206 VDD VDD VSS VSS gf180mcu_fd_sc_mcu7t5v0__fillcap_4
X_2308_ _2308_/A1 _2308_/A2 _2360_/B _2308_/ZN VDD VDD VSS VSS gf180mcu_fd_sc_mcu7t5v0__aoi21_1
XFILLER_39_851 VDD VDD VSS VSS gf180mcu_fd_sc_mcu7t5v0__fillcap_8
XFILLER_85_478 VDD VDD VSS VSS gf180mcu_fd_sc_mcu7t5v0__fill_1
X_2239_ _2239_/A1 _2224_/C _2246_/C input56/Z _2240_/B VDD VDD VSS VSS gf180mcu_fd_sc_mcu7t5v0__aoi22_1
XFILLER_85_489 VDD VDD VSS VSS gf180mcu_fd_sc_mcu7t5v0__fill_1
XFILLER_73_629 VDD VDD VSS VSS gf180mcu_fd_sc_mcu7t5v0__fill_1
XFILLER_70_26 VDD VDD VSS VSS gf180mcu_fd_sc_mcu7t5v0__fill_2
XFILLER_48_147 VDD VDD VSS VSS gf180mcu_fd_sc_mcu7t5v0__fill_2
Xload_slew1143 _2296_/B _2360_/B VDD VDD VSS VSS gf180mcu_fd_sc_mcu7t5v0__buf_4
XTAP_TAPCELL_ROW_47_816 VDD VSS gf180mcu_fd_sc_mcu7t5v0__filltie
XFILLER_76_489 VDD VDD VSS VSS gf180mcu_fd_sc_mcu7t5v0__fillcap_16
XFILLER_17_556 VDD VDD VSS VSS gf180mcu_fd_sc_mcu7t5v0__fillcap_4
XFILLER_56_191 VDD VDD VSS VSS gf180mcu_fd_sc_mcu7t5v0__fill_1
XFILLER_63_139 VDD VDD VSS VSS gf180mcu_fd_sc_mcu7t5v0__fill_1
Xload_slew1187 _2371_/A2 _2363_/A2 VDD VDD VSS VSS gf180mcu_fd_sc_mcu7t5v0__buf_4
XTAP_TAPCELL_ROW_63_1007 VDD VSS gf180mcu_fd_sc_mcu7t5v0__filltie
XFILLER_72_651 VDD VDD VSS VSS gf180mcu_fd_sc_mcu7t5v0__fillcap_8
XTAP_TAPCELL_ROW_63_1018 VDD VSS gf180mcu_fd_sc_mcu7t5v0__filltie
XTAP_TAPCELL_ROW_27_584 VDD VSS gf180mcu_fd_sc_mcu7t5v0__filltie
XFILLER_12_272 VDD VDD VSS VSS gf180mcu_fd_sc_mcu7t5v0__fillcap_32
X_1610_ _1880_/B2 _1609_/Z _1619_/S _1610_/Z VDD VDD VSS VSS gf180mcu_fd_sc_mcu7t5v0__mux2_2
X_2590_ _2590_/D _2597_/RN clkload6/I _2590_/Q VDD VDD VSS VSS gf180mcu_fd_sc_mcu7t5v0__dffrnq_1
Xoutput507 _2698_/Z tl_d_dmem_o[111] VDD VDD VSS VSS gf180mcu_fd_sc_mcu7t5v0__dlyd_1
Xoutput518 _2638_/Z tl_d_dmem_o[19] VDD VDD VSS VSS gf180mcu_fd_sc_mcu7t5v0__dlyd_1
Xoutput529 _1512_/Z tl_d_dmem_o[29] VDD VDD VSS VSS gf180mcu_fd_sc_mcu7t5v0__dlyd_1
X_1541_ _1970_/B2 _1619_/S _1541_/Z VDD VDD VSS VSS gf180mcu_fd_sc_mcu7t5v0__or2_1
X_1472_ _1472_/A1 _1496_/A2 _2361_/A2 VDD VDD VSS VSS gf180mcu_fd_sc_mcu7t5v0__nand2_1
XTAP_TAPCELL_ROW_74_1147 VDD VSS gf180mcu_fd_sc_mcu7t5v0__filltie
XFILLER_99_548 VDD VDD VSS VSS gf180mcu_fd_sc_mcu7t5v0__fill_2
XFILLER_69_90 VDD VDD VSS VSS gf180mcu_fd_sc_mcu7t5v0__fillcap_32
XFILLER_10_2 VDD VDD VSS VSS gf180mcu_fd_sc_mcu7t5v0__fillcap_8
XFILLER_39_136 VDD VDD VSS VSS gf180mcu_fd_sc_mcu7t5v0__fillcap_4
XFILLER_67_478 VDD VDD VSS VSS gf180mcu_fd_sc_mcu7t5v0__fillcap_8
XFILLER_54_139 VDD VDD VSS VSS gf180mcu_fd_sc_mcu7t5v0__fillcap_4
X_2024_ _2399_/I0 _2044_/A2 _2038_/B1 _2760_/I _2025_/I VDD VDD VSS VSS gf180mcu_fd_sc_mcu7t5v0__aoi22_1
XFILLER_82_459 VDD VDD VSS VSS gf180mcu_fd_sc_mcu7t5v0__fill_1
XFILLER_62_150 VDD VDD VSS VSS gf180mcu_fd_sc_mcu7t5v0__fill_1
XFILLER_63_673 VDD VDD VSS VSS gf180mcu_fd_sc_mcu7t5v0__fillcap_16
XTAP_TAPCELL_ROW_85_1276 VDD VSS gf180mcu_fd_sc_mcu7t5v0__filltie
X_1808_ _1998_/A1 _1826_/A2 _1814_/B1 _2731_/I _1809_/I VDD VDD VSS VSS gf180mcu_fd_sc_mcu7t5v0__aoi22_1
XFILLER_104_314 VDD VDD VSS VSS gf180mcu_fd_sc_mcu7t5v0__fill_1
X_1739_ _1739_/I _1739_/ZN VDD VDD VSS VSS gf180mcu_fd_sc_mcu7t5v0__clkinv_1
XFILLER_104_336 VDD VDD VSS VSS gf180mcu_fd_sc_mcu7t5v0__fill_1
XFILLER_77_209 VDD VDD VSS VSS gf180mcu_fd_sc_mcu7t5v0__fill_1
XFILLER_100_531 VDD VDD VSS VSS gf180mcu_fd_sc_mcu7t5v0__fill_2
XFILLER_100_542 VDD VDD VSS VSS gf180mcu_fd_sc_mcu7t5v0__fillcap_8
XFILLER_18_309 VDD VDD VSS VSS gf180mcu_fd_sc_mcu7t5v0__fillcap_4
XFILLER_85_264 VDD VDD VSS VSS gf180mcu_fd_sc_mcu7t5v0__fillcap_4
XFILLER_100_597 VDD VDD VSS VSS gf180mcu_fd_sc_mcu7t5v0__fill_1
XFILLER_81_492 VDD VDD VSS VSS gf180mcu_fd_sc_mcu7t5v0__fill_2
XTAP_TAPCELL_ROW_24_543 VDD VSS gf180mcu_fd_sc_mcu7t5v0__filltie
XTAP_TAPCELL_ROW_52_885 VDD VSS gf180mcu_fd_sc_mcu7t5v0__filltie
XFILLER_49_434 VDD VDD VSS VSS gf180mcu_fd_sc_mcu7t5v0__fill_2
XFILLER_37_629 VDD VDD VSS VSS gf180mcu_fd_sc_mcu7t5v0__fill_1
XFILLER_49_489 VDD VDD VSS VSS gf180mcu_fd_sc_mcu7t5v0__fill_1
XFILLER_92_724 VDD VDD VSS VSS gf180mcu_fd_sc_mcu7t5v0__fill_2
XFILLER_32_367 VDD VDD VSS VSS gf180mcu_fd_sc_mcu7t5v0__fill_2
X_2711_ _2711_/I _2711_/Z VDD VDD VSS VSS gf180mcu_fd_sc_mcu7t5v0__buf_1
X_2642_ _2714_/I _2642_/Z VDD VDD VSS VSS gf180mcu_fd_sc_mcu7t5v0__buf_1
XFILLER_58_2 VDD VDD VSS VSS gf180mcu_fd_sc_mcu7t5v0__fillcap_16
X_2573_ _2573_/D _2587_/RN clkload4/I _2573_/Q VDD VDD VSS VSS gf180mcu_fd_sc_mcu7t5v0__dffrnq_1
XFILLER_99_312 VDD VDD VSS VSS gf180mcu_fd_sc_mcu7t5v0__fill_2
X_1524_ _1936_/B2 _1533_/A2 _1524_/Z VDD VDD VSS VSS gf180mcu_fd_sc_mcu7t5v0__or2_1
XFILLER_99_334 VDD VDD VSS VSS gf180mcu_fd_sc_mcu7t5v0__fillcap_4
XFILLER_59_209 VDD VDD VSS VSS gf180mcu_fd_sc_mcu7t5v0__fill_1
X_1455_ _1487_/A1 _1455_/A2 _1455_/ZN VDD VDD VSS VSS gf180mcu_fd_sc_mcu7t5v0__nor2_1
X_1386_ input93/Z _1418_/A2 _2331_/A3 _1387_/B VDD VDD VSS VSS gf180mcu_fd_sc_mcu7t5v0__nand3_1
XTAP_TAPCELL_ROW_87_1305 VDD VSS gf180mcu_fd_sc_mcu7t5v0__filltie
XFILLER_95_562 VDD VDD VSS VSS gf180mcu_fd_sc_mcu7t5v0__fillcap_8
XFILLER_83_702 VDD VDD VSS VSS gf180mcu_fd_sc_mcu7t5v0__fillcap_64
X_2007_ _2007_/I _2007_/ZN VDD VDD VSS VSS gf180mcu_fd_sc_mcu7t5v0__clkinv_1
XFILLER_51_632 VDD VDD VSS VSS gf180mcu_fd_sc_mcu7t5v0__fillcap_64
XFILLER_50_153 VDD VDD VSS VSS gf180mcu_fd_sc_mcu7t5v0__fillcap_16
XTAP_TAPCELL_ROW_21_513 VDD VSS gf180mcu_fd_sc_mcu7t5v0__filltie
XTAP_TAPCELL_ROW_98_1434 VDD VSS gf180mcu_fd_sc_mcu7t5v0__filltie
XFILLER_116_21 VDD VDD VSS VSS gf180mcu_fd_sc_mcu7t5v0__fill_1
Xoutput882 _2726_/Z tl_d_uart_o[67] VDD VDD VSS VSS gf180mcu_fd_sc_mcu7t5v0__dlyd_1
Xoutput871 _1648_/Z tl_d_uart_o[57] VDD VDD VSS VSS gf180mcu_fd_sc_mcu7t5v0__dlyd_1
Xoutput860 _1638_/Z tl_d_uart_o[47] VDD VDD VSS VSS gf180mcu_fd_sc_mcu7t5v0__dlyd_1
Xoutput893 _2736_/Z tl_d_uart_o[77] VDD VDD VSS VSS gf180mcu_fd_sc_mcu7t5v0__dlyd_1
XFILLER_58_220 VDD VDD VSS VSS gf180mcu_fd_sc_mcu7t5v0__fill_2
XFILLER_58_242 VDD VDD VSS VSS gf180mcu_fd_sc_mcu7t5v0__fill_2
XTAP_TAPCELL_ROW_29_602 VDD VSS gf180mcu_fd_sc_mcu7t5v0__filltie
XTAP_TAPCELL_ROW_57_944 VDD VSS gf180mcu_fd_sc_mcu7t5v0__filltie
XFILLER_73_212 VDD VDD VSS VSS gf180mcu_fd_sc_mcu7t5v0__fillcap_4
XTAP_TAPCELL_ROW_107_1541 VDD VSS gf180mcu_fd_sc_mcu7t5v0__filltie
XTAP_TAPCELL_ROW_1_271 VDD VSS gf180mcu_fd_sc_mcu7t5v0__filltie
XFILLER_41_142 VDD VDD VSS VSS gf180mcu_fd_sc_mcu7t5v0__fillcap_8
XTAP_TAPCELL_ROW_118_1681 VDD VSS gf180mcu_fd_sc_mcu7t5v0__filltie
XTAP_TAPCELL_ROW_118_1670 VDD VSS gf180mcu_fd_sc_mcu7t5v0__filltie
Xoutput1009 _2316_/ZN tl_h_i_o[31] VDD VDD VSS VSS gf180mcu_fd_sc_mcu7t5v0__dlyd_1
XTAP_TAPCELL_ROW_9_360 VDD VSS gf180mcu_fd_sc_mcu7t5v0__filltie
XTAP_TAPCELL_ROW_71_1106 VDD VSS gf180mcu_fd_sc_mcu7t5v0__filltie
X_1240_ input62/Z _2247_/A2 _1249_/A2 VDD VDD VSS VSS gf180mcu_fd_sc_mcu7t5v0__nor2_1
XFILLER_65_702 VDD VDD VSS VSS gf180mcu_fd_sc_mcu7t5v0__fillcap_32
X_1171_ _1191_/A1 _1164_/Z _1173_/A2 _2539_/Q _1175_/A1 VDD VDD VSS VSS gf180mcu_fd_sc_mcu7t5v0__oai31_1
XFILLER_92_510 VDD VDD VSS VSS gf180mcu_fd_sc_mcu7t5v0__fillcap_8
XFILLER_77_562 VDD VDD VSS VSS gf180mcu_fd_sc_mcu7t5v0__fillcap_32
XFILLER_49_286 VDD VDD VSS VSS gf180mcu_fd_sc_mcu7t5v0__fill_1
XFILLER_66_91 VDD VDD VSS VSS gf180mcu_fd_sc_mcu7t5v0__fillcap_8
XTAP_TAPCELL_ROW_69_1079 VDD VSS gf180mcu_fd_sc_mcu7t5v0__filltie
XFILLER_33_632 VDD VDD VSS VSS gf180mcu_fd_sc_mcu7t5v0__fillcap_64
XFILLER_45_492 VDD VDD VSS VSS gf180mcu_fd_sc_mcu7t5v0__fillcap_32
XTAP_TAPCELL_ROW_82_1246 VDD VSS gf180mcu_fd_sc_mcu7t5v0__filltie
XTAP_TAPCELL_ROW_82_1235 VDD VSS gf180mcu_fd_sc_mcu7t5v0__filltie
XFILLER_32_164 VDD VDD VSS VSS gf180mcu_fd_sc_mcu7t5v0__fillcap_4
XANTENNA_16 tl_h_i_i[23] VDD VDD VSS VSS gf180mcu_fd_sc_mcu7t5v0__antenna
XANTENNA_27 _1513_/Z VDD VDD VSS VSS gf180mcu_fd_sc_mcu7t5v0__antenna
XANTENNA_38 _1263_/ZN VDD VDD VSS VSS gf180mcu_fd_sc_mcu7t5v0__antenna
XFILLER_118_236 VDD VDD VSS VSS gf180mcu_fd_sc_mcu7t5v0__fill_2
X_2556_ _2556_/D _2586_/RN clkload4/I _2556_/Q VDD VDD VSS VSS gf180mcu_fd_sc_mcu7t5v0__dffrnq_1
XTAP_TAPCELL_ROW_93_1375 VDD VSS gf180mcu_fd_sc_mcu7t5v0__filltie
X_2487_ _2590_/Q _2507_/B _2488_/B VDD VDD VSS VSS gf180mcu_fd_sc_mcu7t5v0__nand2_1
X_1507_ _1507_/A1 _1505_/Z _1507_/B _1508_/B1 VDD VDD VSS VSS gf180mcu_fd_sc_mcu7t5v0__oai21_1
X_1438_ _1438_/A1 _1510_/A2 _1438_/B1 _2160_/C _1439_/A2 VDD VDD VSS VSS gf180mcu_fd_sc_mcu7t5v0__aoi22_1
XFILLER_28_437 VDD VDD VSS VSS gf180mcu_fd_sc_mcu7t5v0__fillcap_16
XFILLER_55_212 VDD VDD VSS VSS gf180mcu_fd_sc_mcu7t5v0__fillcap_8
X_1369_ _1441_/A1 _2309_/A2 _1369_/Z VDD VDD VSS VSS gf180mcu_fd_sc_mcu7t5v0__and2_1
XFILLER_95_381 VDD VDD VSS VSS gf180mcu_fd_sc_mcu7t5v0__fillcap_8
XFILLER_55_245 VDD VDD VSS VSS gf180mcu_fd_sc_mcu7t5v0__fill_1
XFILLER_55_256 VDD VDD VSS VSS gf180mcu_fd_sc_mcu7t5v0__fillcap_16
XTAP_TAPCELL_ROW_54_903 VDD VSS gf180mcu_fd_sc_mcu7t5v0__filltie
XTAP_TAPCELL_ROW_34_660 VDD VSS gf180mcu_fd_sc_mcu7t5v0__filltie
XFILLER_11_348 VDD VDD VSS VSS gf180mcu_fd_sc_mcu7t5v0__fill_2
XTAP_TAPCELL_ROW_102_1482 VDD VSS gf180mcu_fd_sc_mcu7t5v0__filltie
XFILLER_118_781 VDD VDD VSS VSS gf180mcu_fd_sc_mcu7t5v0__fill_1
XFILLER_105_464 VDD VDD VSS VSS gf180mcu_fd_sc_mcu7t5v0__fillcap_4
Xoutput690 _1997_/ZN tl_d_esram_o[71] VDD VDD VSS VSS gf180mcu_fd_sc_mcu7t5v0__dlyd_1
XTAP_TAPCELL_ROW_6_330 VDD VSS gf180mcu_fd_sc_mcu7t5v0__filltie
XFILLER_47_702 VDD VDD VSS VSS gf180mcu_fd_sc_mcu7t5v0__fillcap_32
XFILLER_59_562 VDD VDD VSS VSS gf180mcu_fd_sc_mcu7t5v0__fillcap_4
XFILLER_62_705 VDD VDD VSS VSS gf180mcu_fd_sc_mcu7t5v0__fillcap_16
XFILLER_27_470 VDD VDD VSS VSS gf180mcu_fd_sc_mcu7t5v0__fillcap_16
XFILLER_15_632 VDD VDD VSS VSS gf180mcu_fd_sc_mcu7t5v0__fillcap_64
XFILLER_27_492 VDD VDD VSS VSS gf180mcu_fd_sc_mcu7t5v0__fillcap_64
XFILLER_42_473 VDD VDD VSS VSS gf180mcu_fd_sc_mcu7t5v0__fillcap_8
XFILLER_30_657 VDD VDD VSS VSS gf180mcu_fd_sc_mcu7t5v0__fillcap_8
Xinput14 tl_d_dmem_i[20] input14/Z VDD VDD VSS VSS gf180mcu_fd_sc_mcu7t5v0__dlyd_1
Xinput25 tl_d_dmem_i[30] input25/Z VDD VDD VSS VSS gf180mcu_fd_sc_mcu7t5v0__dlyd_1
Xinput36 tl_d_dmem_i[40] input36/Z VDD VDD VSS VSS gf180mcu_fd_sc_mcu7t5v0__dlyd_1
XFILLER_7_842 VDD VDD VSS VSS gf180mcu_fd_sc_mcu7t5v0__fillcap_16
XFILLER_10_381 VDD VDD VSS VSS gf180mcu_fd_sc_mcu7t5v0__fillcap_4
Xinput47 tl_d_dmem_i[50] input47/Z VDD VDD VSS VSS gf180mcu_fd_sc_mcu7t5v0__dlyd_1
Xinput58 tl_d_dmem_i[60] input58/Z VDD VDD VSS VSS gf180mcu_fd_sc_mcu7t5v0__dlyd_1
Xinput69 tl_d_esram_i[10] _1087_/I VDD VDD VSS VSS gf180mcu_fd_sc_mcu7t5v0__dlyd_1
XTAP_TAPCELL_ROW_12_398 VDD VSS gf180mcu_fd_sc_mcu7t5v0__filltie
X_2410_ _2560_/Q _2451_/B _2411_/B VDD VDD VSS VSS gf180mcu_fd_sc_mcu7t5v0__nand2_1
XFILLER_97_602 VDD VDD VSS VSS gf180mcu_fd_sc_mcu7t5v0__fill_1
X_2341_ _2345_/A1 _2341_/A2 _2342_/A2 VDD VDD VSS VSS gf180mcu_fd_sc_mcu7t5v0__nand2_1
X_2272_ _2272_/A1 _2272_/A2 _2296_/B _2272_/ZN VDD VDD VSS VSS gf180mcu_fd_sc_mcu7t5v0__aoi21_1
XFILLER_69_348 VDD VDD VSS VSS gf180mcu_fd_sc_mcu7t5v0__fill_2
X_1223_ _1230_/A1 _1223_/A2 _1231_/A2 VDD VDD VSS VSS gf180mcu_fd_sc_mcu7t5v0__nor2_1
XFILLER_37_212 VDD VDD VSS VSS gf180mcu_fd_sc_mcu7t5v0__fillcap_4
XFILLER_65_532 VDD VDD VSS VSS gf180mcu_fd_sc_mcu7t5v0__fillcap_4
XFILLER_25_407 VDD VDD VSS VSS gf180mcu_fd_sc_mcu7t5v0__fill_2
X_1154_ _1151_/Z _1152_/Z _1153_/Z _1155_/B VDD VDD VSS VSS gf180mcu_fd_sc_mcu7t5v0__nor3_1
XFILLER_52_204 VDD VDD VSS VSS gf180mcu_fd_sc_mcu7t5v0__fillcap_16
XFILLER_65_598 VDD VDD VSS VSS gf180mcu_fd_sc_mcu7t5v0__fillcap_16
X_1085_ _1085_/I _1655_/A1 VDD VDD VSS VSS gf180mcu_fd_sc_mcu7t5v0__clkinv_1
XFILLER_92_384 VDD VDD VSS VSS gf180mcu_fd_sc_mcu7t5v0__fill_1
XFILLER_92_362 VDD VDD VSS VSS gf180mcu_fd_sc_mcu7t5v0__fill_1
X_1987_ _1987_/I _1987_/ZN VDD VDD VSS VSS gf180mcu_fd_sc_mcu7t5v0__clkinv_1
XTAP_TAPCELL_ROW_31_630 VDD VSS gf180mcu_fd_sc_mcu7t5v0__filltie
XFILLER_102_401 VDD VDD VSS VSS gf180mcu_fd_sc_mcu7t5v0__fill_1
X_2539_ _2539_/D _2550_/RN clkload1/I _2539_/Q VDD VDD VSS VSS gf180mcu_fd_sc_mcu7t5v0__dffrnq_1
Xinput407 tl_h_i_i[21] _1896_/A1 VDD VDD VSS VSS gf180mcu_fd_sc_mcu7t5v0__dlyd_1
Xinput418 tl_h_i_i[31] _1916_/A1 VDD VDD VSS VSS gf180mcu_fd_sc_mcu7t5v0__dlyd_1
XFILLER_29_702 VDD VDD VSS VSS gf180mcu_fd_sc_mcu7t5v0__fillcap_64
Xinput429 tl_h_i_i[41] _1936_/A1 VDD VDD VSS VSS gf180mcu_fd_sc_mcu7t5v0__dlyd_1
XFILLER_87_167 VDD VDD VSS VSS gf180mcu_fd_sc_mcu7t5v0__fill_1
XFILLER_68_381 VDD VDD VSS VSS gf180mcu_fd_sc_mcu7t5v0__fillcap_4
XTAP_TAPCELL_ROW_39_730 VDD VSS gf180mcu_fd_sc_mcu7t5v0__filltie
XFILLER_83_340 VDD VDD VSS VSS gf180mcu_fd_sc_mcu7t5v0__fillcap_8
XTAP_TAPCELL_ROW_104_1500 VDD VSS gf180mcu_fd_sc_mcu7t5v0__filltie
XFILLER_4_823 VDD VDD VSS VSS gf180mcu_fd_sc_mcu7t5v0__fillcap_8
XTAP_TAPCELL_ROW_115_1640 VDD VSS gf180mcu_fd_sc_mcu7t5v0__filltie
XFILLER_79_613 VDD VDD VSS VSS gf180mcu_fd_sc_mcu7t5v0__fillcap_8
Xfanout1101 _1665_/S _1662_/S VDD VDD VSS VSS gf180mcu_fd_sc_mcu7t5v0__dlyd_1
Xfanout1112 _1507_/A1 _1491_/A1 VDD VDD VSS VSS gf180mcu_fd_sc_mcu7t5v0__dlyd_1
XFILLER_78_112 VDD VDD VSS VSS gf180mcu_fd_sc_mcu7t5v0__fill_1
Xfanout1134 _1854_/B1 _1197_/A2 VDD VDD VSS VSS gf180mcu_fd_sc_mcu7t5v0__dlyd_1
Xfanout1156 _2230_/A2 _2158_/A2 VDD VDD VSS VSS gf180mcu_fd_sc_mcu7t5v0__dlyd_1
Xfanout1178 _1105_/Z _2171_/B VDD VDD VSS VSS gf180mcu_fd_sc_mcu7t5v0__dlyd_1
XFILLER_94_649 VDD VDD VSS VSS gf180mcu_fd_sc_mcu7t5v0__fill_2
XFILLER_19_278 VDD VDD VSS VSS gf180mcu_fd_sc_mcu7t5v0__fill_2
XTAP_TAPCELL_ROW_66_1049 VDD VSS gf180mcu_fd_sc_mcu7t5v0__filltie
XTAP_TAPCELL_ROW_17_457 VDD VSS gf180mcu_fd_sc_mcu7t5v0__filltie
X_1910_ _1910_/A1 _1912_/A2 _1926_/B1 _2719_/I _1911_/I VDD VDD VSS VSS gf180mcu_fd_sc_mcu7t5v0__aoi22_1
XTAP_TAPCELL_ROW_45_799 VDD VSS gf180mcu_fd_sc_mcu7t5v0__filltie
X_1841_ _1841_/I _1841_/ZN VDD VDD VSS VSS gf180mcu_fd_sc_mcu7t5v0__clkinv_1
X_1772_ _1962_/A1 _1772_/A2 _1772_/B1 _1962_/B2 _1773_/I VDD VDD VSS VSS gf180mcu_fd_sc_mcu7t5v0__aoi22_1
XTAP_TAPCELL_ROW_77_1178 VDD VSS gf180mcu_fd_sc_mcu7t5v0__filltie
XFILLER_40_2 VDD VDD VSS VSS gf180mcu_fd_sc_mcu7t5v0__fillcap_8
XFILLER_97_410 VDD VDD VSS VSS gf180mcu_fd_sc_mcu7t5v0__fillcap_8
X_2324_ _2324_/A1 _2324_/A2 _2360_/B _2324_/ZN VDD VDD VSS VSS gf180mcu_fd_sc_mcu7t5v0__aoi21_1
XTAP_TAPCELL_ROW_90_1334 VDD VSS gf180mcu_fd_sc_mcu7t5v0__filltie
XFILLER_69_134 VDD VDD VSS VSS gf180mcu_fd_sc_mcu7t5v0__fill_1
XFILLER_85_605 VDD VDD VSS VSS gf180mcu_fd_sc_mcu7t5v0__fillcap_16
XFILLER_38_521 VDD VDD VSS VSS gf180mcu_fd_sc_mcu7t5v0__fillcap_4
X_2255_ _2255_/A1 _1243_/I _1245_/I _2364_/B VDD VDD VSS VSS gf180mcu_fd_sc_mcu7t5v0__nand3_1
X_2186_ _2186_/A1 _2224_/C _2186_/B1 _2186_/B2 _2186_/ZN VDD VDD VSS VSS gf180mcu_fd_sc_mcu7t5v0__aoi22_2
X_1206_ _2517_/B _2773_/I VDD VDD VSS VSS gf180mcu_fd_sc_mcu7t5v0__clkinv_1
X_1137_ _1145_/B _1135_/Z _1201_/B VDD VDD VSS VSS gf180mcu_fd_sc_mcu7t5v0__nand2_1
XFILLER_80_321 VDD VDD VSS VSS gf180mcu_fd_sc_mcu7t5v0__fill_2
X_1068_ _2589_/Q _2493_/A1 VDD VDD VSS VSS gf180mcu_fd_sc_mcu7t5v0__clkinv_1
XFILLER_80_365 VDD VDD VSS VSS gf180mcu_fd_sc_mcu7t5v0__fill_2
XFILLER_80_387 VDD VDD VSS VSS gf180mcu_fd_sc_mcu7t5v0__fillcap_64
XFILLER_0_358 VDD VDD VSS VSS gf180mcu_fd_sc_mcu7t5v0__fillcap_8
Xinput204 tl_d_uart_i[13] _1094_/I VDD VDD VSS VSS gf180mcu_fd_sc_mcu7t5v0__dlyd_1
Xinput215 tl_d_uart_i[23] _1318_/A1 VDD VDD VSS VSS gf180mcu_fd_sc_mcu7t5v0__dlyd_1
Xinput226 tl_d_uart_i[33] _1398_/A1 VDD VDD VSS VSS gf180mcu_fd_sc_mcu7t5v0__dlyd_1
XFILLER_88_465 VDD VDD VSS VSS gf180mcu_fd_sc_mcu7t5v0__fill_1
XFILLER_88_454 VDD VDD VSS VSS gf180mcu_fd_sc_mcu7t5v0__fill_1
Xinput237 tl_d_uart_i[43] _1478_/A1 VDD VDD VSS VSS gf180mcu_fd_sc_mcu7t5v0__dlyd_1
Xinput248 tl_d_uart_i[53] _2210_/A1 VDD VDD VSS VSS gf180mcu_fd_sc_mcu7t5v0__dlyd_1
Xinput259 tl_d_uart_i[63] _1248_/A1 VDD VDD VSS VSS gf180mcu_fd_sc_mcu7t5v0__dlyd_1
XTAP_TAPCELL_ROW_110_1581 VDD VSS gf180mcu_fd_sc_mcu7t5v0__filltie
XFILLER_56_340 VDD VDD VSS VSS gf180mcu_fd_sc_mcu7t5v0__fill_2
XFILLER_44_524 VDD VDD VSS VSS gf180mcu_fd_sc_mcu7t5v0__fill_1
XFILLER_40_730 VDD VDD VSS VSS gf180mcu_fd_sc_mcu7t5v0__fillcap_4
XTAP_TAPCELL_ROW_14_427 VDD VSS gf180mcu_fd_sc_mcu7t5v0__filltie
XTAP_TAPCELL_ROW_42_758 VDD VSS gf180mcu_fd_sc_mcu7t5v0__filltie
XFILLER_67_627 VDD VDD VSS VSS gf180mcu_fd_sc_mcu7t5v0__fill_2
XFILLER_94_435 VDD VDD VSS VSS gf180mcu_fd_sc_mcu7t5v0__fill_2
X_2040_ _2389_/I0 _2044_/A2 _2044_/B1 _2769_/I _2041_/I VDD VDD VSS VSS gf180mcu_fd_sc_mcu7t5v0__aoi22_1
XFILLER_94_457 VDD VDD VSS VSS gf180mcu_fd_sc_mcu7t5v0__fillcap_32
XFILLER_47_373 VDD VDD VSS VSS gf180mcu_fd_sc_mcu7t5v0__fill_1
XFILLER_62_310 VDD VDD VSS VSS gf180mcu_fd_sc_mcu7t5v0__fillcap_4
XFILLER_50_527 VDD VDD VSS VSS gf180mcu_fd_sc_mcu7t5v0__fillcap_8
XFILLER_62_387 VDD VDD VSS VSS gf180mcu_fd_sc_mcu7t5v0__fillcap_16
XFILLER_90_696 VDD VDD VSS VSS gf180mcu_fd_sc_mcu7t5v0__fillcap_4
XTAP_TAPCELL_ROW_79_1207 VDD VSS gf180mcu_fd_sc_mcu7t5v0__filltie
X_1824_ _2014_/A1 _1826_/A2 _2533_/A2 _2739_/I _1825_/I VDD VDD VSS VSS gf180mcu_fd_sc_mcu7t5v0__aoi22_1
X_1755_ _1755_/I _1755_/ZN VDD VDD VSS VSS gf180mcu_fd_sc_mcu7t5v0__clkinv_1
X_1686_ _1876_/A1 _1720_/A2 _1720_/B1 _1876_/B2 _1687_/I VDD VDD VSS VSS gf180mcu_fd_sc_mcu7t5v0__aoi22_1
XFILLER_85_402 VDD VDD VSS VSS gf180mcu_fd_sc_mcu7t5v0__fill_2
X_2307_ input89/Z _2363_/A2 _2363_/A3 _2308_/A2 VDD VDD VSS VSS gf180mcu_fd_sc_mcu7t5v0__nand3_1
XFILLER_39_863 VDD VDD VSS VSS gf180mcu_fd_sc_mcu7t5v0__fill_2
X_2238_ _2238_/A1 _2238_/A2 _2238_/B1 _2238_/B2 _2240_/A2 VDD VDD VSS VSS gf180mcu_fd_sc_mcu7t5v0__aoi22_1
XFILLER_26_502 VDD VDD VSS VSS gf180mcu_fd_sc_mcu7t5v0__fillcap_16
XFILLER_38_373 VDD VDD VSS VSS gf180mcu_fd_sc_mcu7t5v0__fillcap_8
XFILLER_72_107 VDD VDD VSS VSS gf180mcu_fd_sc_mcu7t5v0__fillcap_16
XFILLER_26_524 VDD VDD VSS VSS gf180mcu_fd_sc_mcu7t5v0__fill_1
X_2169_ _2169_/A1 _2233_/A2 _2169_/Z VDD VDD VSS VSS gf180mcu_fd_sc_mcu7t5v0__and2_1
XFILLER_81_685 VDD VDD VSS VSS gf180mcu_fd_sc_mcu7t5v0__fill_1
XFILLER_48_115 VDD VDD VSS VSS gf180mcu_fd_sc_mcu7t5v0__fillcap_32
XFILLER_49_638 VDD VDD VSS VSS gf180mcu_fd_sc_mcu7t5v0__fill_1
XFILLER_88_295 VDD VDD VSS VSS gf180mcu_fd_sc_mcu7t5v0__fillcap_4
XFILLER_76_457 VDD VDD VSS VSS gf180mcu_fd_sc_mcu7t5v0__fillcap_32
XFILLER_64_619 VDD VDD VSS VSS gf180mcu_fd_sc_mcu7t5v0__fill_1
Xload_slew1111 _1534_/A2 _1550_/A2 VDD VDD VSS VSS gf180mcu_fd_sc_mcu7t5v0__buf_4
Xload_slew1133 _1812_/B1 _1814_/B1 VDD VDD VSS VSS gf180mcu_fd_sc_mcu7t5v0__buf_4
Xload_slew1144 _2380_/B _2296_/B VDD VDD VSS VSS gf180mcu_fd_sc_mcu7t5v0__buf_4
XTAP_TAPCELL_ROW_47_817 VDD VSS gf180mcu_fd_sc_mcu7t5v0__filltie
XFILLER_91_416 VDD VDD VSS VSS gf180mcu_fd_sc_mcu7t5v0__fillcap_4
XFILLER_57_693 VDD VDD VSS VSS gf180mcu_fd_sc_mcu7t5v0__fillcap_4
Xload_slew1155 _2157_/B _2142_/B VDD VDD VSS VSS gf180mcu_fd_sc_mcu7t5v0__clkbuf_4
XFILLER_44_365 VDD VDD VSS VSS gf180mcu_fd_sc_mcu7t5v0__fill_1
XTAP_TAPCELL_ROW_63_1008 VDD VSS gf180mcu_fd_sc_mcu7t5v0__filltie
XFILLER_72_663 VDD VDD VSS VSS gf180mcu_fd_sc_mcu7t5v0__fill_2
XTAP_TAPCELL_ROW_27_585 VDD VSS gf180mcu_fd_sc_mcu7t5v0__filltie
XFILLER_72_696 VDD VDD VSS VSS gf180mcu_fd_sc_mcu7t5v0__fillcap_32
XFILLER_60_71 VDD VDD VSS VSS gf180mcu_fd_sc_mcu7t5v0__fillcap_32
Xoutput508 _2699_/Z tl_d_dmem_o[112] VDD VDD VSS VSS gf180mcu_fd_sc_mcu7t5v0__dlyd_1
X_1540_ _1968_/B2 _1619_/S _1540_/Z VDD VDD VSS VSS gf180mcu_fd_sc_mcu7t5v0__or2_1
Xoutput519 _1544_/Z tl_d_dmem_o[1] VDD VDD VSS VSS gf180mcu_fd_sc_mcu7t5v0__dlyd_1
X_1471_ _1487_/A1 _1471_/A2 _1471_/ZN VDD VDD VSS VSS gf180mcu_fd_sc_mcu7t5v0__nor2_1
XTAP_TAPCELL_ROW_74_1148 VDD VSS gf180mcu_fd_sc_mcu7t5v0__filltie
XFILLER_69_80 VDD VDD VSS VSS gf180mcu_fd_sc_mcu7t5v0__fill_2
XFILLER_79_262 VDD VDD VSS VSS gf180mcu_fd_sc_mcu7t5v0__fill_1
XFILLER_39_148 VDD VDD VSS VSS gf180mcu_fd_sc_mcu7t5v0__fill_1
XFILLER_54_107 VDD VDD VSS VSS gf180mcu_fd_sc_mcu7t5v0__fillcap_32
XPHY_EDGE_ROW_19_Left_138 VDD VSS gf180mcu_fd_sc_mcu7t5v0__endcap
XFILLER_63_641 VDD VDD VSS VSS gf180mcu_fd_sc_mcu7t5v0__fillcap_32
X_2023_ _2023_/I _2023_/ZN VDD VDD VSS VSS gf180mcu_fd_sc_mcu7t5v0__clkinv_1
XTAP_TAPCELL_ROW_85_1277 VDD VSS gf180mcu_fd_sc_mcu7t5v0__filltie
XFILLER_90_493 VDD VDD VSS VSS gf180mcu_fd_sc_mcu7t5v0__fillcap_4
XFILLER_50_357 VDD VDD VSS VSS gf180mcu_fd_sc_mcu7t5v0__fillcap_16
XFILLER_51_858 VDD VDD VSS VSS gf180mcu_fd_sc_mcu7t5v0__fillcap_8
XPHY_EDGE_ROW_28_Left_147 VDD VSS gf180mcu_fd_sc_mcu7t5v0__endcap
X_1807_ _1807_/I _1807_/ZN VDD VDD VSS VSS gf180mcu_fd_sc_mcu7t5v0__clkinv_1
X_1738_ _1928_/A1 _1772_/A2 _1772_/B1 _1928_/B2 _1739_/I VDD VDD VSS VSS gf180mcu_fd_sc_mcu7t5v0__aoi22_1
X_1669_ _1669_/I _1669_/ZN VDD VDD VSS VSS gf180mcu_fd_sc_mcu7t5v0__clkinv_1
XFILLER_86_733 VDD VDD VSS VSS gf180mcu_fd_sc_mcu7t5v0__fill_2
XFILLER_58_457 VDD VDD VSS VSS gf180mcu_fd_sc_mcu7t5v0__fillcap_16
XPHY_EDGE_ROW_37_Left_156 VDD VSS gf180mcu_fd_sc_mcu7t5v0__endcap
XFILLER_58_479 VDD VDD VSS VSS gf180mcu_fd_sc_mcu7t5v0__fill_1
XFILLER_85_254 VDD VDD VSS VSS gf180mcu_fd_sc_mcu7t5v0__fill_2
XFILLER_73_416 VDD VDD VSS VSS gf180mcu_fd_sc_mcu7t5v0__fillcap_4
XFILLER_26_365 VDD VDD VSS VSS gf180mcu_fd_sc_mcu7t5v0__fill_2
XFILLER_54_663 VDD VDD VSS VSS gf180mcu_fd_sc_mcu7t5v0__fill_2
XFILLER_14_527 VDD VDD VSS VSS gf180mcu_fd_sc_mcu7t5v0__fillcap_64
XFILLER_41_302 VDD VDD VSS VSS gf180mcu_fd_sc_mcu7t5v0__fill_2
XTAP_TAPCELL_ROW_24_544 VDD VSS gf180mcu_fd_sc_mcu7t5v0__filltie
XFILLER_10_711 VDD VDD VSS VSS gf180mcu_fd_sc_mcu7t5v0__fill_1
XFILLER_41_368 VDD VDD VSS VSS gf180mcu_fd_sc_mcu7t5v0__fillcap_4
XTAP_TAPCELL_ROW_52_886 VDD VSS gf180mcu_fd_sc_mcu7t5v0__filltie
XTAP_TAPCELL_ROW_52_875 VDD VSS gf180mcu_fd_sc_mcu7t5v0__filltie
XPHY_EDGE_ROW_46_Left_165 VDD VSS gf180mcu_fd_sc_mcu7t5v0__endcap
XFILLER_107_142 VDD VDD VSS VSS gf180mcu_fd_sc_mcu7t5v0__fill_2
XPHY_EDGE_ROW_55_Left_174 VDD VSS gf180mcu_fd_sc_mcu7t5v0__endcap
XFILLER_39_72 VDD VDD VSS VSS gf180mcu_fd_sc_mcu7t5v0__fillcap_4
XFILLER_77_766 VDD VDD VSS VSS gf180mcu_fd_sc_mcu7t5v0__fillcap_4
XFILLER_29_181 VDD VDD VSS VSS gf180mcu_fd_sc_mcu7t5v0__fill_2
XFILLER_64_449 VDD VDD VSS VSS gf180mcu_fd_sc_mcu7t5v0__fillcap_4
XPHY_EDGE_ROW_101_Right_101 VDD VSS gf180mcu_fd_sc_mcu7t5v0__endcap
XFILLER_91_279 VDD VDD VSS VSS gf180mcu_fd_sc_mcu7t5v0__fill_1
XFILLER_32_313 VDD VDD VSS VSS gf180mcu_fd_sc_mcu7t5v0__fill_2
XFILLER_45_696 VDD VDD VSS VSS gf180mcu_fd_sc_mcu7t5v0__fillcap_4
XFILLER_33_858 VDD VDD VSS VSS gf180mcu_fd_sc_mcu7t5v0__fillcap_8
XPHY_EDGE_ROW_64_Left_183 VDD VSS gf180mcu_fd_sc_mcu7t5v0__endcap
X_2710_ _2710_/I _2710_/Z VDD VDD VSS VSS gf180mcu_fd_sc_mcu7t5v0__buf_1
X_2641_ _2713_/I _2641_/Z VDD VDD VSS VSS gf180mcu_fd_sc_mcu7t5v0__buf_1
X_2572_ _2572_/D _2587_/RN clkload6/I _2572_/Q VDD VDD VSS VSS gf180mcu_fd_sc_mcu7t5v0__dffrnq_1
X_1523_ _1934_/B2 _1533_/A2 _1523_/Z VDD VDD VSS VSS gf180mcu_fd_sc_mcu7t5v0__or2_1
X_1454_ _1454_/A1 _1486_/A2 _1454_/B1 _2208_/B _1455_/A2 VDD VDD VSS VSS gf180mcu_fd_sc_mcu7t5v0__aoi22_1
XPHY_EDGE_ROW_73_Left_192 VDD VSS gf180mcu_fd_sc_mcu7t5v0__endcap
X_1385_ _1441_/A1 _2317_/A2 _1385_/Z VDD VDD VSS VSS gf180mcu_fd_sc_mcu7t5v0__and2_1
XFILLER_95_530 VDD VDD VSS VSS gf180mcu_fd_sc_mcu7t5v0__fill_1
XFILLER_67_276 VDD VDD VSS VSS gf180mcu_fd_sc_mcu7t5v0__fillcap_4
XTAP_TAPCELL_ROW_87_1306 VDD VSS gf180mcu_fd_sc_mcu7t5v0__filltie
XFILLER_95_596 VDD VDD VSS VSS gf180mcu_fd_sc_mcu7t5v0__fillcap_4
X_2006_ _2006_/A1 _2044_/A2 _2038_/B1 _2735_/I _2007_/I VDD VDD VSS VSS gf180mcu_fd_sc_mcu7t5v0__aoi22_1
XFILLER_35_151 VDD VDD VSS VSS gf180mcu_fd_sc_mcu7t5v0__fillcap_16
XTAP_TAPCELL_ROW_21_503 VDD VSS gf180mcu_fd_sc_mcu7t5v0__filltie
XTAP_TAPCELL_ROW_21_514 VDD VSS gf180mcu_fd_sc_mcu7t5v0__filltie
XTAP_TAPCELL_ROW_98_1435 VDD VSS gf180mcu_fd_sc_mcu7t5v0__filltie
XFILLER_105_613 VDD VDD VSS VSS gf180mcu_fd_sc_mcu7t5v0__fill_2
Xoutput872 _1649_/Z tl_d_uart_o[58] VDD VDD VSS VSS gf180mcu_fd_sc_mcu7t5v0__dlyd_1
Xoutput861 _1639_/Z tl_d_uart_o[48] VDD VDD VSS VSS gf180mcu_fd_sc_mcu7t5v0__dlyd_1
Xoutput850 _1629_/Z tl_d_uart_o[38] VDD VDD VSS VSS gf180mcu_fd_sc_mcu7t5v0__dlyd_1
Xoutput894 _2737_/Z tl_d_uart_o[78] VDD VDD VSS VSS gf180mcu_fd_sc_mcu7t5v0__dlyd_1
Xoutput883 _2727_/Z tl_d_uart_o[68] VDD VDD VSS VSS gf180mcu_fd_sc_mcu7t5v0__dlyd_1
XFILLER_59_766 VDD VDD VSS VSS gf180mcu_fd_sc_mcu7t5v0__fillcap_4
XTAP_TAPCELL_ROW_29_603 VDD VSS gf180mcu_fd_sc_mcu7t5v0__filltie
XFILLER_100_373 VDD VDD VSS VSS gf180mcu_fd_sc_mcu7t5v0__fill_1
XFILLER_100_384 VDD VDD VSS VSS gf180mcu_fd_sc_mcu7t5v0__fill_1
XTAP_TAPCELL_ROW_57_945 VDD VSS gf180mcu_fd_sc_mcu7t5v0__filltie
XTAP_TAPCELL_ROW_107_1542 VDD VSS gf180mcu_fd_sc_mcu7t5v0__filltie
XFILLER_74_769 VDD VDD VSS VSS gf180mcu_fd_sc_mcu7t5v0__fill_2
XFILLER_14_313 VDD VDD VSS VSS gf180mcu_fd_sc_mcu7t5v0__fill_2
XFILLER_27_696 VDD VDD VSS VSS gf180mcu_fd_sc_mcu7t5v0__fillcap_4
XTAP_TAPCELL_ROW_1_272 VDD VSS gf180mcu_fd_sc_mcu7t5v0__filltie
XFILLER_26_195 VDD VDD VSS VSS gf180mcu_fd_sc_mcu7t5v0__fillcap_8
XFILLER_81_290 VDD VDD VSS VSS gf180mcu_fd_sc_mcu7t5v0__fill_1
XFILLER_41_187 VDD VDD VSS VSS gf180mcu_fd_sc_mcu7t5v0__fillcap_16
XFILLER_6_523 VDD VDD VSS VSS gf180mcu_fd_sc_mcu7t5v0__fill_2
XTAP_TAPCELL_ROW_118_1671 VDD VSS gf180mcu_fd_sc_mcu7t5v0__filltie
XTAP_TAPCELL_ROW_118_1682 VDD VSS gf180mcu_fd_sc_mcu7t5v0__filltie
XTAP_TAPCELL_ROW_9_361 VDD VSS gf180mcu_fd_sc_mcu7t5v0__filltie
XTAP_TAPCELL_ROW_71_1107 VDD VSS gf180mcu_fd_sc_mcu7t5v0__filltie
XFILLER_2_34 VDD VDD VSS VSS gf180mcu_fd_sc_mcu7t5v0__fill_1
X_1170_ _1058_/I _2383_/A1 _1208_/C VDD VDD VSS VSS gf180mcu_fd_sc_mcu7t5v0__nand2_1
XFILLER_92_522 VDD VDD VSS VSS gf180mcu_fd_sc_mcu7t5v0__fill_2
XFILLER_65_769 VDD VDD VSS VSS gf180mcu_fd_sc_mcu7t5v0__fill_1
XFILLER_52_419 VDD VDD VSS VSS gf180mcu_fd_sc_mcu7t5v0__fillcap_4
XTAP_TAPCELL_ROW_82_1236 VDD VSS gf180mcu_fd_sc_mcu7t5v0__filltie
XFILLER_32_143 VDD VDD VSS VSS gf180mcu_fd_sc_mcu7t5v0__fillcap_8
XFILLER_60_452 VDD VDD VSS VSS gf180mcu_fd_sc_mcu7t5v0__fill_2
XANTENNA_17 tl_h_i_i[4] VDD VDD VSS VSS gf180mcu_fd_sc_mcu7t5v0__antenna
XANTENNA_28 _1661_/Z VDD VDD VSS VSS gf180mcu_fd_sc_mcu7t5v0__antenna
XANTENNA_39 _1279_/ZN VDD VDD VSS VSS gf180mcu_fd_sc_mcu7t5v0__antenna
XFILLER_70_2 VDD VDD VSS VSS gf180mcu_fd_sc_mcu7t5v0__fillcap_16
XPHY_EDGE_ROW_81_Left_200 VDD VSS gf180mcu_fd_sc_mcu7t5v0__endcap
X_2555_ _2555_/D _2586_/RN clkload4/I _2555_/Q VDD VDD VSS VSS gf180mcu_fd_sc_mcu7t5v0__dffrnq_1
XTAP_TAPCELL_ROW_93_1376 VDD VSS gf180mcu_fd_sc_mcu7t5v0__filltie
X_2486_ _2590_/Q _2493_/A1 _2517_/B _2486_/Z VDD VDD VSS VSS gf180mcu_fd_sc_mcu7t5v0__xor3_1
X_1506_ _2379_/A1 _2230_/A2 _2379_/A3 _1507_/B VDD VDD VSS VSS gf180mcu_fd_sc_mcu7t5v0__nand3_1
X_1437_ _1437_/I _1438_/B1 VDD VDD VSS VSS gf180mcu_fd_sc_mcu7t5v0__clkinv_1
XFILLER_87_349 VDD VDD VSS VSS gf180mcu_fd_sc_mcu7t5v0__fill_1
XFILLER_68_552 VDD VDD VSS VSS gf180mcu_fd_sc_mcu7t5v0__fillcap_8
X_1368_ _1368_/A1 _1368_/A2 _2309_/A2 VDD VDD VSS VSS gf180mcu_fd_sc_mcu7t5v0__nand2_1
XFILLER_95_360 VDD VDD VSS VSS gf180mcu_fd_sc_mcu7t5v0__fillcap_16
XFILLER_55_224 VDD VDD VSS VSS gf180mcu_fd_sc_mcu7t5v0__fill_2
XFILLER_55_235 VDD VDD VSS VSS gf180mcu_fd_sc_mcu7t5v0__fillcap_8
X_1299_ _1339_/A1 _1297_/Z _1299_/B _1300_/B1 VDD VDD VSS VSS gf180mcu_fd_sc_mcu7t5v0__oai21_1
XTAP_TAPCELL_ROW_54_904 VDD VSS gf180mcu_fd_sc_mcu7t5v0__filltie
XFILLER_83_555 VDD VDD VSS VSS gf180mcu_fd_sc_mcu7t5v0__fillcap_4
XFILLER_43_419 VDD VDD VSS VSS gf180mcu_fd_sc_mcu7t5v0__fill_1
XFILLER_70_216 VDD VDD VSS VSS gf180mcu_fd_sc_mcu7t5v0__fillcap_16
XTAP_TAPCELL_ROW_34_661 VDD VSS gf180mcu_fd_sc_mcu7t5v0__filltie
XFILLER_23_176 VDD VDD VSS VSS gf180mcu_fd_sc_mcu7t5v0__fill_1
XTAP_TAPCELL_ROW_102_1483 VDD VSS gf180mcu_fd_sc_mcu7t5v0__filltie
XFILLER_105_476 VDD VDD VSS VSS gf180mcu_fd_sc_mcu7t5v0__fillcap_8
Xoutput680 _1979_/ZN tl_d_esram_o[62] VDD VDD VSS VSS gf180mcu_fd_sc_mcu7t5v0__dlyd_1
XFILLER_78_305 VDD VDD VSS VSS gf180mcu_fd_sc_mcu7t5v0__fillcap_8
Xoutput691 _1999_/ZN tl_d_esram_o[72] VDD VDD VSS VSS gf180mcu_fd_sc_mcu7t5v0__dlyd_1
XTAP_TAPCELL_ROW_6_331 VDD VSS gf180mcu_fd_sc_mcu7t5v0__filltie
XFILLER_86_382 VDD VDD VSS VSS gf180mcu_fd_sc_mcu7t5v0__fill_2
XFILLER_46_279 VDD VDD VSS VSS gf180mcu_fd_sc_mcu7t5v0__fillcap_8
XFILLER_42_430 VDD VDD VSS VSS gf180mcu_fd_sc_mcu7t5v0__fill_2
XFILLER_42_441 VDD VDD VSS VSS gf180mcu_fd_sc_mcu7t5v0__fillcap_8
Xinput15 tl_d_dmem_i[21] input15/Z VDD VDD VSS VSS gf180mcu_fd_sc_mcu7t5v0__dlyd_1
Xinput26 tl_d_dmem_i[31] input26/Z VDD VDD VSS VSS gf180mcu_fd_sc_mcu7t5v0__dlyd_1
Xinput37 tl_d_dmem_i[41] input37/Z VDD VDD VSS VSS gf180mcu_fd_sc_mcu7t5v0__dlyd_1
Xinput48 tl_d_dmem_i[51] input48/Z VDD VDD VSS VSS gf180mcu_fd_sc_mcu7t5v0__dlyd_1
Xinput59 tl_d_dmem_i[61] input59/Z VDD VDD VSS VSS gf180mcu_fd_sc_mcu7t5v0__dlyd_1
XTAP_TAPCELL_ROW_12_399 VDD VSS gf180mcu_fd_sc_mcu7t5v0__filltie
X_2340_ _2340_/A1 _2340_/A2 _2376_/B _2340_/ZN VDD VDD VSS VSS gf180mcu_fd_sc_mcu7t5v0__aoi21_1
XFILLER_97_625 VDD VDD VSS VSS gf180mcu_fd_sc_mcu7t5v0__fill_1
XFILLER_69_316 VDD VDD VSS VSS gf180mcu_fd_sc_mcu7t5v0__fillcap_32
X_2271_ input80/Z _2363_/A2 _2295_/A3 _2272_/A2 VDD VDD VSS VSS gf180mcu_fd_sc_mcu7t5v0__nand3_1
X_1222_ _1222_/A1 _1641_/A2 _2772_/I VDD VDD VSS VSS gf180mcu_fd_sc_mcu7t5v0__nor2_1
XFILLER_65_500 VDD VDD VSS VSS gf180mcu_fd_sc_mcu7t5v0__fillcap_32
XFILLER_93_842 VDD VDD VSS VSS gf180mcu_fd_sc_mcu7t5v0__fillcap_4
X_1153_ _2590_/Q _2589_/Q _2597_/Q _1153_/Z VDD VDD VSS VSS gf180mcu_fd_sc_mcu7t5v0__or3_1
XFILLER_93_864 VDD VDD VSS VSS gf180mcu_fd_sc_mcu7t5v0__fill_2
XFILLER_25_419 VDD VDD VSS VSS gf180mcu_fd_sc_mcu7t5v0__fill_1
X_1084_ _1084_/I _1653_/A1 VDD VDD VSS VSS gf180mcu_fd_sc_mcu7t5v0__clkinv_1
XFILLER_45_290 VDD VDD VSS VSS gf180mcu_fd_sc_mcu7t5v0__fill_2
XFILLER_61_772 VDD VDD VSS VSS gf180mcu_fd_sc_mcu7t5v0__fillcap_32
X_1986_ _1986_/A1 _2030_/A2 _2014_/B1 _2725_/I _1987_/I VDD VDD VSS VSS gf180mcu_fd_sc_mcu7t5v0__aoi22_1
XTAP_TAPCELL_ROW_31_631 VDD VSS gf180mcu_fd_sc_mcu7t5v0__filltie
X_2538_ _1158_/Z _2538_/A2 _2538_/ZN VDD VDD VSS VSS gf180mcu_fd_sc_mcu7t5v0__nand2_1
XFILLER_102_424 VDD VDD VSS VSS gf180mcu_fd_sc_mcu7t5v0__fillcap_8
Xinput408 tl_h_i_i[22] _1898_/A1 VDD VDD VSS VSS gf180mcu_fd_sc_mcu7t5v0__dlyd_1
Xinput419 tl_h_i_i[32] _1918_/A1 VDD VDD VSS VSS gf180mcu_fd_sc_mcu7t5v0__dlyd_1
XFILLER_102_457 VDD VDD VSS VSS gf180mcu_fd_sc_mcu7t5v0__fillcap_8
X_2469_ _2764_/I _2579_/Q _2476_/S _2579_/D VDD VDD VSS VSS gf180mcu_fd_sc_mcu7t5v0__mux2_2
XFILLER_56_522 VDD VDD VSS VSS gf180mcu_fd_sc_mcu7t5v0__fill_2
XTAP_TAPCELL_ROW_39_720 VDD VSS gf180mcu_fd_sc_mcu7t5v0__filltie
XFILLER_84_831 VDD VDD VSS VSS gf180mcu_fd_sc_mcu7t5v0__fill_1
XFILLER_43_205 VDD VDD VSS VSS gf180mcu_fd_sc_mcu7t5v0__fillcap_4
XFILLER_83_352 VDD VDD VSS VSS gf180mcu_fd_sc_mcu7t5v0__fillcap_16
XTAP_TAPCELL_ROW_104_1501 VDD VSS gf180mcu_fd_sc_mcu7t5v0__filltie
XFILLER_71_558 VDD VDD VSS VSS gf180mcu_fd_sc_mcu7t5v0__fill_2
XFILLER_51_282 VDD VDD VSS VSS gf180mcu_fd_sc_mcu7t5v0__fillcap_64
XTAP_TAPCELL_ROW_115_1641 VDD VSS gf180mcu_fd_sc_mcu7t5v0__filltie
XFILLER_0_2 VDD VDD VSS VSS gf180mcu_fd_sc_mcu7t5v0__fillcap_32
Xfanout1124 _1248_/ZN _1510_/A2 VDD VDD VSS VSS gf180mcu_fd_sc_mcu7t5v0__dlyd_1
Xfanout1146 _2378_/A1 _2302_/A1 VDD VDD VSS VSS gf180mcu_fd_sc_mcu7t5v0__dlyd_1
XFILLER_47_500 VDD VDD VSS VSS gf180mcu_fd_sc_mcu7t5v0__fillcap_4
Xfanout1168 _1110_/ZN _2199_/A2 VDD VDD VSS VSS gf180mcu_fd_sc_mcu7t5v0__dlyd_1
Xwire1230 _1700_/B2 _2709_/I VDD VDD VSS VSS gf180mcu_fd_sc_mcu7t5v0__clkbuf_8
Xwire1241 _2550_/RN _2580_/RN VDD VDD VSS VSS gf180mcu_fd_sc_mcu7t5v0__clkbuf_4
XFILLER_75_842 VDD VDD VSS VSS gf180mcu_fd_sc_mcu7t5v0__fillcap_16
XFILLER_90_823 VDD VDD VSS VSS gf180mcu_fd_sc_mcu7t5v0__fillcap_8
XTAP_TAPCELL_ROW_17_458 VDD VSS gf180mcu_fd_sc_mcu7t5v0__filltie
X_1840_ _2393_/I0 _1854_/A2 _1850_/B1 _2764_/I _1841_/I VDD VDD VSS VSS gf180mcu_fd_sc_mcu7t5v0__aoi22_1
X_1771_ _1771_/I _1771_/ZN VDD VDD VSS VSS gf180mcu_fd_sc_mcu7t5v0__clkinv_1
XTAP_TAPCELL_ROW_77_1179 VDD VSS gf180mcu_fd_sc_mcu7t5v0__filltie
X_2323_ input94/Z _2323_/A2 _2375_/A3 _2324_/A2 VDD VDD VSS VSS gf180mcu_fd_sc_mcu7t5v0__nand3_1
XTAP_TAPCELL_ROW_90_1335 VDD VSS gf180mcu_fd_sc_mcu7t5v0__filltie
XFILLER_97_422 VDD VDD VSS VSS gf180mcu_fd_sc_mcu7t5v0__fillcap_8
XFILLER_66_831 VDD VDD VSS VSS gf180mcu_fd_sc_mcu7t5v0__fill_1
X_2254_ input75/Z _2323_/A2 _2295_/A3 _2256_/A2 VDD VDD VSS VSS gf180mcu_fd_sc_mcu7t5v0__nand3_1
XFILLER_97_488 VDD VDD VSS VSS gf180mcu_fd_sc_mcu7t5v0__fill_2
X_2185_ input45/Z _2236_/A2 _2236_/B _2186_/B2 VDD VDD VSS VSS gf180mcu_fd_sc_mcu7t5v0__aoi21_1
X_1205_ _2485_/A2 _2485_/A3 _2517_/B VDD VDD VSS VSS gf180mcu_fd_sc_mcu7t5v0__nand2_1
XFILLER_65_352 VDD VDD VSS VSS gf180mcu_fd_sc_mcu7t5v0__fillcap_64
X_1136_ _2740_/I _1142_/A2 _1143_/A3 _1143_/A4 _1146_/A1 VDD VDD VSS VSS gf180mcu_fd_sc_mcu7t5v0__nand4_1
X_1067_ _2590_/Q _2482_/B VDD VDD VSS VSS gf180mcu_fd_sc_mcu7t5v0__clkinv_1
XFILLER_21_422 VDD VDD VSS VSS gf180mcu_fd_sc_mcu7t5v0__fillcap_16
XFILLER_33_260 VDD VDD VSS VSS gf180mcu_fd_sc_mcu7t5v0__fillcap_4
XFILLER_33_282 VDD VDD VSS VSS gf180mcu_fd_sc_mcu7t5v0__fillcap_4
X_1969_ _1969_/I _1969_/ZN VDD VDD VSS VSS gf180mcu_fd_sc_mcu7t5v0__clkinv_1
XFILLER_48_308 VDD VDD VSS VSS gf180mcu_fd_sc_mcu7t5v0__fillcap_4
Xinput205 tl_d_uart_i[14] _1095_/I VDD VDD VSS VSS gf180mcu_fd_sc_mcu7t5v0__dlyd_1
Xinput216 tl_d_uart_i[24] _1326_/A1 VDD VDD VSS VSS gf180mcu_fd_sc_mcu7t5v0__dlyd_1
Xinput227 tl_d_uart_i[34] _1406_/A1 VDD VDD VSS VSS gf180mcu_fd_sc_mcu7t5v0__dlyd_1
Xinput238 tl_d_uart_i[44] _1486_/A1 VDD VDD VSS VSS gf180mcu_fd_sc_mcu7t5v0__dlyd_1
Xinput249 tl_d_uart_i[54] _1100_/I VDD VDD VSS VSS gf180mcu_fd_sc_mcu7t5v0__dlyd_1
XTAP_TAPCELL_ROW_110_1582 VDD VSS gf180mcu_fd_sc_mcu7t5v0__filltie
XTAP_TAPCELL_ROW_110_1571 VDD VSS gf180mcu_fd_sc_mcu7t5v0__filltie
XFILLER_57_842 VDD VDD VSS VSS gf180mcu_fd_sc_mcu7t5v0__fill_2
XFILLER_57_864 VDD VDD VSS VSS gf180mcu_fd_sc_mcu7t5v0__fill_2
XFILLER_75_138 VDD VDD VSS VSS gf180mcu_fd_sc_mcu7t5v0__fill_2
XFILLER_56_363 VDD VDD VSS VSS gf180mcu_fd_sc_mcu7t5v0__fillcap_16
XFILLER_84_661 VDD VDD VSS VSS gf180mcu_fd_sc_mcu7t5v0__fillcap_4
XFILLER_72_823 VDD VDD VSS VSS gf180mcu_fd_sc_mcu7t5v0__fillcap_8
XFILLER_72_801 VDD VDD VSS VSS gf180mcu_fd_sc_mcu7t5v0__fillcap_4
XFILLER_44_547 VDD VDD VSS VSS gf180mcu_fd_sc_mcu7t5v0__fill_1
XTAP_TAPCELL_ROW_14_428 VDD VSS gf180mcu_fd_sc_mcu7t5v0__filltie
XFILLER_52_591 VDD VDD VSS VSS gf180mcu_fd_sc_mcu7t5v0__fillcap_4
XTAP_TAPCELL_ROW_42_759 VDD VSS gf180mcu_fd_sc_mcu7t5v0__filltie
XFILLER_79_422 VDD VDD VSS VSS gf180mcu_fd_sc_mcu7t5v0__fillcap_64
XFILLER_0_860 VDD VDD VSS VSS gf180mcu_fd_sc_mcu7t5v0__fillcap_4
XFILLER_58_71 VDD VDD VSS VSS gf180mcu_fd_sc_mcu7t5v0__fillcap_8
XFILLER_48_831 VDD VDD VSS VSS gf180mcu_fd_sc_mcu7t5v0__fill_1
XFILLER_59_190 VDD VDD VSS VSS gf180mcu_fd_sc_mcu7t5v0__fill_2
XFILLER_47_341 VDD VDD VSS VSS gf180mcu_fd_sc_mcu7t5v0__fill_1
XFILLER_47_352 VDD VDD VSS VSS gf180mcu_fd_sc_mcu7t5v0__fill_1
XFILLER_62_333 VDD VDD VSS VSS gf180mcu_fd_sc_mcu7t5v0__fillcap_8
XFILLER_90_653 VDD VDD VSS VSS gf180mcu_fd_sc_mcu7t5v0__fillcap_4
XFILLER_50_539 VDD VDD VSS VSS gf180mcu_fd_sc_mcu7t5v0__fill_2
XFILLER_30_263 VDD VDD VSS VSS gf180mcu_fd_sc_mcu7t5v0__fillcap_4
X_1823_ _1823_/I _1823_/ZN VDD VDD VSS VSS gf180mcu_fd_sc_mcu7t5v0__clkinv_1
XTAP_TAPCELL_ROW_79_1208 VDD VSS gf180mcu_fd_sc_mcu7t5v0__filltie
X_1754_ _1944_/A1 _1772_/A2 _1762_/B1 _1944_/B2 _1755_/I VDD VDD VSS VSS gf180mcu_fd_sc_mcu7t5v0__aoi22_1
X_1685_ _1685_/I _1685_/ZN VDD VDD VSS VSS gf180mcu_fd_sc_mcu7t5v0__clkinv_1
XPHY_EDGE_ROW_115_Right_115 VDD VSS gf180mcu_fd_sc_mcu7t5v0__endcap
X_2306_ _2358_/A1 _2306_/A2 _2308_/A1 VDD VDD VSS VSS gf180mcu_fd_sc_mcu7t5v0__nand2_1
XFILLER_39_842 VDD VDD VSS VSS gf180mcu_fd_sc_mcu7t5v0__fill_1
XFILLER_57_138 VDD VDD VSS VSS gf180mcu_fd_sc_mcu7t5v0__fill_2
X_2237_ _2237_/A1 _2231_/C _2237_/B1 _2237_/B2 _2237_/ZN VDD VDD VSS VSS gf180mcu_fd_sc_mcu7t5v0__aoi22_1
XFILLER_54_801 VDD VDD VSS VSS gf180mcu_fd_sc_mcu7t5v0__fillcap_4
XFILLER_54_823 VDD VDD VSS VSS gf180mcu_fd_sc_mcu7t5v0__fillcap_8
XFILLER_65_182 VDD VDD VSS VSS gf180mcu_fd_sc_mcu7t5v0__fillcap_4
X_2168_ _2168_/A1 _2171_/B _2168_/B1 _2168_/B2 _2168_/ZN VDD VDD VSS VSS gf180mcu_fd_sc_mcu7t5v0__aoi22_1
XFILLER_81_620 VDD VDD VSS VSS gf180mcu_fd_sc_mcu7t5v0__fill_1
XFILLER_65_193 VDD VDD VSS VSS gf180mcu_fd_sc_mcu7t5v0__fillcap_4
X_2099_ _2540_/Q _2557_/Q _2221_/A1 _2375_/A2 _2377_/A1 _2218_/A1 _2100_/I VDD VDD
+ VSS VSS gf180mcu_fd_sc_mcu7t5v0__aoi222_1
X_1119_ _1257_/A1 _1116_/B _2170_/B1 _1119_/B2 _2170_/C _1120_/B VDD VDD VSS VSS gf180mcu_fd_sc_mcu7t5v0__oai221_1
XFILLER_81_664 VDD VDD VSS VSS gf180mcu_fd_sc_mcu7t5v0__fillcap_8
XFILLER_80_185 VDD VDD VSS VSS gf180mcu_fd_sc_mcu7t5v0__fill_2
XFILLER_22_731 VDD VDD VSS VSS gf180mcu_fd_sc_mcu7t5v0__fillcap_4
XPHY_EDGE_ROW_17_Right_17 VDD VSS gf180mcu_fd_sc_mcu7t5v0__endcap
XTAP_TAPCELL_ROW_112_1600 VDD VSS gf180mcu_fd_sc_mcu7t5v0__filltie
XFILLER_88_230 VDD VDD VSS VSS gf180mcu_fd_sc_mcu7t5v0__fillcap_8
XPHY_EDGE_ROW_26_Right_26 VDD VSS gf180mcu_fd_sc_mcu7t5v0__endcap
XFILLER_76_403 VDD VDD VSS VSS gf180mcu_fd_sc_mcu7t5v0__fillcap_4
XFILLER_48_149 VDD VDD VSS VSS gf180mcu_fd_sc_mcu7t5v0__fill_1
XFILLER_29_352 VDD VDD VSS VSS gf180mcu_fd_sc_mcu7t5v0__fillcap_8
Xload_slew1123 _1398_/A2 _1406_/A2 VDD VDD VSS VSS gf180mcu_fd_sc_mcu7t5v0__buf_4
XTAP_TAPCELL_ROW_47_818 VDD VSS gf180mcu_fd_sc_mcu7t5v0__filltie
Xload_slew1189 _2155_/B1 _2154_/A2 VDD VDD VSS VSS gf180mcu_fd_sc_mcu7t5v0__clkbuf_4
XFILLER_72_675 VDD VDD VSS VSS gf180mcu_fd_sc_mcu7t5v0__fillcap_4
XTAP_TAPCELL_ROW_63_1009 VDD VSS gf180mcu_fd_sc_mcu7t5v0__filltie
XTAP_TAPCELL_ROW_27_586 VDD VSS gf180mcu_fd_sc_mcu7t5v0__filltie
XTAP_TAPCELL_ROW_27_575 VDD VSS gf180mcu_fd_sc_mcu7t5v0__filltie
XPHY_EDGE_ROW_35_Right_35 VDD VSS gf180mcu_fd_sc_mcu7t5v0__endcap
Xoutput509 _2700_/Z tl_d_dmem_o[113] VDD VDD VSS VSS gf180mcu_fd_sc_mcu7t5v0__dlyd_1
X_1470_ _1470_/A1 _1486_/A2 _1470_/B1 _2208_/B _1471_/A2 VDD VDD VSS VSS gf180mcu_fd_sc_mcu7t5v0__aoi22_1
XTAP_TAPCELL_ROW_74_1149 VDD VSS gf180mcu_fd_sc_mcu7t5v0__filltie
XPHY_EDGE_ROW_44_Right_44 VDD VSS gf180mcu_fd_sc_mcu7t5v0__endcap
XFILLER_67_414 VDD VDD VSS VSS gf180mcu_fd_sc_mcu7t5v0__fillcap_4
XFILLER_67_436 VDD VDD VSS VSS gf180mcu_fd_sc_mcu7t5v0__fillcap_8
XFILLER_94_266 VDD VDD VSS VSS gf180mcu_fd_sc_mcu7t5v0__fill_1
XFILLER_36_823 VDD VDD VSS VSS gf180mcu_fd_sc_mcu7t5v0__fillcap_8
X_2022_ _2398_/I0 _2022_/A2 _2022_/B1 _2759_/I _2023_/I VDD VDD VSS VSS gf180mcu_fd_sc_mcu7t5v0__aoi22_1
XFILLER_63_697 VDD VDD VSS VSS gf180mcu_fd_sc_mcu7t5v0__fill_2
XTAP_TAPCELL_ROW_85_1278 VDD VSS gf180mcu_fd_sc_mcu7t5v0__filltie
XFILLER_16_591 VDD VDD VSS VSS gf180mcu_fd_sc_mcu7t5v0__fillcap_4
XPHY_EDGE_ROW_53_Right_53 VDD VSS gf180mcu_fd_sc_mcu7t5v0__endcap
X_1806_ _1996_/A1 _1822_/A2 _1814_/B1 _2730_/I _1807_/I VDD VDD VSS VSS gf180mcu_fd_sc_mcu7t5v0__aoi22_1
Xclkbuf_3_1__f_clk_i clkbuf_0_clk_i/Z clkload1/I VDD VDD VSS VSS gf180mcu_fd_sc_mcu7t5v0__clkbuf_16
X_1737_ _1737_/I _1737_/ZN VDD VDD VSS VSS gf180mcu_fd_sc_mcu7t5v0__clkinv_1
X_1668_ _1858_/A1 _1732_/A2 _1722_/B1 _1084_/I _1669_/I VDD VDD VSS VSS gf180mcu_fd_sc_mcu7t5v0__aoi22_1
XPHY_EDGE_ROW_62_Right_62 VDD VSS gf180mcu_fd_sc_mcu7t5v0__endcap
XFILLER_113_850 VDD VDD VSS VSS gf180mcu_fd_sc_mcu7t5v0__fillcap_16
X_1599_ _1597_/Z _1598_/Z _1599_/Z VDD VDD VSS VSS gf180mcu_fd_sc_mcu7t5v0__xor2_1
XFILLER_100_522 VDD VDD VSS VSS gf180mcu_fd_sc_mcu7t5v0__fill_2
XFILLER_85_244 VDD VDD VSS VSS gf180mcu_fd_sc_mcu7t5v0__fill_2
XFILLER_39_683 VDD VDD VSS VSS gf180mcu_fd_sc_mcu7t5v0__fillcap_16
XFILLER_66_491 VDD VDD VSS VSS gf180mcu_fd_sc_mcu7t5v0__fillcap_32
XFILLER_41_314 VDD VDD VSS VSS gf180mcu_fd_sc_mcu7t5v0__fillcap_8
XFILLER_53_174 VDD VDD VSS VSS gf180mcu_fd_sc_mcu7t5v0__fillcap_4
XPHY_EDGE_ROW_71_Right_71 VDD VSS gf180mcu_fd_sc_mcu7t5v0__endcap
XTAP_TAPCELL_ROW_24_545 VDD VSS gf180mcu_fd_sc_mcu7t5v0__filltie
XTAP_TAPCELL_ROW_52_876 VDD VSS gf180mcu_fd_sc_mcu7t5v0__filltie
XFILLER_10_734 VDD VDD VSS VSS gf180mcu_fd_sc_mcu7t5v0__fill_1
XPHY_EDGE_ROW_101_Left_220 VDD VSS gf180mcu_fd_sc_mcu7t5v0__endcap
XPHY_EDGE_ROW_80_Right_80 VDD VSS gf180mcu_fd_sc_mcu7t5v0__endcap
XFILLER_96_509 VDD VDD VSS VSS gf180mcu_fd_sc_mcu7t5v0__fillcap_4
XFILLER_49_403 VDD VDD VSS VSS gf180mcu_fd_sc_mcu7t5v0__fillcap_16
XFILLER_1_487 VDD VDD VSS VSS gf180mcu_fd_sc_mcu7t5v0__fill_2
XFILLER_49_436 VDD VDD VSS VSS gf180mcu_fd_sc_mcu7t5v0__fill_1
XFILLER_18_823 VDD VDD VSS VSS gf180mcu_fd_sc_mcu7t5v0__fillcap_8
XFILLER_44_174 VDD VDD VSS VSS gf180mcu_fd_sc_mcu7t5v0__fill_1
XFILLER_32_369 VDD VDD VSS VSS gf180mcu_fd_sc_mcu7t5v0__fill_1
XFILLER_60_667 VDD VDD VSS VSS gf180mcu_fd_sc_mcu7t5v0__fillcap_64
X_2640_ _2712_/I _2640_/Z VDD VDD VSS VSS gf180mcu_fd_sc_mcu7t5v0__buf_1
X_2571_ _2571_/D _2586_/RN clkload5/I _2571_/Q VDD VDD VSS VSS gf180mcu_fd_sc_mcu7t5v0__dffsnq_1
X_1522_ _1932_/B2 _1533_/A2 _1522_/Z VDD VDD VSS VSS gf180mcu_fd_sc_mcu7t5v0__or2_1
X_1453_ _1453_/I _1454_/B1 VDD VDD VSS VSS gf180mcu_fd_sc_mcu7t5v0__clkinv_1
X_1384_ _1384_/A1 _1496_/A2 _2317_/A2 VDD VDD VSS VSS gf180mcu_fd_sc_mcu7t5v0__nand2_1
XFILLER_68_734 VDD VDD VSS VSS gf180mcu_fd_sc_mcu7t5v0__fill_1
XFILLER_28_609 VDD VDD VSS VSS gf180mcu_fd_sc_mcu7t5v0__fillcap_32
XFILLER_36_664 VDD VDD VSS VSS gf180mcu_fd_sc_mcu7t5v0__fill_1
X_2005_ _2005_/I _2005_/ZN VDD VDD VSS VSS gf180mcu_fd_sc_mcu7t5v0__clkinv_1
XFILLER_82_247 VDD VDD VSS VSS gf180mcu_fd_sc_mcu7t5v0__fillcap_16
XFILLER_51_623 VDD VDD VSS VSS gf180mcu_fd_sc_mcu7t5v0__fillcap_4
XFILLER_31_380 VDD VDD VSS VSS gf180mcu_fd_sc_mcu7t5v0__fillcap_8
XFILLER_50_177 VDD VDD VSS VSS gf180mcu_fd_sc_mcu7t5v0__fillcap_8
XTAP_TAPCELL_ROW_21_504 VDD VSS gf180mcu_fd_sc_mcu7t5v0__filltie
XTAP_TAPCELL_ROW_98_1436 VDD VSS gf180mcu_fd_sc_mcu7t5v0__filltie
X_2769_ _2769_/I _2769_/Z VDD VDD VSS VSS gf180mcu_fd_sc_mcu7t5v0__buf_1
Xoutput873 _1650_/Z tl_d_uart_o[59] VDD VDD VSS VSS gf180mcu_fd_sc_mcu7t5v0__dlyd_1
Xoutput862 _1640_/Z tl_d_uart_o[49] VDD VDD VSS VSS gf180mcu_fd_sc_mcu7t5v0__dlyd_1
Xoutput851 _1630_/Z tl_d_uart_o[39] VDD VDD VSS VSS gf180mcu_fd_sc_mcu7t5v0__dlyd_1
Xoutput840 _1620_/Z tl_d_uart_o[29] VDD VDD VSS VSS gf180mcu_fd_sc_mcu7t5v0__dlyd_1
Xoutput895 _2738_/Z tl_d_uart_o[79] VDD VDD VSS VSS gf180mcu_fd_sc_mcu7t5v0__dlyd_1
Xoutput884 _2728_/Z tl_d_uart_o[69] VDD VDD VSS VSS gf180mcu_fd_sc_mcu7t5v0__dlyd_1
XFILLER_101_842 VDD VDD VSS VSS gf180mcu_fd_sc_mcu7t5v0__fillcap_4
XFILLER_59_734 VDD VDD VSS VSS gf180mcu_fd_sc_mcu7t5v0__fill_2
XFILLER_100_341 VDD VDD VSS VSS gf180mcu_fd_sc_mcu7t5v0__fillcap_4
XFILLER_58_244 VDD VDD VSS VSS gf180mcu_fd_sc_mcu7t5v0__fill_1
XTAP_TAPCELL_ROW_57_946 VDD VSS gf180mcu_fd_sc_mcu7t5v0__filltie
XTAP_TAPCELL_ROW_57_935 VDD VSS gf180mcu_fd_sc_mcu7t5v0__filltie
XTAP_TAPCELL_ROW_29_604 VDD VSS gf180mcu_fd_sc_mcu7t5v0__filltie
XFILLER_86_597 VDD VDD VSS VSS gf180mcu_fd_sc_mcu7t5v0__fillcap_64
XFILLER_86_586 VDD VDD VSS VSS gf180mcu_fd_sc_mcu7t5v0__fill_1
XFILLER_74_737 VDD VDD VSS VSS gf180mcu_fd_sc_mcu7t5v0__fillcap_32
XTAP_TAPCELL_ROW_107_1543 VDD VSS gf180mcu_fd_sc_mcu7t5v0__filltie
XFILLER_42_601 VDD VDD VSS VSS gf180mcu_fd_sc_mcu7t5v0__fill_1
XTAP_TAPCELL_ROW_1_273 VDD VSS gf180mcu_fd_sc_mcu7t5v0__filltie
XFILLER_30_807 VDD VDD VSS VSS gf180mcu_fd_sc_mcu7t5v0__fillcap_16
XFILLER_41_155 VDD VDD VSS VSS gf180mcu_fd_sc_mcu7t5v0__fillcap_32
XFILLER_42_667 VDD VDD VSS VSS gf180mcu_fd_sc_mcu7t5v0__fillcap_64
XFILLER_10_597 VDD VDD VSS VSS gf180mcu_fd_sc_mcu7t5v0__fillcap_32
XTAP_TAPCELL_ROW_118_1672 VDD VSS gf180mcu_fd_sc_mcu7t5v0__filltie
XTAP_TAPCELL_ROW_118_1683 VDD VSS gf180mcu_fd_sc_mcu7t5v0__filltie
XTAP_TAPCELL_ROW_71_1108 VDD VSS gf180mcu_fd_sc_mcu7t5v0__filltie
XTAP_TAPCELL_ROW_9_362 VDD VSS gf180mcu_fd_sc_mcu7t5v0__filltie
XFILLER_96_317 VDD VDD VSS VSS gf180mcu_fd_sc_mcu7t5v0__fillcap_64
XFILLER_49_277 VDD VDD VSS VSS gf180mcu_fd_sc_mcu7t5v0__fill_2
XFILLER_66_71 VDD VDD VSS VSS gf180mcu_fd_sc_mcu7t5v0__fillcap_8
XTAP_TAPCELL_ROW_82_1237 VDD VSS gf180mcu_fd_sc_mcu7t5v0__filltie
XANTENNA_18 tl_h_i_i[86] VDD VDD VSS VSS gf180mcu_fd_sc_mcu7t5v0__antenna
XANTENNA_29 _2705_/I VDD VDD VSS VSS gf180mcu_fd_sc_mcu7t5v0__antenna
XFILLER_20_317 VDD VDD VSS VSS gf180mcu_fd_sc_mcu7t5v0__fillcap_8
X_2554_ _2554_/D _2588_/RN clkload4/I _2554_/Q VDD VDD VSS VSS gf180mcu_fd_sc_mcu7t5v0__dffrnq_1
X_1505_ _2218_/A2 _2377_/A2 _1505_/Z VDD VDD VSS VSS gf180mcu_fd_sc_mcu7t5v0__and2_1
XTAP_TAPCELL_ROW_93_1377 VDD VSS gf180mcu_fd_sc_mcu7t5v0__filltie
XFILLER_88_807 VDD VDD VSS VSS gf180mcu_fd_sc_mcu7t5v0__fillcap_16
X_2485_ _2482_/B _2485_/A2 _2485_/A3 _2492_/A2 VDD VDD VSS VSS gf180mcu_fd_sc_mcu7t5v0__nand3_1
XFILLER_68_531 VDD VDD VSS VSS gf180mcu_fd_sc_mcu7t5v0__fill_2
X_1436_ input33/Z _1500_/A2 _1436_/B1 _1476_/B2 _1437_/I VDD VDD VSS VSS gf180mcu_fd_sc_mcu7t5v0__aoi22_1
XFILLER_68_564 VDD VDD VSS VSS gf180mcu_fd_sc_mcu7t5v0__fill_2
X_1367_ _1487_/A1 _1367_/A2 _1367_/ZN VDD VDD VSS VSS gf180mcu_fd_sc_mcu7t5v0__nor2_1
XFILLER_56_737 VDD VDD VSS VSS gf180mcu_fd_sc_mcu7t5v0__fillcap_64
XFILLER_68_597 VDD VDD VSS VSS gf180mcu_fd_sc_mcu7t5v0__fillcap_16
X_1298_ input81/Z _2116_/B1 _2259_/A3 _1299_/B VDD VDD VSS VSS gf180mcu_fd_sc_mcu7t5v0__nand3_1
XTAP_TAPCELL_ROW_54_905 VDD VSS gf180mcu_fd_sc_mcu7t5v0__filltie
XFILLER_12_807 VDD VDD VSS VSS gf180mcu_fd_sc_mcu7t5v0__fillcap_16
XFILLER_24_667 VDD VDD VSS VSS gf180mcu_fd_sc_mcu7t5v0__fillcap_64
XFILLER_51_486 VDD VDD VSS VSS gf180mcu_fd_sc_mcu7t5v0__fillcap_4
XTAP_TAPCELL_ROW_34_662 VDD VSS gf180mcu_fd_sc_mcu7t5v0__filltie
XTAP_TAPCELL_ROW_102_1484 VDD VSS gf180mcu_fd_sc_mcu7t5v0__filltie
XFILLER_105_422 VDD VDD VSS VSS gf180mcu_fd_sc_mcu7t5v0__fillcap_8
Xoutput681 _1981_/ZN tl_d_esram_o[63] VDD VDD VSS VSS gf180mcu_fd_sc_mcu7t5v0__dlyd_1
Xoutput670 _1961_/ZN tl_d_esram_o[53] VDD VDD VSS VSS gf180mcu_fd_sc_mcu7t5v0__dlyd_1
XFILLER_78_317 VDD VDD VSS VSS gf180mcu_fd_sc_mcu7t5v0__fillcap_8
Xoutput692 _2001_/ZN tl_d_esram_o[73] VDD VDD VSS VSS gf180mcu_fd_sc_mcu7t5v0__dlyd_1
XTAP_TAPCELL_ROW_6_332 VDD VSS gf180mcu_fd_sc_mcu7t5v0__filltie
XFILLER_59_575 VDD VDD VSS VSS gf180mcu_fd_sc_mcu7t5v0__fillcap_32
XFILLER_46_247 VDD VDD VSS VSS gf180mcu_fd_sc_mcu7t5v0__fillcap_32
XFILLER_61_206 VDD VDD VSS VSS gf180mcu_fd_sc_mcu7t5v0__fillcap_4
XFILLER_62_729 VDD VDD VSS VSS gf180mcu_fd_sc_mcu7t5v0__fillcap_4
XFILLER_61_228 VDD VDD VSS VSS gf180mcu_fd_sc_mcu7t5v0__fillcap_4
XTAP_TAPCELL_ROW_68_1070 VDD VSS gf180mcu_fd_sc_mcu7t5v0__filltie
XFILLER_42_453 VDD VDD VSS VSS gf180mcu_fd_sc_mcu7t5v0__fill_2
XFILLER_11_851 VDD VDD VSS VSS gf180mcu_fd_sc_mcu7t5v0__fillcap_8
Xinput16 tl_d_dmem_i[22] input16/Z VDD VDD VSS VSS gf180mcu_fd_sc_mcu7t5v0__dlyd_1
Xinput27 tl_d_dmem_i[32] input27/Z VDD VDD VSS VSS gf180mcu_fd_sc_mcu7t5v0__dlyd_1
Xinput38 tl_d_dmem_i[42] input38/Z VDD VDD VSS VSS gf180mcu_fd_sc_mcu7t5v0__dlyd_1
Xinput49 tl_d_dmem_i[52] input49/Z VDD VDD VSS VSS gf180mcu_fd_sc_mcu7t5v0__dlyd_1
X_2270_ _2282_/A1 _2270_/A2 _2272_/A1 VDD VDD VSS VSS gf180mcu_fd_sc_mcu7t5v0__nand2_1
X_1221_ _1202_/B _1221_/A2 _1221_/ZN VDD VDD VSS VSS gf180mcu_fd_sc_mcu7t5v0__nand2_1
XFILLER_38_737 VDD VDD VSS VSS gf180mcu_fd_sc_mcu7t5v0__fillcap_64
X_1152_ _2592_/Q _2591_/Q _1152_/Z VDD VDD VSS VSS gf180mcu_fd_sc_mcu7t5v0__or2_1
XFILLER_25_409 VDD VDD VSS VSS gf180mcu_fd_sc_mcu7t5v0__fill_1
X_1083_ _2705_/I _2467_/A2 VDD VDD VSS VSS gf180mcu_fd_sc_mcu7t5v0__clkinv_1
XFILLER_80_515 VDD VDD VSS VSS gf180mcu_fd_sc_mcu7t5v0__fill_2
XFILLER_52_228 VDD VDD VSS VSS gf180mcu_fd_sc_mcu7t5v0__fill_2
XFILLER_80_548 VDD VDD VSS VSS gf180mcu_fd_sc_mcu7t5v0__fillcap_4
XFILLER_21_626 VDD VDD VSS VSS gf180mcu_fd_sc_mcu7t5v0__fillcap_4
XFILLER_33_486 VDD VDD VSS VSS gf180mcu_fd_sc_mcu7t5v0__fillcap_4
X_1985_ _1985_/I _1985_/ZN VDD VDD VSS VSS gf180mcu_fd_sc_mcu7t5v0__clkinv_1
XTAP_TAPCELL_ROW_31_632 VDD VSS gf180mcu_fd_sc_mcu7t5v0__filltie
X_2537_ _1077_/I _2537_/A2 _2537_/B _2601_/D VDD VDD VSS VSS gf180mcu_fd_sc_mcu7t5v0__aoi21_1
XFILLER_102_436 VDD VDD VSS VSS gf180mcu_fd_sc_mcu7t5v0__fill_1
Xinput409 tl_h_i_i[23] _1900_/A1 VDD VDD VSS VSS gf180mcu_fd_sc_mcu7t5v0__dlyd_1
X_2468_ _2477_/S _2468_/A2 _2578_/D VDD VDD VSS VSS gf180mcu_fd_sc_mcu7t5v0__nand2_1
X_1419_ _1499_/A1 _1417_/Z _1419_/B _1420_/B1 VDD VDD VSS VSS gf180mcu_fd_sc_mcu7t5v0__oai21_1
X_2399_ _2399_/I0 _2555_/Q _2401_/S _2555_/D VDD VDD VSS VSS gf180mcu_fd_sc_mcu7t5v0__mux2_2
XTAP_TAPCELL_ROW_39_721 VDD VSS gf180mcu_fd_sc_mcu7t5v0__filltie
XFILLER_56_567 VDD VDD VSS VSS gf180mcu_fd_sc_mcu7t5v0__fillcap_16
XTAP_TAPCELL_ROW_104_1502 VDD VSS gf180mcu_fd_sc_mcu7t5v0__filltie
XFILLER_24_442 VDD VDD VSS VSS gf180mcu_fd_sc_mcu7t5v0__fillcap_8
XTAP_TAPCELL_ROW_115_1642 VDD VSS gf180mcu_fd_sc_mcu7t5v0__filltie
XTAP_TAPCELL_ROW_115_1631 VDD VSS gf180mcu_fd_sc_mcu7t5v0__filltie
Xfanout1103 _1665_/S _1641_/A2 VDD VDD VSS VSS gf180mcu_fd_sc_mcu7t5v0__dlyd_1
Xfanout1114 _1475_/A1 _1507_/A1 VDD VDD VSS VSS gf180mcu_fd_sc_mcu7t5v0__dlyd_1
Xfanout1136 _1854_/B1 _1850_/B1 VDD VDD VSS VSS gf180mcu_fd_sc_mcu7t5v0__dlyd_1
Xfanout1158 _2246_/B1 _1490_/A2 VDD VDD VSS VSS gf180mcu_fd_sc_mcu7t5v0__dlyd_1
Xfanout1169 _2160_/C _1390_/B2 VDD VDD VSS VSS gf180mcu_fd_sc_mcu7t5v0__dlyd_1
Xwire1231 _1698_/B2 _2708_/I VDD VDD VSS VSS gf180mcu_fd_sc_mcu7t5v0__clkbuf_8
XFILLER_94_629 VDD VDD VSS VSS gf180mcu_fd_sc_mcu7t5v0__fillcap_4
XFILLER_87_670 VDD VDD VSS VSS gf180mcu_fd_sc_mcu7t5v0__fill_1
XFILLER_86_191 VDD VDD VSS VSS gf180mcu_fd_sc_mcu7t5v0__fill_1
XFILLER_47_578 VDD VDD VSS VSS gf180mcu_fd_sc_mcu7t5v0__fillcap_8
XFILLER_62_515 VDD VDD VSS VSS gf180mcu_fd_sc_mcu7t5v0__fillcap_8
XFILLER_74_353 VDD VDD VSS VSS gf180mcu_fd_sc_mcu7t5v0__fillcap_4
XTAP_TAPCELL_ROW_17_459 VDD VSS gf180mcu_fd_sc_mcu7t5v0__filltie
XFILLER_15_486 VDD VDD VSS VSS gf180mcu_fd_sc_mcu7t5v0__fillcap_4
XFILLER_63_72 VDD VDD VSS VSS gf180mcu_fd_sc_mcu7t5v0__fillcap_32
X_1770_ _1960_/A1 _1772_/A2 _1772_/B1 _1960_/B2 _1771_/I VDD VDD VSS VSS gf180mcu_fd_sc_mcu7t5v0__aoi22_1
X_2322_ _2378_/A1 _2322_/A2 _2324_/A1 VDD VDD VSS VSS gf180mcu_fd_sc_mcu7t5v0__nand2_1
XTAP_TAPCELL_ROW_90_1336 VDD VSS gf180mcu_fd_sc_mcu7t5v0__filltie
XFILLER_97_434 VDD VDD VSS VSS gf180mcu_fd_sc_mcu7t5v0__fill_2
XFILLER_26_2 VDD VDD VSS VSS gf180mcu_fd_sc_mcu7t5v0__fillcap_8
X_2253_ _2253_/A1 _2282_/A1 _2256_/A1 VDD VDD VSS VSS gf180mcu_fd_sc_mcu7t5v0__nand2_1
XFILLER_85_629 VDD VDD VSS VSS gf180mcu_fd_sc_mcu7t5v0__fill_1
X_2184_ _2184_/A1 _1116_/B _2215_/B _2184_/C _2186_/B1 VDD VDD VSS VSS gf180mcu_fd_sc_mcu7t5v0__oai211_1
X_1204_ _1204_/A1 _1202_/B _1204_/B _2485_/A3 VDD VDD VSS VSS gf180mcu_fd_sc_mcu7t5v0__aoi21_1
XFILLER_77_191 VDD VDD VSS VSS gf180mcu_fd_sc_mcu7t5v0__fillcap_16
XFILLER_77_180 VDD VDD VSS VSS gf180mcu_fd_sc_mcu7t5v0__fill_2
X_1135_ _2740_/I _1142_/A2 _1143_/A3 _1143_/A4 _1135_/Z VDD VDD VSS VSS gf180mcu_fd_sc_mcu7t5v0__and4_1
X_1066_ _1066_/I _2067_/B VDD VDD VSS VSS gf180mcu_fd_sc_mcu7t5v0__clkinv_1
XTAP_TAPCELL_ROW_44_790 VDD VSS gf180mcu_fd_sc_mcu7t5v0__filltie
X_1968_ _1968_/A1 _1982_/A2 _1998_/B1 _1968_/B2 _1969_/I VDD VDD VSS VSS gf180mcu_fd_sc_mcu7t5v0__aoi22_1
X_1899_ _1899_/I _1899_/ZN VDD VDD VSS VSS gf180mcu_fd_sc_mcu7t5v0__clkinv_1
XFILLER_0_338 VDD VDD VSS VSS gf180mcu_fd_sc_mcu7t5v0__fill_2
Xinput206 tl_d_uart_i[15] _2175_/A1 VDD VDD VSS VSS gf180mcu_fd_sc_mcu7t5v0__dlyd_1
Xinput217 tl_d_uart_i[25] _1334_/A1 VDD VDD VSS VSS gf180mcu_fd_sc_mcu7t5v0__dlyd_1
Xinput228 tl_d_uart_i[35] _1414_/A1 VDD VDD VSS VSS gf180mcu_fd_sc_mcu7t5v0__dlyd_1
Xinput239 tl_d_uart_i[45] _1494_/A1 VDD VDD VSS VSS gf180mcu_fd_sc_mcu7t5v0__dlyd_1
XTAP_TAPCELL_ROW_110_1572 VDD VSS gf180mcu_fd_sc_mcu7t5v0__filltie
XFILLER_69_681 VDD VDD VSS VSS gf180mcu_fd_sc_mcu7t5v0__fillcap_4
XFILLER_29_556 VDD VDD VSS VSS gf180mcu_fd_sc_mcu7t5v0__fillcap_4
XFILLER_56_342 VDD VDD VSS VSS gf180mcu_fd_sc_mcu7t5v0__fill_1
XTAP_TAPCELL_ROW_65_1040 VDD VSS gf180mcu_fd_sc_mcu7t5v0__filltie
XTAP_TAPCELL_ROW_14_429 VDD VSS gf180mcu_fd_sc_mcu7t5v0__filltie
XFILLER_67_629 VDD VDD VSS VSS gf180mcu_fd_sc_mcu7t5v0__fill_1
XFILLER_47_331 VDD VDD VSS VSS gf180mcu_fd_sc_mcu7t5v0__fillcap_8
XFILLER_74_150 VDD VDD VSS VSS gf180mcu_fd_sc_mcu7t5v0__fill_2
XFILLER_43_570 VDD VDD VSS VSS gf180mcu_fd_sc_mcu7t5v0__fillcap_4
XFILLER_62_378 VDD VDD VSS VSS gf180mcu_fd_sc_mcu7t5v0__fillcap_4
XFILLER_30_242 VDD VDD VSS VSS gf180mcu_fd_sc_mcu7t5v0__fill_2
X_1822_ _2012_/A1 _1822_/A2 _2533_/A2 _2738_/I _1823_/I VDD VDD VSS VSS gf180mcu_fd_sc_mcu7t5v0__aoi22_1
XTAP_TAPCELL_ROW_79_1209 VDD VSS gf180mcu_fd_sc_mcu7t5v0__filltie
X_1753_ _1753_/I _1753_/ZN VDD VDD VSS VSS gf180mcu_fd_sc_mcu7t5v0__clkinv_1
X_1684_ _1874_/A1 _1722_/A2 _1720_/B1 _1874_/B2 _1685_/I VDD VDD VSS VSS gf180mcu_fd_sc_mcu7t5v0__aoi22_1
X_2305_ _2357_/A1 _2305_/A2 _2306_/A2 VDD VDD VSS VSS gf180mcu_fd_sc_mcu7t5v0__nand2_1
XFILLER_85_404 VDD VDD VSS VSS gf180mcu_fd_sc_mcu7t5v0__fill_1
X_2236_ input55/Z _2236_/A2 _2236_/B _2237_/B2 VDD VDD VSS VSS gf180mcu_fd_sc_mcu7t5v0__aoi21_1
XFILLER_39_865 VDD VDD VSS VSS gf180mcu_fd_sc_mcu7t5v0__fill_1
X_2167_ input6/Z _2236_/A2 _2171_/B _2168_/B2 VDD VDD VSS VSS gf180mcu_fd_sc_mcu7t5v0__aoi21_1
XFILLER_93_492 VDD VDD VSS VSS gf180mcu_fd_sc_mcu7t5v0__fillcap_4
XFILLER_81_632 VDD VDD VSS VSS gf180mcu_fd_sc_mcu7t5v0__fillcap_32
XFILLER_53_334 VDD VDD VSS VSS gf180mcu_fd_sc_mcu7t5v0__fillcap_16
X_2098_ _2098_/A1 _2098_/A2 _2098_/ZN VDD VDD VSS VSS gf180mcu_fd_sc_mcu7t5v0__nand2_1
X_1118_ _2569_/Q _2246_/A2 _2235_/B VDD VDD VSS VSS gf180mcu_fd_sc_mcu7t5v0__nand2_1
XFILLER_41_518 VDD VDD VSS VSS gf180mcu_fd_sc_mcu7t5v0__fillcap_32
XFILLER_81_698 VDD VDD VSS VSS gf180mcu_fd_sc_mcu7t5v0__fill_2
XFILLER_34_592 VDD VDD VSS VSS gf180mcu_fd_sc_mcu7t5v0__fill_2
XFILLER_70_18 VDD VDD VSS VSS gf180mcu_fd_sc_mcu7t5v0__fillcap_8
XFILLER_21_286 VDD VDD VSS VSS gf180mcu_fd_sc_mcu7t5v0__fill_2
XTAP_TAPCELL_ROW_112_1601 VDD VSS gf180mcu_fd_sc_mcu7t5v0__filltie
XFILLER_89_732 VDD VDD VSS VSS gf180mcu_fd_sc_mcu7t5v0__fillcap_4
XFILLER_88_242 VDD VDD VSS VSS gf180mcu_fd_sc_mcu7t5v0__fill_2
XFILLER_0_168 VDD VDD VSS VSS gf180mcu_fd_sc_mcu7t5v0__fill_2
XFILLER_49_629 VDD VDD VSS VSS gf180mcu_fd_sc_mcu7t5v0__fill_1
XFILLER_29_331 VDD VDD VSS VSS gf180mcu_fd_sc_mcu7t5v0__fillcap_16
Xload_slew1102 _1662_/S _1664_/S VDD VDD VSS VSS gf180mcu_fd_sc_mcu7t5v0__buf_4
Xload_slew1113 _1491_/A1 _1499_/A1 VDD VDD VSS VSS gf180mcu_fd_sc_mcu7t5v0__buf_4
Xload_slew1135 _1197_/A2 _2533_/A2 VDD VDD VSS VSS gf180mcu_fd_sc_mcu7t5v0__clkbuf_4
XTAP_TAPCELL_ROW_47_819 VDD VSS gf180mcu_fd_sc_mcu7t5v0__filltie
XFILLER_29_386 VDD VDD VSS VSS gf180mcu_fd_sc_mcu7t5v0__fill_1
XFILLER_29_397 VDD VDD VSS VSS gf180mcu_fd_sc_mcu7t5v0__fillcap_4
XFILLER_44_312 VDD VDD VSS VSS gf180mcu_fd_sc_mcu7t5v0__fill_2
Xload_slew1157 _2158_/A2 _1418_/A2 VDD VDD VSS VSS gf180mcu_fd_sc_mcu7t5v0__buf_4
Xload_slew1179 _2171_/B _2172_/A2 VDD VDD VSS VSS gf180mcu_fd_sc_mcu7t5v0__buf_4
XFILLER_71_142 VDD VDD VSS VSS gf180mcu_fd_sc_mcu7t5v0__fillcap_4
XTAP_TAPCELL_ROW_27_576 VDD VSS gf180mcu_fd_sc_mcu7t5v0__filltie
XFILLER_12_253 VDD VDD VSS VSS gf180mcu_fd_sc_mcu7t5v0__fillcap_16
XTAP_TAPCELL_ROW_74_1139 VDD VSS gf180mcu_fd_sc_mcu7t5v0__filltie
XFILLER_67_404 VDD VDD VSS VSS gf180mcu_fd_sc_mcu7t5v0__fillcap_4
X_2021_ _2021_/I _2021_/ZN VDD VDD VSS VSS gf180mcu_fd_sc_mcu7t5v0__clkinv_1
XFILLER_82_407 VDD VDD VSS VSS gf180mcu_fd_sc_mcu7t5v0__fill_1
XFILLER_35_301 VDD VDD VSS VSS gf180mcu_fd_sc_mcu7t5v0__fill_2
XFILLER_63_632 VDD VDD VSS VSS gf180mcu_fd_sc_mcu7t5v0__fill_1
XFILLER_62_131 VDD VDD VSS VSS gf180mcu_fd_sc_mcu7t5v0__fillcap_4
XFILLER_62_142 VDD VDD VSS VSS gf180mcu_fd_sc_mcu7t5v0__fillcap_8
XFILLER_75_492 VDD VDD VSS VSS gf180mcu_fd_sc_mcu7t5v0__fillcap_32
XTAP_TAPCELL_ROW_85_1279 VDD VSS gf180mcu_fd_sc_mcu7t5v0__filltie
XFILLER_31_562 VDD VDD VSS VSS gf180mcu_fd_sc_mcu7t5v0__fillcap_64
X_1805_ _1805_/I _1805_/ZN VDD VDD VSS VSS gf180mcu_fd_sc_mcu7t5v0__clkinv_1
X_1736_ _1926_/A1 _1768_/A2 _1736_/B1 _1926_/B2 _1737_/I VDD VDD VSS VSS gf180mcu_fd_sc_mcu7t5v0__aoi22_1
X_1667_ _1667_/I _1667_/ZN VDD VDD VSS VSS gf180mcu_fd_sc_mcu7t5v0__clkinv_1
X_1598_ _2748_/I _2742_/I _1573_/Z _1598_/Z VDD VDD VSS VSS gf180mcu_fd_sc_mcu7t5v0__xor3_1
XFILLER_85_212 VDD VDD VSS VSS gf180mcu_fd_sc_mcu7t5v0__fillcap_16
XFILLER_66_481 VDD VDD VSS VSS gf180mcu_fd_sc_mcu7t5v0__fill_2
X_2219_ _2587_/Q _2140_/B _2220_/A3 VDD VDD VSS VSS gf180mcu_fd_sc_mcu7t5v0__nand2_1
XFILLER_54_643 VDD VDD VSS VSS gf180mcu_fd_sc_mcu7t5v0__fillcap_16
XFILLER_41_304 VDD VDD VSS VSS gf180mcu_fd_sc_mcu7t5v0__fill_1
XFILLER_53_142 VDD VDD VSS VSS gf180mcu_fd_sc_mcu7t5v0__fillcap_32
XTAP_TAPCELL_ROW_52_877 VDD VSS gf180mcu_fd_sc_mcu7t5v0__filltie
XTAP_TAPCELL_ROW_24_546 VDD VSS gf180mcu_fd_sc_mcu7t5v0__filltie
XFILLER_107_144 VDD VDD VSS VSS gf180mcu_fd_sc_mcu7t5v0__fill_1
XFILLER_1_444 VDD VDD VSS VSS gf180mcu_fd_sc_mcu7t5v0__fill_1
XFILLER_89_562 VDD VDD VSS VSS gf180mcu_fd_sc_mcu7t5v0__fillcap_64
XFILLER_77_702 VDD VDD VSS VSS gf180mcu_fd_sc_mcu7t5v0__fillcap_64
XFILLER_39_63 VDD VDD VSS VSS gf180mcu_fd_sc_mcu7t5v0__fillcap_4
XFILLER_44_131 VDD VDD VSS VSS gf180mcu_fd_sc_mcu7t5v0__fillcap_8
XFILLER_45_632 VDD VDD VSS VSS gf180mcu_fd_sc_mcu7t5v0__fillcap_64
XFILLER_57_492 VDD VDD VSS VSS gf180mcu_fd_sc_mcu7t5v0__fill_1
XFILLER_91_237 VDD VDD VSS VSS gf180mcu_fd_sc_mcu7t5v0__fill_2
XFILLER_13_562 VDD VDD VSS VSS gf180mcu_fd_sc_mcu7t5v0__fillcap_64
XFILLER_40_370 VDD VDD VSS VSS gf180mcu_fd_sc_mcu7t5v0__fill_2
X_2570_ _2570_/D _2594_/RN _2596_/CLK _2570_/Q VDD VDD VSS VSS gf180mcu_fd_sc_mcu7t5v0__dffrnq_1
X_1521_ _1930_/B2 _1533_/A2 _1521_/Z VDD VDD VSS VSS gf180mcu_fd_sc_mcu7t5v0__or2_1
X_1452_ input36/Z _1500_/A2 _1452_/B1 _2247_/A2 _1453_/I VDD VDD VSS VSS gf180mcu_fd_sc_mcu7t5v0__aoi22_1
XFILLER_67_212 VDD VDD VSS VSS gf180mcu_fd_sc_mcu7t5v0__fillcap_64
X_1383_ _1487_/A1 _1383_/A2 _1383_/ZN VDD VDD VSS VSS gf180mcu_fd_sc_mcu7t5v0__nor2_1
XFILLER_55_418 VDD VDD VSS VSS gf180mcu_fd_sc_mcu7t5v0__fill_2
X_2004_ _2004_/A1 _2030_/A2 _2014_/B1 _2734_/I _2005_/I VDD VDD VSS VSS gf180mcu_fd_sc_mcu7t5v0__aoi22_1
XFILLER_35_142 VDD VDD VSS VSS gf180mcu_fd_sc_mcu7t5v0__fill_1
XFILLER_35_197 VDD VDD VSS VSS gf180mcu_fd_sc_mcu7t5v0__fill_2
XFILLER_50_112 VDD VDD VSS VSS gf180mcu_fd_sc_mcu7t5v0__fillcap_16
XFILLER_90_281 VDD VDD VSS VSS gf180mcu_fd_sc_mcu7t5v0__fill_1
XTAP_TAPCELL_ROW_21_505 VDD VSS gf180mcu_fd_sc_mcu7t5v0__filltie
XTAP_TAPCELL_ROW_98_1437 VDD VSS gf180mcu_fd_sc_mcu7t5v0__filltie
X_2768_ _2768_/I _2768_/Z VDD VDD VSS VSS gf180mcu_fd_sc_mcu7t5v0__buf_1
XFILLER_105_615 VDD VDD VSS VSS gf180mcu_fd_sc_mcu7t5v0__fill_1
X_2699_ _2699_/I _2699_/Z VDD VDD VSS VSS gf180mcu_fd_sc_mcu7t5v0__buf_1
Xoutput830 _1652_/Z tl_d_uart_o[1] VDD VDD VSS VSS gf180mcu_fd_sc_mcu7t5v0__dlyd_1
X_1719_ _1719_/I _1719_/ZN VDD VDD VSS VSS gf180mcu_fd_sc_mcu7t5v0__clkinv_1
Xoutput863 _1655_/ZN tl_d_uart_o[4] VDD VDD VSS VSS gf180mcu_fd_sc_mcu7t5v0__dlyd_1
Xoutput852 _1654_/Z tl_d_uart_o[3] VDD VDD VSS VSS gf180mcu_fd_sc_mcu7t5v0__dlyd_1
Xoutput841 _1653_/ZN tl_d_uart_o[2] VDD VDD VSS VSS gf180mcu_fd_sc_mcu7t5v0__dlyd_1
XFILLER_59_702 VDD VDD VSS VSS gf180mcu_fd_sc_mcu7t5v0__fillcap_32
Xoutput896 _1658_/Z tl_d_uart_o[7] VDD VDD VSS VSS gf180mcu_fd_sc_mcu7t5v0__dlyd_1
Xoutput885 _1657_/ZN tl_d_uart_o[6] VDD VDD VSS VSS gf180mcu_fd_sc_mcu7t5v0__dlyd_1
Xoutput874 _1656_/Z tl_d_uart_o[5] VDD VDD VSS VSS gf180mcu_fd_sc_mcu7t5v0__dlyd_1
XFILLER_86_521 VDD VDD VSS VSS gf180mcu_fd_sc_mcu7t5v0__fillcap_4
XFILLER_58_234 VDD VDD VSS VSS gf180mcu_fd_sc_mcu7t5v0__fillcap_8
XFILLER_58_267 VDD VDD VSS VSS gf180mcu_fd_sc_mcu7t5v0__fill_2
XFILLER_86_543 VDD VDD VSS VSS gf180mcu_fd_sc_mcu7t5v0__fill_1
XTAP_TAPCELL_ROW_57_936 VDD VSS gf180mcu_fd_sc_mcu7t5v0__filltie
XTAP_TAPCELL_ROW_29_605 VDD VSS gf180mcu_fd_sc_mcu7t5v0__filltie
XFILLER_73_226 VDD VDD VSS VSS gf180mcu_fd_sc_mcu7t5v0__fillcap_16
XFILLER_27_632 VDD VDD VSS VSS gf180mcu_fd_sc_mcu7t5v0__fillcap_64
XFILLER_54_473 VDD VDD VSS VSS gf180mcu_fd_sc_mcu7t5v0__fill_2
XTAP_TAPCELL_ROW_1_274 VDD VSS gf180mcu_fd_sc_mcu7t5v0__filltie
XTAP_TAPCELL_ROW_1_263 VDD VSS gf180mcu_fd_sc_mcu7t5v0__filltie
XTAP_TAPCELL_ROW_107_1544 VDD VSS gf180mcu_fd_sc_mcu7t5v0__filltie
XFILLER_41_134 VDD VDD VSS VSS gf180mcu_fd_sc_mcu7t5v0__fillcap_4
XFILLER_10_521 VDD VDD VSS VSS gf180mcu_fd_sc_mcu7t5v0__fillcap_4
XFILLER_22_381 VDD VDD VSS VSS gf180mcu_fd_sc_mcu7t5v0__fillcap_4
XFILLER_10_565 VDD VDD VSS VSS gf180mcu_fd_sc_mcu7t5v0__fillcap_16
XFILLER_6_503 VDD VDD VSS VSS gf180mcu_fd_sc_mcu7t5v0__fillcap_16
XTAP_TAPCELL_ROW_118_1684 VDD VSS gf180mcu_fd_sc_mcu7t5v0__filltie
XTAP_TAPCELL_ROW_118_1673 VDD VSS gf180mcu_fd_sc_mcu7t5v0__filltie
XTAP_TAPCELL_ROW_71_1109 VDD VSS gf180mcu_fd_sc_mcu7t5v0__filltie
XTAP_TAPCELL_ROW_9_363 VDD VSS gf180mcu_fd_sc_mcu7t5v0__filltie
XFILLER_49_201 VDD VDD VSS VSS gf180mcu_fd_sc_mcu7t5v0__fillcap_8
XFILLER_49_212 VDD VDD VSS VSS gf180mcu_fd_sc_mcu7t5v0__fillcap_16
XFILLER_106_90 VDD VDD VSS VSS gf180mcu_fd_sc_mcu7t5v0__fillcap_8
XFILLER_65_738 VDD VDD VSS VSS gf180mcu_fd_sc_mcu7t5v0__fill_1
XFILLER_92_524 VDD VDD VSS VSS gf180mcu_fd_sc_mcu7t5v0__fill_1
XTAP_TAPCELL_ROW_82_1238 VDD VSS gf180mcu_fd_sc_mcu7t5v0__filltie
XFILLER_60_454 VDD VDD VSS VSS gf180mcu_fd_sc_mcu7t5v0__fill_1
XANTENNA_19 tl_h_i_i[90] VDD VDD VSS VSS gf180mcu_fd_sc_mcu7t5v0__antenna
XFILLER_9_352 VDD VDD VSS VSS gf180mcu_fd_sc_mcu7t5v0__fillcap_64
XFILLER_56_2 VDD VDD VSS VSS gf180mcu_fd_sc_mcu7t5v0__fillcap_32
X_2553_ _2553_/D _2583_/RN clkload3/I _2553_/Q VDD VDD VSS VSS gf180mcu_fd_sc_mcu7t5v0__dffrnq_1
X_1504_ _1504_/A1 _1504_/A2 _2377_/A2 VDD VDD VSS VSS gf180mcu_fd_sc_mcu7t5v0__nand2_1
XTAP_TAPCELL_ROW_93_1367 VDD VSS gf180mcu_fd_sc_mcu7t5v0__filltie
X_2484_ _2590_/Q _2517_/B _2493_/A2 VDD VDD VSS VSS gf180mcu_fd_sc_mcu7t5v0__nor2_1
XTAP_TAPCELL_ROW_93_1378 VDD VSS gf180mcu_fd_sc_mcu7t5v0__filltie
X_1435_ _1499_/A1 _1433_/Z _1435_/B _1436_/B1 VDD VDD VSS VSS gf180mcu_fd_sc_mcu7t5v0__oai21_1
X_1366_ _1366_/A1 _1486_/A2 _1366_/B1 _1390_/B2 _1367_/A2 VDD VDD VSS VSS gf180mcu_fd_sc_mcu7t5v0__aoi22_1
XFILLER_95_340 VDD VDD VSS VSS gf180mcu_fd_sc_mcu7t5v0__fill_1
XFILLER_55_204 VDD VDD VSS VSS gf180mcu_fd_sc_mcu7t5v0__fill_1
XFILLER_55_226 VDD VDD VSS VSS gf180mcu_fd_sc_mcu7t5v0__fill_1
X_1297_ _1393_/A1 _2273_/A2 _1297_/Z VDD VDD VSS VSS gf180mcu_fd_sc_mcu7t5v0__and2_1
XFILLER_36_451 VDD VDD VSS VSS gf180mcu_fd_sc_mcu7t5v0__fillcap_4
XTAP_TAPCELL_ROW_54_906 VDD VSS gf180mcu_fd_sc_mcu7t5v0__filltie
XFILLER_36_484 VDD VDD VSS VSS gf180mcu_fd_sc_mcu7t5v0__fill_2
XTAP_TAPCELL_ROW_34_663 VDD VSS gf180mcu_fd_sc_mcu7t5v0__filltie
XTAP_TAPCELL_ROW_102_1485 VDD VSS gf180mcu_fd_sc_mcu7t5v0__filltie
Xoutput660 _1943_/ZN tl_d_esram_o[44] VDD VDD VSS VSS gf180mcu_fd_sc_mcu7t5v0__dlyd_1
Xoutput671 _1963_/ZN tl_d_esram_o[54] VDD VDD VSS VSS gf180mcu_fd_sc_mcu7t5v0__dlyd_1
Xoutput693 _2003_/ZN tl_d_esram_o[74] VDD VDD VSS VSS gf180mcu_fd_sc_mcu7t5v0__dlyd_1
Xoutput682 _1983_/ZN tl_d_esram_o[64] VDD VDD VSS VSS gf180mcu_fd_sc_mcu7t5v0__dlyd_1
XTAP_TAPCELL_ROW_6_333 VDD VSS gf180mcu_fd_sc_mcu7t5v0__filltie
XFILLER_19_418 VDD VDD VSS VSS gf180mcu_fd_sc_mcu7t5v0__fill_2
XFILLER_86_384 VDD VDD VSS VSS gf180mcu_fd_sc_mcu7t5v0__fill_1
XFILLER_86_362 VDD VDD VSS VSS gf180mcu_fd_sc_mcu7t5v0__fillcap_16
XFILLER_74_524 VDD VDD VSS VSS gf180mcu_fd_sc_mcu7t5v0__fill_1
XTAP_TAPCELL_ROW_68_1071 VDD VSS gf180mcu_fd_sc_mcu7t5v0__filltie
XFILLER_42_432 VDD VDD VSS VSS gf180mcu_fd_sc_mcu7t5v0__fill_1
XFILLER_11_863 VDD VDD VSS VSS gf180mcu_fd_sc_mcu7t5v0__fill_2
Xinput17 tl_d_dmem_i[23] input17/Z VDD VDD VSS VSS gf180mcu_fd_sc_mcu7t5v0__dlyd_1
Xinput28 tl_d_dmem_i[33] input28/Z VDD VDD VSS VSS gf180mcu_fd_sc_mcu7t5v0__dlyd_1
Xinput39 tl_d_dmem_i[43] input39/Z VDD VDD VSS VSS gf180mcu_fd_sc_mcu7t5v0__dlyd_1
XFILLER_111_426 VDD VDD VSS VSS gf180mcu_fd_sc_mcu7t5v0__fill_1
X_1220_ _1222_/A1 _1534_/A2 _2700_/I VDD VDD VSS VSS gf180mcu_fd_sc_mcu7t5v0__nor2_1
XFILLER_96_159 VDD VDD VSS VSS gf180mcu_fd_sc_mcu7t5v0__fill_2
X_1151_ _2594_/Q _2593_/Q _2596_/Q _2595_/Q _1151_/Z VDD VDD VSS VSS gf180mcu_fd_sc_mcu7t5v0__or4_1
XFILLER_92_321 VDD VDD VSS VSS gf180mcu_fd_sc_mcu7t5v0__fill_1
XFILLER_18_451 VDD VDD VSS VSS gf180mcu_fd_sc_mcu7t5v0__fillcap_4
X_1082_ _1082_/I _1225_/A2 VDD VDD VSS VSS gf180mcu_fd_sc_mcu7t5v0__clkinv_1
XFILLER_92_387 VDD VDD VSS VSS gf180mcu_fd_sc_mcu7t5v0__fillcap_4
X_1984_ _1984_/A1 _2022_/A2 _1998_/B1 _2724_/I _1985_/I VDD VDD VSS VSS gf180mcu_fd_sc_mcu7t5v0__aoi22_1
XTAP_TAPCELL_ROW_31_633 VDD VSS gf180mcu_fd_sc_mcu7t5v0__filltie
XTAP_TAPCELL_ROW_11_390 VDD VSS gf180mcu_fd_sc_mcu7t5v0__filltie
X_2536_ _2601_/Q _2702_/I _2537_/B VDD VDD VSS VSS gf180mcu_fd_sc_mcu7t5v0__nor2_1
X_2467_ _2578_/Q _2467_/A2 _2468_/A2 VDD VDD VSS VSS gf180mcu_fd_sc_mcu7t5v0__nand2_1
X_1418_ input97/Z _1418_/A2 _2375_/A3 _1419_/B VDD VDD VSS VSS gf180mcu_fd_sc_mcu7t5v0__nand3_1
XFILLER_68_373 VDD VDD VSS VSS gf180mcu_fd_sc_mcu7t5v0__fillcap_8
X_2398_ _2398_/I0 _2554_/Q _2398_/S _2554_/D VDD VDD VSS VSS gf180mcu_fd_sc_mcu7t5v0__mux2_2
XFILLER_56_524 VDD VDD VSS VSS gf180mcu_fd_sc_mcu7t5v0__fill_1
XFILLER_56_535 VDD VDD VSS VSS gf180mcu_fd_sc_mcu7t5v0__fill_2
X_1349_ _1349_/I _1350_/B1 VDD VDD VSS VSS gf180mcu_fd_sc_mcu7t5v0__clkinv_1
XTAP_TAPCELL_ROW_39_722 VDD VSS gf180mcu_fd_sc_mcu7t5v0__filltie
XFILLER_83_310 VDD VDD VSS VSS gf180mcu_fd_sc_mcu7t5v0__fill_2
XFILLER_36_270 VDD VDD VSS VSS gf180mcu_fd_sc_mcu7t5v0__fillcap_4
XFILLER_52_730 VDD VDD VSS VSS gf180mcu_fd_sc_mcu7t5v0__fillcap_4
XTAP_TAPCELL_ROW_104_1503 VDD VSS gf180mcu_fd_sc_mcu7t5v0__filltie
XFILLER_71_538 VDD VDD VSS VSS gf180mcu_fd_sc_mcu7t5v0__fillcap_16
XFILLER_24_454 VDD VDD VSS VSS gf180mcu_fd_sc_mcu7t5v0__fill_1
XTAP_TAPCELL_ROW_19_490 VDD VSS gf180mcu_fd_sc_mcu7t5v0__filltie
XFILLER_24_465 VDD VDD VSS VSS gf180mcu_fd_sc_mcu7t5v0__fill_1
XTAP_TAPCELL_ROW_115_1632 VDD VSS gf180mcu_fd_sc_mcu7t5v0__filltie
Xfanout1104 _1665_/S _1651_/A2 VDD VDD VSS VSS gf180mcu_fd_sc_mcu7t5v0__dlyd_1
Xfanout1126 _1718_/B1 _1772_/B1 VDD VDD VSS VSS gf180mcu_fd_sc_mcu7t5v0__dlyd_1
XFILLER_78_148 VDD VDD VSS VSS gf180mcu_fd_sc_mcu7t5v0__fillcap_4
XFILLER_101_492 VDD VDD VSS VSS gf180mcu_fd_sc_mcu7t5v0__fillcap_4
XFILLER_87_693 VDD VDD VSS VSS gf180mcu_fd_sc_mcu7t5v0__fill_1
XFILLER_47_557 VDD VDD VSS VSS gf180mcu_fd_sc_mcu7t5v0__fill_2
XFILLER_62_527 VDD VDD VSS VSS gf180mcu_fd_sc_mcu7t5v0__fillcap_64
XFILLER_74_387 VDD VDD VSS VSS gf180mcu_fd_sc_mcu7t5v0__fillcap_64
XFILLER_70_593 VDD VDD VSS VSS gf180mcu_fd_sc_mcu7t5v0__fill_2
X_2321_ _2333_/A1 _2321_/A2 _2322_/A2 VDD VDD VSS VSS gf180mcu_fd_sc_mcu7t5v0__nand2_1
XTAP_TAPCELL_ROW_90_1337 VDD VSS gf180mcu_fd_sc_mcu7t5v0__filltie
X_2252_ _2291_/A2 _2252_/A2 _2362_/A1 VDD VDD VSS VSS gf180mcu_fd_sc_mcu7t5v0__nor2_1
X_1203_ _1219_/A1 _1203_/A2 _1203_/A3 _1203_/B _2485_/A2 VDD VDD VSS VSS gf180mcu_fd_sc_mcu7t5v0__oai31_1
XFILLER_19_2 VDD VDD VSS VSS gf180mcu_fd_sc_mcu7t5v0__fillcap_4
XFILLER_38_535 VDD VDD VSS VSS gf180mcu_fd_sc_mcu7t5v0__fillcap_4
X_2183_ _1116_/B _2183_/A2 _2183_/A3 _2184_/C VDD VDD VSS VSS gf180mcu_fd_sc_mcu7t5v0__nand3_1
X_1134_ _2742_/I _2743_/I _1143_/A4 VDD VDD VSS VSS gf180mcu_fd_sc_mcu7t5v0__nor2_1
X_1065_ _2539_/Q _2382_/A1 VDD VDD VSS VSS gf180mcu_fd_sc_mcu7t5v0__clkinv_1
XFILLER_92_184 VDD VDD VSS VSS gf180mcu_fd_sc_mcu7t5v0__fill_2
XFILLER_80_313 VDD VDD VSS VSS gf180mcu_fd_sc_mcu7t5v0__fill_2
XFILLER_80_357 VDD VDD VSS VSS gf180mcu_fd_sc_mcu7t5v0__fillcap_8
XFILLER_21_446 VDD VDD VSS VSS gf180mcu_fd_sc_mcu7t5v0__fillcap_4
XTAP_TAPCELL_ROW_44_780 VDD VSS gf180mcu_fd_sc_mcu7t5v0__filltie
X_1967_ _1967_/I _1967_/ZN VDD VDD VSS VSS gf180mcu_fd_sc_mcu7t5v0__clkinv_1
X_1898_ _1898_/A1 _1914_/A2 _1914_/B1 _2713_/I _1899_/I VDD VDD VSS VSS gf180mcu_fd_sc_mcu7t5v0__aoi22_1
X_2519_ _2526_/C _2519_/A2 _2526_/B _2522_/B VDD VDD VSS VSS gf180mcu_fd_sc_mcu7t5v0__aoi21_1
Xinput207 tl_d_uart_i[16] _1262_/A1 VDD VDD VSS VSS gf180mcu_fd_sc_mcu7t5v0__dlyd_1
Xinput218 tl_d_uart_i[26] _1342_/A1 VDD VDD VSS VSS gf180mcu_fd_sc_mcu7t5v0__dlyd_1
XFILLER_88_435 VDD VDD VSS VSS gf180mcu_fd_sc_mcu7t5v0__fillcap_4
Xinput229 tl_d_uart_i[36] _1422_/A1 VDD VDD VSS VSS gf180mcu_fd_sc_mcu7t5v0__dlyd_1
XTAP_TAPCELL_ROW_110_1573 VDD VSS gf180mcu_fd_sc_mcu7t5v0__filltie
XFILLER_56_332 VDD VDD VSS VSS gf180mcu_fd_sc_mcu7t5v0__fillcap_8
XFILLER_84_630 VDD VDD VSS VSS gf180mcu_fd_sc_mcu7t5v0__fill_2
XFILLER_44_505 VDD VDD VSS VSS gf180mcu_fd_sc_mcu7t5v0__fill_2
XFILLER_44_527 VDD VDD VSS VSS gf180mcu_fd_sc_mcu7t5v0__fillcap_16
XFILLER_56_387 VDD VDD VSS VSS gf180mcu_fd_sc_mcu7t5v0__fillcap_16
XFILLER_71_324 VDD VDD VSS VSS gf180mcu_fd_sc_mcu7t5v0__fillcap_16
XTAP_TAPCELL_ROW_65_1041 VDD VSS gf180mcu_fd_sc_mcu7t5v0__filltie
XTAP_TAPCELL_ROW_14_419 VDD VSS gf180mcu_fd_sc_mcu7t5v0__filltie
XFILLER_12_457 VDD VDD VSS VSS gf180mcu_fd_sc_mcu7t5v0__fillcap_64
XTAP_TAPCELL_ROW_76_1170 VDD VSS gf180mcu_fd_sc_mcu7t5v0__filltie
XFILLER_79_402 VDD VDD VSS VSS gf180mcu_fd_sc_mcu7t5v0__fillcap_16
XFILLER_66_107 VDD VDD VSS VSS gf180mcu_fd_sc_mcu7t5v0__fillcap_64
XFILLER_94_427 VDD VDD VSS VSS gf180mcu_fd_sc_mcu7t5v0__fillcap_8
XFILLER_59_192 VDD VDD VSS VSS gf180mcu_fd_sc_mcu7t5v0__fill_1
XFILLER_63_836 VDD VDD VSS VSS gf180mcu_fd_sc_mcu7t5v0__fillcap_4
XFILLER_63_858 VDD VDD VSS VSS gf180mcu_fd_sc_mcu7t5v0__fillcap_8
XFILLER_90_688 VDD VDD VSS VSS gf180mcu_fd_sc_mcu7t5v0__fillcap_8
XFILLER_31_766 VDD VDD VSS VSS gf180mcu_fd_sc_mcu7t5v0__fillcap_4
X_1821_ _1821_/I _1821_/ZN VDD VDD VSS VSS gf180mcu_fd_sc_mcu7t5v0__clkinv_1
XTAP_TAPCELL_ROW_41_750 VDD VSS gf180mcu_fd_sc_mcu7t5v0__filltie
XFILLER_30_298 VDD VDD VSS VSS gf180mcu_fd_sc_mcu7t5v0__fillcap_8
X_1752_ _1942_/A1 _1772_/A2 _1762_/B1 _1942_/B2 _1753_/I VDD VDD VSS VSS gf180mcu_fd_sc_mcu7t5v0__aoi22_1
X_1683_ _1683_/I _1683_/ZN VDD VDD VSS VSS gf180mcu_fd_sc_mcu7t5v0__clkinv_1
X_2304_ _2304_/A1 _2304_/A2 _2348_/B _2304_/ZN VDD VDD VSS VSS gf180mcu_fd_sc_mcu7t5v0__aoi21_1
X_2235_ _2235_/A1 _1116_/B _2235_/B _2235_/C _2237_/B1 VDD VDD VSS VSS gf180mcu_fd_sc_mcu7t5v0__oai211_1
X_2166_ input72/Z _2142_/B _2170_/C _2166_/C _2168_/B1 VDD VDD VSS VSS gf180mcu_fd_sc_mcu7t5v0__oai211_1
XTAP_TAPCELL_ROW_49_850 VDD VSS gf180mcu_fd_sc_mcu7t5v0__filltie
XFILLER_26_527 VDD VDD VSS VSS gf180mcu_fd_sc_mcu7t5v0__fillcap_64
XFILLER_38_387 VDD VDD VSS VSS gf180mcu_fd_sc_mcu7t5v0__fillcap_64
X_1117_ _2569_/Q _2246_/A2 _1117_/Z VDD VDD VSS VSS gf180mcu_fd_sc_mcu7t5v0__and2_1
X_2097_ _1066_/I _2556_/Q _2215_/A1 _2347_/A2 _2098_/A2 VDD VDD VSS VSS gf180mcu_fd_sc_mcu7t5v0__aoi22_1
XFILLER_80_143 VDD VDD VSS VSS gf180mcu_fd_sc_mcu7t5v0__fillcap_32
XFILLER_21_254 VDD VDD VSS VSS gf180mcu_fd_sc_mcu7t5v0__fillcap_16
XPHY_EDGE_ROW_3_Right_3 VDD VSS gf180mcu_fd_sc_mcu7t5v0__endcap
XTAP_TAPCELL_ROW_112_1602 VDD VSS gf180mcu_fd_sc_mcu7t5v0__filltie
Xload_slew1125 _1510_/A2 _1486_/A2 VDD VDD VSS VSS gf180mcu_fd_sc_mcu7t5v0__buf_4
Xload_slew1147 _2346_/A1 _2374_/A1 VDD VDD VSS VSS gf180mcu_fd_sc_mcu7t5v0__buf_4
XTAP_TAPCELL_ROW_27_577 VDD VSS gf180mcu_fd_sc_mcu7t5v0__filltie
XFILLER_71_176 VDD VDD VSS VSS gf180mcu_fd_sc_mcu7t5v0__fillcap_4
XFILLER_13_766 VDD VDD VSS VSS gf180mcu_fd_sc_mcu7t5v0__fillcap_4
XFILLER_99_508 VDD VDD VSS VSS gf180mcu_fd_sc_mcu7t5v0__fill_2
XFILLER_69_72 VDD VDD VSS VSS gf180mcu_fd_sc_mcu7t5v0__fillcap_8
X_2020_ _2397_/I0 _2022_/A2 _2022_/B1 _2758_/I _2021_/I VDD VDD VSS VSS gf180mcu_fd_sc_mcu7t5v0__aoi22_1
XFILLER_94_257 VDD VDD VSS VSS gf180mcu_fd_sc_mcu7t5v0__fill_1
XFILLER_47_184 VDD VDD VSS VSS gf180mcu_fd_sc_mcu7t5v0__fillcap_16
XFILLER_63_699 VDD VDD VSS VSS gf180mcu_fd_sc_mcu7t5v0__fill_1
XFILLER_50_349 VDD VDD VSS VSS gf180mcu_fd_sc_mcu7t5v0__fill_1
X_1804_ _1994_/A1 _1818_/A2 _1814_/B1 _2729_/I _1805_/I VDD VDD VSS VSS gf180mcu_fd_sc_mcu7t5v0__aoi22_1
X_1735_ _1735_/I _1735_/ZN VDD VDD VSS VSS gf180mcu_fd_sc_mcu7t5v0__clkinv_1
X_1666_ _1856_/A1 _1720_/A2 _1720_/B1 _1856_/B2 _1667_/I VDD VDD VSS VSS gf180mcu_fd_sc_mcu7t5v0__aoi22_1
X_1597_ _1592_/Z _1596_/Z _1597_/Z VDD VDD VSS VSS gf180mcu_fd_sc_mcu7t5v0__xor2_1
XFILLER_86_725 VDD VDD VSS VSS gf180mcu_fd_sc_mcu7t5v0__fillcap_8
XFILLER_100_513 VDD VDD VSS VSS gf180mcu_fd_sc_mcu7t5v0__fillcap_4
XFILLER_100_524 VDD VDD VSS VSS gf180mcu_fd_sc_mcu7t5v0__fill_1
XFILLER_85_268 VDD VDD VSS VSS gf180mcu_fd_sc_mcu7t5v0__fill_2
XFILLER_85_246 VDD VDD VSS VSS gf180mcu_fd_sc_mcu7t5v0__fill_1
X_2218_ _2218_/A1 _2218_/A2 _2220_/A2 VDD VDD VSS VSS gf180mcu_fd_sc_mcu7t5v0__nand2_1
XFILLER_85_279 VDD VDD VSS VSS gf180mcu_fd_sc_mcu7t5v0__fill_1
XFILLER_27_858 VDD VDD VSS VSS gf180mcu_fd_sc_mcu7t5v0__fillcap_8
X_2149_ _2142_/B _2149_/A2 _2150_/B2 VDD VDD VSS VSS gf180mcu_fd_sc_mcu7t5v0__nand2_1
XFILLER_53_187 VDD VDD VSS VSS gf180mcu_fd_sc_mcu7t5v0__fillcap_16
XTAP_TAPCELL_ROW_62_1000 VDD VSS gf180mcu_fd_sc_mcu7t5v0__filltie
XTAP_TAPCELL_ROW_52_878 VDD VSS gf180mcu_fd_sc_mcu7t5v0__filltie
XTAP_TAPCELL_ROW_24_547 VDD VSS gf180mcu_fd_sc_mcu7t5v0__filltie
XPHY_EDGE_ROW_15_Left_134 VDD VSS gf180mcu_fd_sc_mcu7t5v0__endcap
XFILLER_1_489 VDD VDD VSS VSS gf180mcu_fd_sc_mcu7t5v0__fill_1
XPHY_EDGE_ROW_24_Left_143 VDD VSS gf180mcu_fd_sc_mcu7t5v0__endcap
XFILLER_17_346 VDD VDD VSS VSS gf180mcu_fd_sc_mcu7t5v0__fillcap_4
XFILLER_25_390 VDD VDD VSS VSS gf180mcu_fd_sc_mcu7t5v0__fill_1
XFILLER_32_349 VDD VDD VSS VSS gf180mcu_fd_sc_mcu7t5v0__fillcap_8
XPHY_EDGE_ROW_33_Left_152 VDD VSS gf180mcu_fd_sc_mcu7t5v0__endcap
XFILLER_9_556 VDD VDD VSS VSS gf180mcu_fd_sc_mcu7t5v0__fillcap_4
X_1520_ _1928_/B2 _1533_/A2 _1520_/Z VDD VDD VSS VSS gf180mcu_fd_sc_mcu7t5v0__or2_1
X_1451_ _1499_/A1 _1449_/Z _1451_/B _1452_/B1 VDD VDD VSS VSS gf180mcu_fd_sc_mcu7t5v0__oai21_1
XFILLER_99_338 VDD VDD VSS VSS gf180mcu_fd_sc_mcu7t5v0__fill_2
X_1382_ _1382_/A1 _1486_/A2 _1382_/B1 _1390_/B2 _1383_/A2 VDD VDD VSS VSS gf180mcu_fd_sc_mcu7t5v0__aoi22_1
XPHY_EDGE_ROW_42_Left_161 VDD VSS gf180mcu_fd_sc_mcu7t5v0__endcap
XFILLER_95_544 VDD VDD VSS VSS gf180mcu_fd_sc_mcu7t5v0__fill_2
Xinput390 tl_h_i_i[109] _2038_/A1 VDD VDD VSS VSS gf180mcu_fd_sc_mcu7t5v0__dlyd_1
X_2003_ _2003_/I _2003_/ZN VDD VDD VSS VSS gf180mcu_fd_sc_mcu7t5v0__clkinv_1
XFILLER_23_349 VDD VDD VSS VSS gf180mcu_fd_sc_mcu7t5v0__fill_1
XFILLER_50_135 VDD VDD VSS VSS gf180mcu_fd_sc_mcu7t5v0__fillcap_8
XTAP_TAPCELL_ROW_21_506 VDD VSS gf180mcu_fd_sc_mcu7t5v0__filltie
XPHY_EDGE_ROW_51_Left_170 VDD VSS gf180mcu_fd_sc_mcu7t5v0__endcap
XTAP_TAPCELL_ROW_98_1427 VDD VSS gf180mcu_fd_sc_mcu7t5v0__filltie
XTAP_TAPCELL_ROW_98_1438 VDD VSS gf180mcu_fd_sc_mcu7t5v0__filltie
X_2767_ _2767_/I _2767_/Z VDD VDD VSS VSS gf180mcu_fd_sc_mcu7t5v0__buf_1
X_2698_ _2698_/I _2698_/Z VDD VDD VSS VSS gf180mcu_fd_sc_mcu7t5v0__buf_1
Xoutput820 _2772_/Z tl_d_uart_o[113] VDD VDD VSS VSS gf180mcu_fd_sc_mcu7t5v0__dlyd_1
X_1718_ _1908_/A1 _1728_/A2 _1718_/B1 _2718_/I _1719_/I VDD VDD VSS VSS gf180mcu_fd_sc_mcu7t5v0__aoi22_1
Xoutput864 _1641_/Z tl_d_uart_o[50] VDD VDD VSS VSS gf180mcu_fd_sc_mcu7t5v0__dlyd_1
Xoutput853 _1631_/Z tl_d_uart_o[40] VDD VDD VSS VSS gf180mcu_fd_sc_mcu7t5v0__dlyd_1
Xoutput842 _1621_/Z tl_d_uart_o[30] VDD VDD VSS VSS gf180mcu_fd_sc_mcu7t5v0__dlyd_1
Xoutput831 _2711_/Z tl_d_uart_o[20] VDD VDD VSS VSS gf180mcu_fd_sc_mcu7t5v0__dlyd_1
X_1649_ _1970_/B2 _1651_/A2 _1649_/Z VDD VDD VSS VSS gf180mcu_fd_sc_mcu7t5v0__or2_1
Xoutput897 _2739_/Z tl_d_uart_o[80] VDD VDD VSS VSS gf180mcu_fd_sc_mcu7t5v0__dlyd_1
Xoutput886 _2729_/Z tl_d_uart_o[70] VDD VDD VSS VSS gf180mcu_fd_sc_mcu7t5v0__dlyd_1
Xoutput875 _1651_/Z tl_d_uart_o[60] VDD VDD VSS VSS gf180mcu_fd_sc_mcu7t5v0__dlyd_1
XFILLER_98_371 VDD VDD VSS VSS gf180mcu_fd_sc_mcu7t5v0__fillcap_4
XFILLER_76_18 VDD VDD VSS VSS gf180mcu_fd_sc_mcu7t5v0__fill_1
XFILLER_59_758 VDD VDD VSS VSS gf180mcu_fd_sc_mcu7t5v0__fillcap_8
XFILLER_100_387 VDD VDD VSS VSS gf180mcu_fd_sc_mcu7t5v0__fillcap_16
XTAP_TAPCELL_ROW_57_937 VDD VSS gf180mcu_fd_sc_mcu7t5v0__filltie
XTAP_TAPCELL_ROW_29_606 VDD VSS gf180mcu_fd_sc_mcu7t5v0__filltie
XFILLER_73_216 VDD VDD VSS VSS gf180mcu_fd_sc_mcu7t5v0__fill_2
XTAP_TAPCELL_ROW_1_264 VDD VSS gf180mcu_fd_sc_mcu7t5v0__filltie
XTAP_TAPCELL_ROW_107_1545 VDD VSS gf180mcu_fd_sc_mcu7t5v0__filltie
XFILLER_42_614 VDD VDD VSS VSS gf180mcu_fd_sc_mcu7t5v0__fillcap_4
XFILLER_81_282 VDD VDD VSS VSS gf180mcu_fd_sc_mcu7t5v0__fillcap_8
XFILLER_42_658 VDD VDD VSS VSS gf180mcu_fd_sc_mcu7t5v0__fillcap_4
XFILLER_41_76 VDD VDD VSS VSS gf180mcu_fd_sc_mcu7t5v0__fillcap_4
XTAP_TAPCELL_ROW_118_1685 VDD VSS gf180mcu_fd_sc_mcu7t5v0__filltie
XTAP_TAPCELL_ROW_118_1674 VDD VSS gf180mcu_fd_sc_mcu7t5v0__filltie
XTAP_TAPCELL_ROW_9_364 VDD VSS gf180mcu_fd_sc_mcu7t5v0__filltie
XFILLER_37_419 VDD VDD VSS VSS gf180mcu_fd_sc_mcu7t5v0__fill_1
XFILLER_49_279 VDD VDD VSS VSS gf180mcu_fd_sc_mcu7t5v0__fill_1
XFILLER_64_205 VDD VDD VSS VSS gf180mcu_fd_sc_mcu7t5v0__fill_2
XFILLER_57_290 VDD VDD VSS VSS gf180mcu_fd_sc_mcu7t5v0__fillcap_4
XFILLER_64_238 VDD VDD VSS VSS gf180mcu_fd_sc_mcu7t5v0__fillcap_4
XFILLER_60_444 VDD VDD VSS VSS gf180mcu_fd_sc_mcu7t5v0__fillcap_8
XTAP_TAPCELL_ROW_82_1239 VDD VSS gf180mcu_fd_sc_mcu7t5v0__filltie
XFILLER_32_168 VDD VDD VSS VSS gf180mcu_fd_sc_mcu7t5v0__fill_1
X_2552_ _2552_/D _2580_/RN clkload3/I _2552_/Q VDD VDD VSS VSS gf180mcu_fd_sc_mcu7t5v0__dffrnq_1
X_1503_ _1503_/A1 _1503_/A2 _1503_/ZN VDD VDD VSS VSS gf180mcu_fd_sc_mcu7t5v0__nor2_1
XTAP_TAPCELL_ROW_93_1368 VDD VSS gf180mcu_fd_sc_mcu7t5v0__filltie
X_2483_ _2590_/Q _2517_/B _2493_/B VDD VDD VSS VSS gf180mcu_fd_sc_mcu7t5v0__nand2_1
X_1434_ input99/Z _2158_/A2 _2379_/A3 _1435_/B VDD VDD VSS VSS gf180mcu_fd_sc_mcu7t5v0__nand3_1
XFILLER_96_831 VDD VDD VSS VSS gf180mcu_fd_sc_mcu7t5v0__fill_1
XFILLER_68_533 VDD VDD VSS VSS gf180mcu_fd_sc_mcu7t5v0__fill_1
XFILLER_68_566 VDD VDD VSS VSS gf180mcu_fd_sc_mcu7t5v0__fill_1
X_1365_ _1365_/I _1366_/B1 VDD VDD VSS VSS gf180mcu_fd_sc_mcu7t5v0__clkinv_1
XFILLER_95_330 VDD VDD VSS VSS gf180mcu_fd_sc_mcu7t5v0__fillcap_8
XFILLER_68_577 VDD VDD VSS VSS gf180mcu_fd_sc_mcu7t5v0__fillcap_16
XFILLER_95_352 VDD VDD VSS VSS gf180mcu_fd_sc_mcu7t5v0__fillcap_4
X_1296_ _1296_/A1 _1368_/A2 _2273_/A2 VDD VDD VSS VSS gf180mcu_fd_sc_mcu7t5v0__nand2_1
XFILLER_83_547 VDD VDD VSS VSS gf180mcu_fd_sc_mcu7t5v0__fillcap_8
XTAP_TAPCELL_ROW_54_907 VDD VSS gf180mcu_fd_sc_mcu7t5v0__filltie
XFILLER_51_422 VDD VDD VSS VSS gf180mcu_fd_sc_mcu7t5v0__fillcap_64
XFILLER_63_282 VDD VDD VSS VSS gf180mcu_fd_sc_mcu7t5v0__fillcap_64
XTAP_TAPCELL_ROW_62_995 VDD VSS gf180mcu_fd_sc_mcu7t5v0__filltie
XTAP_TAPCELL_ROW_34_664 VDD VSS gf180mcu_fd_sc_mcu7t5v0__filltie
XFILLER_20_831 VDD VDD VSS VSS gf180mcu_fd_sc_mcu7t5v0__fill_1
XTAP_TAPCELL_ROW_102_1486 VDD VSS gf180mcu_fd_sc_mcu7t5v0__filltie
XTAP_TAPCELL_ROW_102_1475 VDD VSS gf180mcu_fd_sc_mcu7t5v0__filltie
Xoutput650 _1925_/ZN tl_d_esram_o[35] VDD VDD VSS VSS gf180mcu_fd_sc_mcu7t5v0__dlyd_1
Xoutput661 _1945_/ZN tl_d_esram_o[45] VDD VDD VSS VSS gf180mcu_fd_sc_mcu7t5v0__dlyd_1
Xoutput672 _1965_/ZN tl_d_esram_o[55] VDD VDD VSS VSS gf180mcu_fd_sc_mcu7t5v0__dlyd_1
Xoutput694 _2005_/ZN tl_d_esram_o[75] VDD VDD VSS VSS gf180mcu_fd_sc_mcu7t5v0__dlyd_1
Xoutput683 _1985_/ZN tl_d_esram_o[65] VDD VDD VSS VSS gf180mcu_fd_sc_mcu7t5v0__dlyd_1
XTAP_TAPCELL_ROW_6_334 VDD VSS gf180mcu_fd_sc_mcu7t5v0__filltie
XTAP_TAPCELL_ROW_6_323 VDD VSS gf180mcu_fd_sc_mcu7t5v0__filltie
XFILLER_87_842 VDD VDD VSS VSS gf180mcu_fd_sc_mcu7t5v0__fillcap_4
XFILLER_86_341 VDD VDD VSS VSS gf180mcu_fd_sc_mcu7t5v0__fill_2
XFILLER_59_566 VDD VDD VSS VSS gf180mcu_fd_sc_mcu7t5v0__fill_1
XFILLER_36_10 VDD VDD VSS VSS gf180mcu_fd_sc_mcu7t5v0__fill_2
XFILLER_42_422 VDD VDD VSS VSS gf180mcu_fd_sc_mcu7t5v0__fillcap_8
XTAP_TAPCELL_ROW_68_1072 VDD VSS gf180mcu_fd_sc_mcu7t5v0__filltie
XFILLER_11_842 VDD VDD VSS VSS gf180mcu_fd_sc_mcu7t5v0__fillcap_4
Xinput18 tl_d_dmem_i[24] input18/Z VDD VDD VSS VSS gf180mcu_fd_sc_mcu7t5v0__dlyd_1
Xinput29 tl_d_dmem_i[34] input29/Z VDD VDD VSS VSS gf180mcu_fd_sc_mcu7t5v0__dlyd_1
XFILLER_78_831 VDD VDD VSS VSS gf180mcu_fd_sc_mcu7t5v0__fill_1
XFILLER_89_190 VDD VDD VSS VSS gf180mcu_fd_sc_mcu7t5v0__fillcap_16
XFILLER_37_205 VDD VDD VSS VSS gf180mcu_fd_sc_mcu7t5v0__fillcap_4
X_1150_ _1144_/Z _1155_/A2 _1156_/B VDD VDD VSS VSS gf180mcu_fd_sc_mcu7t5v0__nand2_1
XFILLER_77_352 VDD VDD VSS VSS gf180mcu_fd_sc_mcu7t5v0__fillcap_16
XFILLER_37_216 VDD VDD VSS VSS gf180mcu_fd_sc_mcu7t5v0__fill_2
XFILLER_65_536 VDD VDD VSS VSS gf180mcu_fd_sc_mcu7t5v0__fill_1
XFILLER_65_558 VDD VDD VSS VSS gf180mcu_fd_sc_mcu7t5v0__fill_2
X_1081_ _1081_/I _1223_/A2 VDD VDD VSS VSS gf180mcu_fd_sc_mcu7t5v0__clkinv_1
XFILLER_92_399 VDD VDD VSS VSS gf180mcu_fd_sc_mcu7t5v0__fillcap_16
XFILLER_33_422 VDD VDD VSS VSS gf180mcu_fd_sc_mcu7t5v0__fillcap_64
XFILLER_45_282 VDD VDD VSS VSS gf180mcu_fd_sc_mcu7t5v0__fillcap_8
X_1983_ _1983_/I _1983_/ZN VDD VDD VSS VSS gf180mcu_fd_sc_mcu7t5v0__clkinv_1
XTAP_TAPCELL_ROW_31_634 VDD VSS gf180mcu_fd_sc_mcu7t5v0__filltie
XTAP_TAPCELL_ROW_31_623 VDD VSS gf180mcu_fd_sc_mcu7t5v0__filltie
XTAP_TAPCELL_ROW_11_391 VDD VSS gf180mcu_fd_sc_mcu7t5v0__filltie
X_2535_ _2535_/A1 _2702_/I _2535_/B _2600_/D VDD VDD VSS VSS gf180mcu_fd_sc_mcu7t5v0__oai21_1
X_2466_ _2466_/A1 _2471_/S _2466_/B _2577_/D VDD VDD VSS VSS gf180mcu_fd_sc_mcu7t5v0__aoi21_1
X_1417_ _1441_/A1 _2333_/A2 _1417_/Z VDD VDD VSS VSS gf180mcu_fd_sc_mcu7t5v0__and2_1
XFILLER_69_842 VDD VDD VSS VSS gf180mcu_fd_sc_mcu7t5v0__fillcap_16
XFILLER_28_205 VDD VDD VSS VSS gf180mcu_fd_sc_mcu7t5v0__fill_2
X_2397_ _2397_/I0 _2553_/Q _2397_/S _2553_/D VDD VDD VSS VSS gf180mcu_fd_sc_mcu7t5v0__mux2_2
XFILLER_84_823 VDD VDD VSS VSS gf180mcu_fd_sc_mcu7t5v0__fillcap_8
XFILLER_84_801 VDD VDD VSS VSS gf180mcu_fd_sc_mcu7t5v0__fillcap_4
XFILLER_28_216 VDD VDD VSS VSS gf180mcu_fd_sc_mcu7t5v0__fillcap_16
XFILLER_28_238 VDD VDD VSS VSS gf180mcu_fd_sc_mcu7t5v0__fillcap_4
X_1348_ input21/Z _1348_/A2 _1348_/B1 _1444_/B2 _1349_/I VDD VDD VSS VSS gf180mcu_fd_sc_mcu7t5v0__aoi22_1
XTAP_TAPCELL_ROW_39_723 VDD VSS gf180mcu_fd_sc_mcu7t5v0__filltie
X_1279_ _1399_/A1 _1279_/A2 _1279_/ZN VDD VDD VSS VSS gf180mcu_fd_sc_mcu7t5v0__nor2_1
XFILLER_24_411 VDD VDD VSS VSS gf180mcu_fd_sc_mcu7t5v0__fillcap_8
XFILLER_36_260 VDD VDD VSS VSS gf180mcu_fd_sc_mcu7t5v0__fill_1
XTAP_TAPCELL_ROW_104_1504 VDD VSS gf180mcu_fd_sc_mcu7t5v0__filltie
XTAP_TAPCELL_ROW_19_480 VDD VSS gf180mcu_fd_sc_mcu7t5v0__filltie
XFILLER_20_661 VDD VDD VSS VSS gf180mcu_fd_sc_mcu7t5v0__fillcap_4
XTAP_TAPCELL_ROW_115_1633 VDD VSS gf180mcu_fd_sc_mcu7t5v0__filltie
Xfanout1105 _1221_/ZN _1665_/S VDD VDD VSS VSS gf180mcu_fd_sc_mcu7t5v0__dlyd_1
Xfanout1138 _1196_/ZN _1854_/B1 VDD VDD VSS VSS gf180mcu_fd_sc_mcu7t5v0__dlyd_1
XPHY_EDGE_ROW_110_Right_110 VDD VSS gf180mcu_fd_sc_mcu7t5v0__endcap
XFILLER_59_352 VDD VDD VSS VSS gf180mcu_fd_sc_mcu7t5v0__fillcap_64
Xfanout1149 _2362_/A1 _2378_/A1 VDD VDD VSS VSS gf180mcu_fd_sc_mcu7t5v0__dlyd_1
Xwire1233 _1694_/B2 _2706_/I VDD VDD VSS VSS gf180mcu_fd_sc_mcu7t5v0__clkbuf_8
XFILLER_27_260 VDD VDD VSS VSS gf180mcu_fd_sc_mcu7t5v0__fillcap_16
XFILLER_74_377 VDD VDD VSS VSS gf180mcu_fd_sc_mcu7t5v0__fillcap_8
XFILLER_15_422 VDD VDD VSS VSS gf180mcu_fd_sc_mcu7t5v0__fillcap_64
XFILLER_27_282 VDD VDD VSS VSS gf180mcu_fd_sc_mcu7t5v0__fill_1
XFILLER_30_436 VDD VDD VSS VSS gf180mcu_fd_sc_mcu7t5v0__fillcap_4
XFILLER_11_650 VDD VDD VSS VSS gf180mcu_fd_sc_mcu7t5v0__fill_1
XPHY_EDGE_ROW_7_Left_126 VDD VSS gf180mcu_fd_sc_mcu7t5v0__endcap
X_2320_ _2320_/A1 _2320_/A2 _2348_/B _2320_/ZN VDD VDD VSS VSS gf180mcu_fd_sc_mcu7t5v0__aoi21_1
XTAP_TAPCELL_ROW_90_1338 VDD VSS gf180mcu_fd_sc_mcu7t5v0__filltie
X_2251_ _2541_/Q _2544_/Q _2251_/A3 _2251_/A4 _2252_/A2 VDD VDD VSS VSS gf180mcu_fd_sc_mcu7t5v0__nor4_1
XFILLER_66_801 VDD VDD VSS VSS gf180mcu_fd_sc_mcu7t5v0__fillcap_4
X_1202_ input2/Z _1219_/A1 _1202_/B _1203_/B VDD VDD VSS VSS gf180mcu_fd_sc_mcu7t5v0__aoi21_1
XFILLER_78_661 VDD VDD VSS VSS gf180mcu_fd_sc_mcu7t5v0__fillcap_4
XFILLER_66_823 VDD VDD VSS VSS gf180mcu_fd_sc_mcu7t5v0__fillcap_8
X_2182_ _2581_/Q _2140_/B _2183_/A3 VDD VDD VSS VSS gf180mcu_fd_sc_mcu7t5v0__nand2_1
XFILLER_77_182 VDD VDD VSS VSS gf180mcu_fd_sc_mcu7t5v0__fill_1
X_1133_ _2745_/I _2744_/I _2746_/I _2747_/I _1143_/A3 VDD VDD VSS VSS gf180mcu_fd_sc_mcu7t5v0__nor4_1
XFILLER_25_208 VDD VDD VSS VSS gf180mcu_fd_sc_mcu7t5v0__fill_2
X_1064_ _2577_/Q _2466_/A1 VDD VDD VSS VSS gf180mcu_fd_sc_mcu7t5v0__clkinv_1
XFILLER_34_731 VDD VDD VSS VSS gf180mcu_fd_sc_mcu7t5v0__fillcap_4
XFILLER_21_403 VDD VDD VSS VSS gf180mcu_fd_sc_mcu7t5v0__fillcap_16
XTAP_TAPCELL_ROW_16_450 VDD VSS gf180mcu_fd_sc_mcu7t5v0__filltie
XTAP_TAPCELL_ROW_44_781 VDD VSS gf180mcu_fd_sc_mcu7t5v0__filltie
X_1966_ _1966_/A1 _1976_/A2 _2014_/B1 _1966_/B2 _1967_/I VDD VDD VSS VSS gf180mcu_fd_sc_mcu7t5v0__aoi22_1
X_1897_ _1897_/I _1897_/ZN VDD VDD VSS VSS gf180mcu_fd_sc_mcu7t5v0__clkinv_1
X_2518_ _2526_/B _2526_/C _2519_/A2 _2518_/Z VDD VDD VSS VSS gf180mcu_fd_sc_mcu7t5v0__and3_1
Xinput208 tl_d_uart_i[17] _1270_/A1 VDD VDD VSS VSS gf180mcu_fd_sc_mcu7t5v0__dlyd_1
Xinput219 tl_d_uart_i[27] _1350_/A1 VDD VDD VSS VSS gf180mcu_fd_sc_mcu7t5v0__dlyd_1
X_2449_ _2566_/Q _2565_/Q _2775_/I _2445_/B _2449_/Z VDD VDD VSS VSS gf180mcu_fd_sc_mcu7t5v0__or4_1
XTAP_TAPCELL_ROW_110_1574 VDD VSS gf180mcu_fd_sc_mcu7t5v0__filltie
XFILLER_69_694 VDD VDD VSS VSS gf180mcu_fd_sc_mcu7t5v0__fillcap_4
XFILLER_84_675 VDD VDD VSS VSS gf180mcu_fd_sc_mcu7t5v0__fillcap_4
XTAP_TAPCELL_ROW_65_1031 VDD VSS gf180mcu_fd_sc_mcu7t5v0__filltie
XTAP_TAPCELL_ROW_65_1042 VDD VSS gf180mcu_fd_sc_mcu7t5v0__filltie
XFILLER_40_734 VDD VDD VSS VSS gf180mcu_fd_sc_mcu7t5v0__fill_1
XTAP_TAPCELL_ROW_76_1171 VDD VSS gf180mcu_fd_sc_mcu7t5v0__filltie
XFILLER_0_852 VDD VDD VSS VSS gf180mcu_fd_sc_mcu7t5v0__fillcap_8
XFILLER_48_823 VDD VDD VSS VSS gf180mcu_fd_sc_mcu7t5v0__fillcap_8
XFILLER_62_314 VDD VDD VSS VSS gf180mcu_fd_sc_mcu7t5v0__fill_1
XFILLER_16_731 VDD VDD VSS VSS gf180mcu_fd_sc_mcu7t5v0__fillcap_4
XFILLER_90_667 VDD VDD VSS VSS gf180mcu_fd_sc_mcu7t5v0__fillcap_16
XFILLER_90_645 VDD VDD VSS VSS gf180mcu_fd_sc_mcu7t5v0__fillcap_8
XFILLER_50_509 VDD VDD VSS VSS gf180mcu_fd_sc_mcu7t5v0__fillcap_16
XFILLER_30_200 VDD VDD VSS VSS gf180mcu_fd_sc_mcu7t5v0__fillcap_16
XFILLER_30_244 VDD VDD VSS VSS gf180mcu_fd_sc_mcu7t5v0__fill_1
X_1820_ _2010_/A1 _1826_/A2 _2533_/A2 _2737_/I _1821_/I VDD VDD VSS VSS gf180mcu_fd_sc_mcu7t5v0__aoi22_1
XTAP_TAPCELL_ROW_41_751 VDD VSS gf180mcu_fd_sc_mcu7t5v0__filltie
X_1751_ _1751_/I _1751_/ZN VDD VDD VSS VSS gf180mcu_fd_sc_mcu7t5v0__clkinv_1
X_1682_ _1872_/A1 _1720_/A2 _1720_/B1 _1872_/B2 _1683_/I VDD VDD VSS VSS gf180mcu_fd_sc_mcu7t5v0__aoi22_1
XFILLER_116_349 VDD VDD VSS VSS gf180mcu_fd_sc_mcu7t5v0__fill_1
X_2303_ input88/Z _2323_/A2 _2311_/A3 _2304_/A2 VDD VDD VSS VSS gf180mcu_fd_sc_mcu7t5v0__nand3_1
XFILLER_97_277 VDD VDD VSS VSS gf180mcu_fd_sc_mcu7t5v0__fill_2
X_2234_ _1116_/B _2234_/A2 _2234_/A3 _2235_/C VDD VDD VSS VSS gf180mcu_fd_sc_mcu7t5v0__nand3_1
XFILLER_38_333 VDD VDD VSS VSS gf180mcu_fd_sc_mcu7t5v0__fillcap_8
X_2165_ _2142_/B _2165_/A2 _2234_/A2 _2166_/C VDD VDD VSS VSS gf180mcu_fd_sc_mcu7t5v0__nand3_1
XTAP_TAPCELL_ROW_49_840 VDD VSS gf180mcu_fd_sc_mcu7t5v0__filltie
XFILLER_65_174 VDD VDD VSS VSS gf180mcu_fd_sc_mcu7t5v0__fillcap_8
XFILLER_66_675 VDD VDD VSS VSS gf180mcu_fd_sc_mcu7t5v0__fillcap_4
XFILLER_66_697 VDD VDD VSS VSS gf180mcu_fd_sc_mcu7t5v0__fillcap_32
X_1116_ _2233_/A2 _2141_/A1 _1116_/B _2170_/B1 VDD VDD VSS VSS gf180mcu_fd_sc_mcu7t5v0__oai21_1
XFILLER_93_483 VDD VDD VSS VSS gf180mcu_fd_sc_mcu7t5v0__fillcap_4
XFILLER_0_70 VDD VDD VSS VSS gf180mcu_fd_sc_mcu7t5v0__fill_2
X_2096_ _2212_/A1 _2377_/A1 _2098_/A1 VDD VDD VSS VSS gf180mcu_fd_sc_mcu7t5v0__nand2_1
XFILLER_34_594 VDD VDD VSS VSS gf180mcu_fd_sc_mcu7t5v0__fill_1
XFILLER_80_177 VDD VDD VSS VSS gf180mcu_fd_sc_mcu7t5v0__fillcap_8
XFILLER_21_288 VDD VDD VSS VSS gf180mcu_fd_sc_mcu7t5v0__fill_1
X_1949_ _1949_/I _1949_/ZN VDD VDD VSS VSS gf180mcu_fd_sc_mcu7t5v0__clkinv_1
XFILLER_103_500 VDD VDD VSS VSS gf180mcu_fd_sc_mcu7t5v0__fillcap_8
XTAP_TAPCELL_ROW_112_1603 VDD VSS gf180mcu_fd_sc_mcu7t5v0__filltie
XFILLER_49_609 VDD VDD VSS VSS gf180mcu_fd_sc_mcu7t5v0__fillcap_16
XFILLER_88_244 VDD VDD VSS VSS gf180mcu_fd_sc_mcu7t5v0__fill_1
XFILLER_88_299 VDD VDD VSS VSS gf180mcu_fd_sc_mcu7t5v0__fill_2
Xload_slew1115 _1467_/A1 _1339_/A1 VDD VDD VSS VSS gf180mcu_fd_sc_mcu7t5v0__buf_4
XFILLER_29_366 VDD VDD VSS VSS gf180mcu_fd_sc_mcu7t5v0__fillcap_16
XFILLER_44_314 VDD VDD VSS VSS gf180mcu_fd_sc_mcu7t5v0__fill_1
XFILLER_57_697 VDD VDD VSS VSS gf180mcu_fd_sc_mcu7t5v0__fill_2
Xload_slew1137 _1850_/B1 _1838_/B1 VDD VDD VSS VSS gf180mcu_fd_sc_mcu7t5v0__buf_3
Xload_slew1148 _2302_/A1 _2346_/A1 VDD VDD VSS VSS gf180mcu_fd_sc_mcu7t5v0__buf_2
Xload_slew1159 _1490_/A2 _2116_/B1 VDD VDD VSS VSS gf180mcu_fd_sc_mcu7t5v0__clkbuf_4
XFILLER_44_10 VDD VDD VSS VSS gf180mcu_fd_sc_mcu7t5v0__fill_2
XFILLER_56_185 VDD VDD VSS VSS gf180mcu_fd_sc_mcu7t5v0__fillcap_4
XPHY_EDGE_ROW_88_Left_207 VDD VSS gf180mcu_fd_sc_mcu7t5v0__endcap
XFILLER_60_807 VDD VDD VSS VSS gf180mcu_fd_sc_mcu7t5v0__fillcap_16
XTAP_TAPCELL_ROW_27_578 VDD VSS gf180mcu_fd_sc_mcu7t5v0__filltie
XFILLER_72_667 VDD VDD VSS VSS gf180mcu_fd_sc_mcu7t5v0__fillcap_8
XFILLER_52_380 VDD VDD VSS VSS gf180mcu_fd_sc_mcu7t5v0__fillcap_4
XFILLER_40_597 VDD VDD VSS VSS gf180mcu_fd_sc_mcu7t5v0__fillcap_64
XPHY_EDGE_ROW_97_Left_216 VDD VSS gf180mcu_fd_sc_mcu7t5v0__endcap
XFILLER_79_244 VDD VDD VSS VSS gf180mcu_fd_sc_mcu7t5v0__fillcap_16
XPHY_EDGE_ROW_13_Right_13 VDD VSS gf180mcu_fd_sc_mcu7t5v0__endcap
XFILLER_94_247 VDD VDD VSS VSS gf180mcu_fd_sc_mcu7t5v0__fill_1
XFILLER_35_303 VDD VDD VSS VSS gf180mcu_fd_sc_mcu7t5v0__fill_1
XFILLER_47_152 VDD VDD VSS VSS gf180mcu_fd_sc_mcu7t5v0__fillcap_32
XFILLER_48_664 VDD VDD VSS VSS gf180mcu_fd_sc_mcu7t5v0__fill_1
XTAP_TAPCELL_ROW_46_810 VDD VSS gf180mcu_fd_sc_mcu7t5v0__filltie
XFILLER_63_689 VDD VDD VSS VSS gf180mcu_fd_sc_mcu7t5v0__fillcap_8
XFILLER_50_317 VDD VDD VSS VSS gf180mcu_fd_sc_mcu7t5v0__fillcap_32
XFILLER_62_177 VDD VDD VSS VSS gf180mcu_fd_sc_mcu7t5v0__fillcap_16
XFILLER_31_531 VDD VDD VSS VSS gf180mcu_fd_sc_mcu7t5v0__fill_2
X_1803_ _1803_/I _1803_/ZN VDD VDD VSS VSS gf180mcu_fd_sc_mcu7t5v0__clkinv_1
XPHY_EDGE_ROW_22_Right_22 VDD VSS gf180mcu_fd_sc_mcu7t5v0__endcap
X_1734_ _1924_/A1 _1772_/A2 _1772_/B1 _1924_/B2 _1735_/I VDD VDD VSS VSS gf180mcu_fd_sc_mcu7t5v0__aoi22_1
X_1665_ _1882_/B2 _1618_/Z _1665_/S _1665_/Z VDD VDD VSS VSS gf180mcu_fd_sc_mcu7t5v0__mux2_2
X_1596_ _1593_/Z _1595_/Z _1596_/Z VDD VDD VSS VSS gf180mcu_fd_sc_mcu7t5v0__xor2_1
XFILLER_98_575 VDD VDD VSS VSS gf180mcu_fd_sc_mcu7t5v0__fillcap_4
XFILLER_58_439 VDD VDD VSS VSS gf180mcu_fd_sc_mcu7t5v0__fillcap_16
XPHY_EDGE_ROW_31_Right_31 VDD VSS gf180mcu_fd_sc_mcu7t5v0__endcap
XFILLER_98_597 VDD VDD VSS VSS gf180mcu_fd_sc_mcu7t5v0__fill_1
XFILLER_86_737 VDD VDD VSS VSS gf180mcu_fd_sc_mcu7t5v0__fillcap_16
X_2217_ _2217_/A1 _2224_/C _2217_/B1 _2217_/B2 _2217_/ZN VDD VDD VSS VSS gf180mcu_fd_sc_mcu7t5v0__aoi22_2
XFILLER_38_174 VDD VDD VSS VSS gf180mcu_fd_sc_mcu7t5v0__fill_1
XFILLER_38_185 VDD VDD VSS VSS gf180mcu_fd_sc_mcu7t5v0__fillcap_4
XFILLER_38_196 VDD VDD VSS VSS gf180mcu_fd_sc_mcu7t5v0__fillcap_4
X_2148_ _2148_/A1 _2233_/A2 _2149_/A2 VDD VDD VSS VSS gf180mcu_fd_sc_mcu7t5v0__nand2_1
XFILLER_93_291 VDD VDD VSS VSS gf180mcu_fd_sc_mcu7t5v0__fillcap_8
XFILLER_42_807 VDD VDD VSS VSS gf180mcu_fd_sc_mcu7t5v0__fillcap_16
X_2079_ _2079_/I _2079_/ZN VDD VDD VSS VSS gf180mcu_fd_sc_mcu7t5v0__clkinv_1
XTAP_TAPCELL_ROW_62_1001 VDD VSS gf180mcu_fd_sc_mcu7t5v0__filltie
XFILLER_34_391 VDD VDD VSS VSS gf180mcu_fd_sc_mcu7t5v0__fill_2
XTAP_TAPCELL_ROW_24_548 VDD VSS gf180mcu_fd_sc_mcu7t5v0__filltie
XTAP_TAPCELL_ROW_52_879 VDD VSS gf180mcu_fd_sc_mcu7t5v0__filltie
XPHY_EDGE_ROW_40_Right_40 VDD VSS gf180mcu_fd_sc_mcu7t5v0__endcap
XFILLER_22_597 VDD VDD VSS VSS gf180mcu_fd_sc_mcu7t5v0__fillcap_64
XTAP_TAPCELL_ROW_73_1130 VDD VSS gf180mcu_fd_sc_mcu7t5v0__filltie
XFILLER_103_352 VDD VDD VSS VSS gf180mcu_fd_sc_mcu7t5v0__fillcap_16
XFILLER_89_542 VDD VDD VSS VSS gf180mcu_fd_sc_mcu7t5v0__fillcap_16
XFILLER_1_479 VDD VDD VSS VSS gf180mcu_fd_sc_mcu7t5v0__fillcap_8
XFILLER_39_76 VDD VDD VSS VSS gf180mcu_fd_sc_mcu7t5v0__fill_2
XFILLER_76_247 VDD VDD VSS VSS gf180mcu_fd_sc_mcu7t5v0__fillcap_16
XFILLER_91_217 VDD VDD VSS VSS gf180mcu_fd_sc_mcu7t5v0__fill_1
XFILLER_72_453 VDD VDD VSS VSS gf180mcu_fd_sc_mcu7t5v0__fill_2
XFILLER_32_317 VDD VDD VSS VSS gf180mcu_fd_sc_mcu7t5v0__fillcap_32
XTAP_TAPCELL_ROW_84_1270 VDD VSS gf180mcu_fd_sc_mcu7t5v0__filltie
XFILLER_41_851 VDD VDD VSS VSS gf180mcu_fd_sc_mcu7t5v0__fillcap_8
XFILLER_40_383 VDD VDD VSS VSS gf180mcu_fd_sc_mcu7t5v0__fill_2
X_1450_ _2351_/A1 _2158_/A2 _2379_/A3 _1451_/B VDD VDD VSS VSS gf180mcu_fd_sc_mcu7t5v0__nand3_1
X_1381_ _1381_/I _1382_/B1 VDD VDD VSS VSS gf180mcu_fd_sc_mcu7t5v0__clkinv_1
XFILLER_68_737 VDD VDD VSS VSS gf180mcu_fd_sc_mcu7t5v0__fillcap_64
XFILLER_68_726 VDD VDD VSS VSS gf180mcu_fd_sc_mcu7t5v0__fillcap_8
XFILLER_48_450 VDD VDD VSS VSS gf180mcu_fd_sc_mcu7t5v0__fillcap_4
Xinput380 tl_h_i_i[0] _2403_/A1 VDD VDD VSS VSS gf180mcu_fd_sc_mcu7t5v0__dlyd_1
Xinput391 tl_h_i_i[10] _1874_/A1 VDD VDD VSS VSS gf180mcu_fd_sc_mcu7t5v0__dlyd_1
X_2002_ _2002_/A1 _2022_/A2 _2022_/B1 _2733_/I _2003_/I VDD VDD VSS VSS gf180mcu_fd_sc_mcu7t5v0__aoi22_1
XFILLER_24_807 VDD VDD VSS VSS gf180mcu_fd_sc_mcu7t5v0__fillcap_16
XFILLER_36_656 VDD VDD VSS VSS gf180mcu_fd_sc_mcu7t5v0__fillcap_8
XFILLER_36_667 VDD VDD VSS VSS gf180mcu_fd_sc_mcu7t5v0__fillcap_64
XFILLER_35_177 VDD VDD VSS VSS gf180mcu_fd_sc_mcu7t5v0__fill_2
XFILLER_50_169 VDD VDD VSS VSS gf180mcu_fd_sc_mcu7t5v0__fillcap_4
XTAP_TAPCELL_ROW_21_507 VDD VSS gf180mcu_fd_sc_mcu7t5v0__filltie
XTAP_TAPCELL_ROW_98_1428 VDD VSS gf180mcu_fd_sc_mcu7t5v0__filltie
XFILLER_117_422 VDD VDD VSS VSS gf180mcu_fd_sc_mcu7t5v0__fill_1
X_2766_ _2766_/I _2766_/Z VDD VDD VSS VSS gf180mcu_fd_sc_mcu7t5v0__buf_1
X_2697_ _2697_/I _2697_/Z VDD VDD VSS VSS gf180mcu_fd_sc_mcu7t5v0__buf_1
Xoutput821 _1662_/Z tl_d_uart_o[11] VDD VDD VSS VSS gf180mcu_fd_sc_mcu7t5v0__dlyd_1
Xoutput810 _2763_/Z tl_d_uart_o[104] VDD VDD VSS VSS gf180mcu_fd_sc_mcu7t5v0__dlyd_1
X_1717_ _1717_/I _1717_/ZN VDD VDD VSS VSS gf180mcu_fd_sc_mcu7t5v0__clkinv_1
Xoutput854 _1632_/Z tl_d_uart_o[41] VDD VDD VSS VSS gf180mcu_fd_sc_mcu7t5v0__dlyd_1
Xoutput843 _1622_/Z tl_d_uart_o[31] VDD VDD VSS VSS gf180mcu_fd_sc_mcu7t5v0__dlyd_1
Xoutput832 _2712_/Z tl_d_uart_o[21] VDD VDD VSS VSS gf180mcu_fd_sc_mcu7t5v0__dlyd_1
X_1648_ _1968_/B2 _1651_/A2 _1648_/Z VDD VDD VSS VSS gf180mcu_fd_sc_mcu7t5v0__or2_1
Xoutput887 _2730_/Z tl_d_uart_o[71] VDD VDD VSS VSS gf180mcu_fd_sc_mcu7t5v0__dlyd_1
Xoutput876 _2720_/Z tl_d_uart_o[61] VDD VDD VSS VSS gf180mcu_fd_sc_mcu7t5v0__dlyd_1
Xoutput865 _1642_/Z tl_d_uart_o[51] VDD VDD VSS VSS gf180mcu_fd_sc_mcu7t5v0__dlyd_1
Xoutput898 _2740_/Z tl_d_uart_o[81] VDD VDD VSS VSS gf180mcu_fd_sc_mcu7t5v0__dlyd_1
X_1579_ _1574_/Z _1578_/Z _1579_/Z VDD VDD VSS VSS gf180mcu_fd_sc_mcu7t5v0__xor2_1
XFILLER_100_333 VDD VDD VSS VSS gf180mcu_fd_sc_mcu7t5v0__fillcap_4
XFILLER_58_247 VDD VDD VSS VSS gf180mcu_fd_sc_mcu7t5v0__fillcap_16
XTAP_TAPCELL_ROW_29_607 VDD VSS gf180mcu_fd_sc_mcu7t5v0__filltie
XFILLER_86_578 VDD VDD VSS VSS gf180mcu_fd_sc_mcu7t5v0__fillcap_8
XTAP_TAPCELL_ROW_57_938 VDD VSS gf180mcu_fd_sc_mcu7t5v0__filltie
XTAP_TAPCELL_ROW_1_265 VDD VSS gf180mcu_fd_sc_mcu7t5v0__filltie
XTAP_TAPCELL_ROW_107_1546 VDD VSS gf180mcu_fd_sc_mcu7t5v0__filltie
XTAP_TAPCELL_ROW_107_1535 VDD VSS gf180mcu_fd_sc_mcu7t5v0__filltie
XFILLER_14_317 VDD VDD VSS VSS gf180mcu_fd_sc_mcu7t5v0__fillcap_16
XFILLER_25_56 VDD VDD VSS VSS gf180mcu_fd_sc_mcu7t5v0__fill_1
XTAP_TAPCELL_ROW_37_695 VDD VSS gf180mcu_fd_sc_mcu7t5v0__filltie
XFILLER_10_589 VDD VDD VSS VSS gf180mcu_fd_sc_mcu7t5v0__fillcap_4
XTAP_TAPCELL_ROW_118_1686 VDD VSS gf180mcu_fd_sc_mcu7t5v0__filltie
XTAP_TAPCELL_ROW_118_1675 VDD VSS gf180mcu_fd_sc_mcu7t5v0__filltie
XFILLER_104_650 VDD VDD VSS VSS gf180mcu_fd_sc_mcu7t5v0__fill_1
XTAP_TAPCELL_ROW_9_365 VDD VSS gf180mcu_fd_sc_mcu7t5v0__filltie
XFILLER_49_236 VDD VDD VSS VSS gf180mcu_fd_sc_mcu7t5v0__fill_2
XFILLER_92_559 VDD VDD VSS VSS gf180mcu_fd_sc_mcu7t5v0__fillcap_16
XFILLER_18_667 VDD VDD VSS VSS gf180mcu_fd_sc_mcu7t5v0__fillcap_64
XFILLER_32_103 VDD VDD VSS VSS gf180mcu_fd_sc_mcu7t5v0__fill_2
XFILLER_33_626 VDD VDD VSS VSS gf180mcu_fd_sc_mcu7t5v0__fillcap_4
XFILLER_60_434 VDD VDD VSS VSS gf180mcu_fd_sc_mcu7t5v0__fill_2
XFILLER_60_489 VDD VDD VSS VSS gf180mcu_fd_sc_mcu7t5v0__fillcap_16
X_2551_ _2551_/D _2583_/RN _2596_/CLK _2551_/Q VDD VDD VSS VSS gf180mcu_fd_sc_mcu7t5v0__dffrnq_1
X_2482_ _2485_/A2 _2485_/A3 _2482_/B _2492_/B VDD VDD VSS VSS gf180mcu_fd_sc_mcu7t5v0__aoi21_1
X_1502_ _1502_/A1 _1510_/A2 _1502_/B1 _2208_/B _1503_/A2 VDD VDD VSS VSS gf180mcu_fd_sc_mcu7t5v0__aoi22_1
X_1433_ _1441_/A1 _2341_/A2 _1433_/Z VDD VDD VSS VSS gf180mcu_fd_sc_mcu7t5v0__and2_1
XTAP_TAPCELL_ROW_93_1369 VDD VSS gf180mcu_fd_sc_mcu7t5v0__filltie
XFILLER_68_523 VDD VDD VSS VSS gf180mcu_fd_sc_mcu7t5v0__fill_2
X_1364_ input23/Z _1468_/A2 _1364_/B1 _2160_/A2 _1365_/I VDD VDD VSS VSS gf180mcu_fd_sc_mcu7t5v0__aoi22_1
X_1295_ _1399_/A1 _1295_/A2 _1295_/ZN VDD VDD VSS VSS gf180mcu_fd_sc_mcu7t5v0__nor2_1
XFILLER_83_515 VDD VDD VSS VSS gf180mcu_fd_sc_mcu7t5v0__fillcap_32
XTAP_TAPCELL_ROW_54_908 VDD VSS gf180mcu_fd_sc_mcu7t5v0__filltie
XFILLER_83_559 VDD VDD VSS VSS gf180mcu_fd_sc_mcu7t5v0__fill_1
XTAP_TAPCELL_ROW_34_665 VDD VSS gf180mcu_fd_sc_mcu7t5v0__filltie
XTAP_TAPCELL_ROW_62_996 VDD VSS gf180mcu_fd_sc_mcu7t5v0__filltie
XTAP_TAPCELL_ROW_102_1476 VDD VSS gf180mcu_fd_sc_mcu7t5v0__filltie
XFILLER_109_208 VDD VDD VSS VSS gf180mcu_fd_sc_mcu7t5v0__fill_2
X_2749_ _2749_/I _2749_/Z VDD VDD VSS VSS gf180mcu_fd_sc_mcu7t5v0__buf_1
Xoutput640 _1907_/ZN tl_d_esram_o[26] VDD VDD VSS VSS gf180mcu_fd_sc_mcu7t5v0__dlyd_1
Xoutput651 _1927_/ZN tl_d_esram_o[36] VDD VDD VSS VSS gf180mcu_fd_sc_mcu7t5v0__dlyd_1
Xoutput662 _1947_/ZN tl_d_esram_o[46] VDD VDD VSS VSS gf180mcu_fd_sc_mcu7t5v0__dlyd_1
Xoutput695 _2007_/ZN tl_d_esram_o[76] VDD VDD VSS VSS gf180mcu_fd_sc_mcu7t5v0__dlyd_1
Xoutput684 _1987_/ZN tl_d_esram_o[66] VDD VDD VSS VSS gf180mcu_fd_sc_mcu7t5v0__dlyd_1
Xoutput673 _1967_/ZN tl_d_esram_o[56] VDD VDD VSS VSS gf180mcu_fd_sc_mcu7t5v0__dlyd_1
XTAP_TAPCELL_ROW_70_1100 VDD VSS gf180mcu_fd_sc_mcu7t5v0__filltie
XTAP_TAPCELL_ROW_6_324 VDD VSS gf180mcu_fd_sc_mcu7t5v0__filltie
XFILLER_59_556 VDD VDD VSS VSS gf180mcu_fd_sc_mcu7t5v0__fillcap_4
XFILLER_74_559 VDD VDD VSS VSS gf180mcu_fd_sc_mcu7t5v0__fill_2
XFILLER_15_626 VDD VDD VSS VSS gf180mcu_fd_sc_mcu7t5v0__fillcap_4
XFILLER_27_486 VDD VDD VSS VSS gf180mcu_fd_sc_mcu7t5v0__fillcap_4
XTAP_TAPCELL_ROW_68_1073 VDD VSS gf180mcu_fd_sc_mcu7t5v0__filltie
XFILLER_11_865 VDD VDD VSS VSS gf180mcu_fd_sc_mcu7t5v0__fill_1
XFILLER_22_191 VDD VDD VSS VSS gf180mcu_fd_sc_mcu7t5v0__fillcap_4
Xinput19 tl_d_dmem_i[25] input19/Z VDD VDD VSS VSS gf180mcu_fd_sc_mcu7t5v0__dlyd_1
XFILLER_7_858 VDD VDD VSS VSS gf180mcu_fd_sc_mcu7t5v0__fillcap_8
XPHY_EDGE_ROW_70_Left_189 VDD VSS gf180mcu_fd_sc_mcu7t5v0__endcap
X_1080_ _2548_/Q _2392_/A1 VDD VDD VSS VSS gf180mcu_fd_sc_mcu7t5v0__clkinv_1
XFILLER_92_356 VDD VDD VSS VSS gf180mcu_fd_sc_mcu7t5v0__fillcap_4
XFILLER_73_570 VDD VDD VSS VSS gf180mcu_fd_sc_mcu7t5v0__fill_2
X_1982_ _1982_/A1 _1982_/A2 _1998_/B1 _2723_/I _1983_/I VDD VDD VSS VSS gf180mcu_fd_sc_mcu7t5v0__aoi22_1
XTAP_TAPCELL_ROW_31_624 VDD VSS gf180mcu_fd_sc_mcu7t5v0__filltie
XTAP_TAPCELL_ROW_11_392 VDD VSS gf180mcu_fd_sc_mcu7t5v0__filltie
X_2534_ _2534_/A1 _2534_/A2 _2535_/B VDD VDD VSS VSS gf180mcu_fd_sc_mcu7t5v0__nand2_1
X_2465_ _2699_/I _2471_/S _2466_/B VDD VDD VSS VSS gf180mcu_fd_sc_mcu7t5v0__nor2_1
X_2396_ _2396_/I0 _2552_/Q _2398_/S _2552_/D VDD VDD VSS VSS gf180mcu_fd_sc_mcu7t5v0__mux2_2
X_1416_ _1416_/A1 _1496_/A2 _2333_/A2 VDD VDD VSS VSS gf180mcu_fd_sc_mcu7t5v0__nand2_1
X_1347_ _1467_/A1 _1345_/Z _1347_/B _1348_/B1 VDD VDD VSS VSS gf180mcu_fd_sc_mcu7t5v0__oai21_1
XTAP_TAPCELL_ROW_39_724 VDD VSS gf180mcu_fd_sc_mcu7t5v0__filltie
XFILLER_83_312 VDD VDD VSS VSS gf180mcu_fd_sc_mcu7t5v0__fill_1
X_1278_ _1278_/A1 _1406_/A2 _1278_/B1 _2146_/C _1279_/A2 VDD VDD VSS VSS gf180mcu_fd_sc_mcu7t5v0__aoi22_1
XFILLER_43_209 VDD VDD VSS VSS gf180mcu_fd_sc_mcu7t5v0__fill_1
XTAP_TAPCELL_ROW_104_1505 VDD VSS gf180mcu_fd_sc_mcu7t5v0__filltie
XFILLER_64_592 VDD VDD VSS VSS gf180mcu_fd_sc_mcu7t5v0__fill_2
XTAP_TAPCELL_ROW_19_481 VDD VSS gf180mcu_fd_sc_mcu7t5v0__filltie
XFILLER_51_275 VDD VDD VSS VSS gf180mcu_fd_sc_mcu7t5v0__fillcap_4
XFILLER_118_550 VDD VDD VSS VSS gf180mcu_fd_sc_mcu7t5v0__fill_2
XTAP_TAPCELL_ROW_115_1634 VDD VSS gf180mcu_fd_sc_mcu7t5v0__filltie
Xfanout1106 fanout1107/Z _1533_/A2 VDD VDD VSS VSS gf180mcu_fd_sc_mcu7t5v0__dlyd_1
Xfanout1117 _1396_/A2 _1500_/A2 VDD VDD VSS VSS gf180mcu_fd_sc_mcu7t5v0__dlyd_1
Xfanout1128 _1768_/B1 _1718_/B1 VDD VDD VSS VSS gf180mcu_fd_sc_mcu7t5v0__dlyd_1
XFILLER_47_504 VDD VDD VSS VSS gf180mcu_fd_sc_mcu7t5v0__fill_1
Xwire1201 _2246_/C _2178_/C VDD VDD VSS VSS gf180mcu_fd_sc_mcu7t5v0__clkbuf_4
XFILLER_86_172 VDD VDD VSS VSS gf180mcu_fd_sc_mcu7t5v0__fill_2
XFILLER_86_161 VDD VDD VSS VSS gf180mcu_fd_sc_mcu7t5v0__fill_2
XFILLER_47_559 VDD VDD VSS VSS gf180mcu_fd_sc_mcu7t5v0__fill_1
XFILLER_30_404 VDD VDD VSS VSS gf180mcu_fd_sc_mcu7t5v0__fillcap_32
XFILLER_42_242 VDD VDD VSS VSS gf180mcu_fd_sc_mcu7t5v0__fill_2
XPHY_EDGE_ROW_69_Right_69 VDD VSS gf180mcu_fd_sc_mcu7t5v0__endcap
XFILLER_8_26 VDD VDD VSS VSS gf180mcu_fd_sc_mcu7t5v0__fill_2
XPHY_EDGE_ROW_78_Right_78 VDD VSS gf180mcu_fd_sc_mcu7t5v0__endcap
XTAP_TAPCELL_ROW_90_1339 VDD VSS gf180mcu_fd_sc_mcu7t5v0__filltie
X_2250_ _2542_/Q _2543_/Q _2251_/A4 VDD VDD VSS VSS gf180mcu_fd_sc_mcu7t5v0__nand2_1
X_1201_ _1077_/I _1201_/A2 _1201_/B _1203_/A3 VDD VDD VSS VSS gf180mcu_fd_sc_mcu7t5v0__aoi21_1
X_2181_ _2181_/A1 _2218_/A2 _2183_/A2 VDD VDD VSS VSS gf180mcu_fd_sc_mcu7t5v0__nand2_1
XPHY_EDGE_ROW_108_Left_227 VDD VSS gf180mcu_fd_sc_mcu7t5v0__endcap
XFILLER_93_632 VDD VDD VSS VSS gf180mcu_fd_sc_mcu7t5v0__fillcap_4
XFILLER_77_172 VDD VDD VSS VSS gf180mcu_fd_sc_mcu7t5v0__fillcap_8
XFILLER_65_345 VDD VDD VSS VSS gf180mcu_fd_sc_mcu7t5v0__fillcap_4
X_1132_ _1141_/A1 _1141_/A2 _1146_/C VDD VDD VSS VSS gf180mcu_fd_sc_mcu7t5v0__nand2_1
X_1063_ _1063_/I _1251_/A1 VDD VDD VSS VSS gf180mcu_fd_sc_mcu7t5v0__clkinv_1
XFILLER_46_592 VDD VDD VSS VSS gf180mcu_fd_sc_mcu7t5v0__fill_2
XPHY_EDGE_ROW_87_Right_87 VDD VSS gf180mcu_fd_sc_mcu7t5v0__endcap
XFILLER_61_562 VDD VDD VSS VSS gf180mcu_fd_sc_mcu7t5v0__fillcap_4
XTAP_TAPCELL_ROW_16_451 VDD VSS gf180mcu_fd_sc_mcu7t5v0__filltie
XFILLER_33_264 VDD VDD VSS VSS gf180mcu_fd_sc_mcu7t5v0__fill_2
XFILLER_33_275 VDD VDD VSS VSS gf180mcu_fd_sc_mcu7t5v0__fillcap_4
XFILLER_33_286 VDD VDD VSS VSS gf180mcu_fd_sc_mcu7t5v0__fill_1
XFILLER_33_297 VDD VDD VSS VSS gf180mcu_fd_sc_mcu7t5v0__fillcap_4
XTAP_TAPCELL_ROW_44_782 VDD VSS gf180mcu_fd_sc_mcu7t5v0__filltie
X_1965_ _1965_/I _1965_/ZN VDD VDD VSS VSS gf180mcu_fd_sc_mcu7t5v0__clkinv_1
XPHY_EDGE_ROW_117_Left_236 VDD VSS gf180mcu_fd_sc_mcu7t5v0__endcap
X_1896_ _1896_/A1 _1914_/A2 _1914_/B1 _2712_/I _1897_/I VDD VDD VSS VSS gf180mcu_fd_sc_mcu7t5v0__aoi22_1
XPHY_EDGE_ROW_96_Right_96 VDD VSS gf180mcu_fd_sc_mcu7t5v0__endcap
XFILLER_0_308 VDD VDD VSS VSS gf180mcu_fd_sc_mcu7t5v0__fillcap_16
X_2517_ _2594_/Q _2593_/Q _2517_/B _2519_/A2 VDD VDD VSS VSS gf180mcu_fd_sc_mcu7t5v0__oai21_1
Xclkbuf_3_4__f_clk_i clkbuf_0_clk_i/Z clkload4/I VDD VDD VSS VSS gf180mcu_fd_sc_mcu7t5v0__clkbuf_16
Xinput209 tl_d_uart_i[18] _1278_/A1 VDD VDD VSS VSS gf180mcu_fd_sc_mcu7t5v0__dlyd_1
X_2448_ _2451_/B _2446_/Z _2448_/B _2566_/D VDD VDD VSS VSS gf180mcu_fd_sc_mcu7t5v0__oai21_1
XTAP_TAPCELL_ROW_110_1575 VDD VSS gf180mcu_fd_sc_mcu7t5v0__filltie
XFILLER_68_172 VDD VDD VSS VSS gf180mcu_fd_sc_mcu7t5v0__fill_2
X_2379_ _2379_/A1 _2379_/A2 _2379_/A3 _2380_/A2 VDD VDD VSS VSS gf180mcu_fd_sc_mcu7t5v0__nand3_1
XFILLER_84_610 VDD VDD VSS VSS gf180mcu_fd_sc_mcu7t5v0__fillcap_16
XFILLER_69_673 VDD VDD VSS VSS gf180mcu_fd_sc_mcu7t5v0__fillcap_8
XFILLER_44_507 VDD VDD VSS VSS gf180mcu_fd_sc_mcu7t5v0__fill_1
XFILLER_71_348 VDD VDD VSS VSS gf180mcu_fd_sc_mcu7t5v0__fill_2
XTAP_TAPCELL_ROW_65_1032 VDD VSS gf180mcu_fd_sc_mcu7t5v0__filltie
XTAP_TAPCELL_ROW_76_1172 VDD VSS gf180mcu_fd_sc_mcu7t5v0__filltie
XFILLER_0_864 VDD VDD VSS VSS gf180mcu_fd_sc_mcu7t5v0__fill_2
XFILLER_87_492 VDD VDD VSS VSS gf180mcu_fd_sc_mcu7t5v0__fill_2
XFILLER_75_698 VDD VDD VSS VSS gf180mcu_fd_sc_mcu7t5v0__fill_2
XFILLER_75_687 VDD VDD VSS VSS gf180mcu_fd_sc_mcu7t5v0__fill_2
XFILLER_28_592 VDD VDD VSS VSS gf180mcu_fd_sc_mcu7t5v0__fill_2
XFILLER_90_657 VDD VDD VSS VSS gf180mcu_fd_sc_mcu7t5v0__fill_2
XFILLER_31_702 VDD VDD VSS VSS gf180mcu_fd_sc_mcu7t5v0__fillcap_64
XFILLER_43_562 VDD VDD VSS VSS gf180mcu_fd_sc_mcu7t5v0__fillcap_8
XFILLER_30_234 VDD VDD VSS VSS gf180mcu_fd_sc_mcu7t5v0__fillcap_8
XTAP_TAPCELL_ROW_13_410 VDD VSS gf180mcu_fd_sc_mcu7t5v0__filltie
XFILLER_30_267 VDD VDD VSS VSS gf180mcu_fd_sc_mcu7t5v0__fill_1
X_1750_ _1940_/A1 _1768_/A2 _1762_/B1 _1940_/B2 _1751_/I VDD VDD VSS VSS gf180mcu_fd_sc_mcu7t5v0__aoi22_1
XTAP_TAPCELL_ROW_41_752 VDD VSS gf180mcu_fd_sc_mcu7t5v0__filltie
XFILLER_11_492 VDD VDD VSS VSS gf180mcu_fd_sc_mcu7t5v0__fillcap_64
XFILLER_116_317 VDD VDD VSS VSS gf180mcu_fd_sc_mcu7t5v0__fillcap_32
X_1681_ _1681_/I _1681_/ZN VDD VDD VSS VSS gf180mcu_fd_sc_mcu7t5v0__clkinv_1
X_2302_ _2302_/A1 _2302_/A2 _2304_/A1 VDD VDD VSS VSS gf180mcu_fd_sc_mcu7t5v0__nand2_1
XFILLER_24_2 VDD VDD VSS VSS gf180mcu_fd_sc_mcu7t5v0__fillcap_8
X_2233_ _2233_/A1 _2233_/A2 _2234_/A3 VDD VDD VSS VSS gf180mcu_fd_sc_mcu7t5v0__nand2_1
X_2164_ _2580_/Q _2140_/B _2234_/A2 VDD VDD VSS VSS gf180mcu_fd_sc_mcu7t5v0__nand2_1
XTAP_TAPCELL_ROW_49_841 VDD VSS gf180mcu_fd_sc_mcu7t5v0__filltie
XFILLER_26_518 VDD VDD VSS VSS gf180mcu_fd_sc_mcu7t5v0__fillcap_4
XFILLER_65_142 VDD VDD VSS VSS gf180mcu_fd_sc_mcu7t5v0__fillcap_32
X_1115_ _2576_/Q _2575_/Q _2466_/A1 _2141_/A1 VDD VDD VSS VSS gf180mcu_fd_sc_mcu7t5v0__nor3_1
XFILLER_0_60 VDD VDD VSS VSS gf180mcu_fd_sc_mcu7t5v0__fill_2
XFILLER_65_186 VDD VDD VSS VSS gf180mcu_fd_sc_mcu7t5v0__fill_2
XFILLER_65_197 VDD VDD VSS VSS gf180mcu_fd_sc_mcu7t5v0__fill_1
X_2095_ _2095_/A1 _2095_/A2 _2095_/ZN VDD VDD VSS VSS gf180mcu_fd_sc_mcu7t5v0__nand2_1
XFILLER_21_278 VDD VDD VSS VSS gf180mcu_fd_sc_mcu7t5v0__fill_2
X_1948_ _1948_/A1 _1976_/A2 _1952_/B1 _1948_/B2 _1949_/I VDD VDD VSS VSS gf180mcu_fd_sc_mcu7t5v0__aoi22_1
XFILLER_108_829 VDD VDD VSS VSS gf180mcu_fd_sc_mcu7t5v0__fill_2
X_1879_ _1879_/I _1879_/ZN VDD VDD VSS VSS gf180mcu_fd_sc_mcu7t5v0__clkinv_1
XTAP_TAPCELL_ROW_112_1604 VDD VSS gf180mcu_fd_sc_mcu7t5v0__filltie
XFILLER_89_724 VDD VDD VSS VSS gf180mcu_fd_sc_mcu7t5v0__fillcap_8
XFILLER_103_512 VDD VDD VSS VSS gf180mcu_fd_sc_mcu7t5v0__fill_2
XFILLER_0_138 VDD VDD VSS VSS gf180mcu_fd_sc_mcu7t5v0__fill_2
XFILLER_76_407 VDD VDD VSS VSS gf180mcu_fd_sc_mcu7t5v0__fill_2
XFILLER_57_632 VDD VDD VSS VSS gf180mcu_fd_sc_mcu7t5v0__fill_1
Xload_slew1116 _1507_/A1 _1467_/A1 VDD VDD VSS VSS gf180mcu_fd_sc_mcu7t5v0__buf_3
XFILLER_69_492 VDD VDD VSS VSS gf180mcu_fd_sc_mcu7t5v0__fillcap_4
Xload_slew1127 _1772_/B1 _1762_/B1 VDD VDD VSS VSS gf180mcu_fd_sc_mcu7t5v0__buf_2
XFILLER_72_635 VDD VDD VSS VSS gf180mcu_fd_sc_mcu7t5v0__fillcap_16
XFILLER_13_702 VDD VDD VSS VSS gf180mcu_fd_sc_mcu7t5v0__fillcap_64
XFILLER_72_679 VDD VDD VSS VSS gf180mcu_fd_sc_mcu7t5v0__fill_1
XFILLER_71_134 VDD VDD VSS VSS gf180mcu_fd_sc_mcu7t5v0__fillcap_4
XFILLER_25_562 VDD VDD VSS VSS gf180mcu_fd_sc_mcu7t5v0__fillcap_64
XTAP_TAPCELL_ROW_27_579 VDD VSS gf180mcu_fd_sc_mcu7t5v0__filltie
XFILLER_60_10 VDD VDD VSS VSS gf180mcu_fd_sc_mcu7t5v0__fill_2
XFILLER_60_32 VDD VDD VSS VSS gf180mcu_fd_sc_mcu7t5v0__fill_1
XFILLER_106_372 VDD VDD VSS VSS gf180mcu_fd_sc_mcu7t5v0__fill_2
XFILLER_106_383 VDD VDD VSS VSS gf180mcu_fd_sc_mcu7t5v0__fill_2
XFILLER_79_212 VDD VDD VSS VSS gf180mcu_fd_sc_mcu7t5v0__fillcap_32
XFILLER_67_418 VDD VDD VSS VSS gf180mcu_fd_sc_mcu7t5v0__fill_2
XFILLER_79_278 VDD VDD VSS VSS gf180mcu_fd_sc_mcu7t5v0__fill_2
XFILLER_48_632 VDD VDD VSS VSS gf180mcu_fd_sc_mcu7t5v0__fill_1
XTAP_TAPCELL_ROW_89_1330 VDD VSS gf180mcu_fd_sc_mcu7t5v0__filltie
XFILLER_47_142 VDD VDD VSS VSS gf180mcu_fd_sc_mcu7t5v0__fillcap_4
XFILLER_62_123 VDD VDD VSS VSS gf180mcu_fd_sc_mcu7t5v0__fillcap_8
XTAP_TAPCELL_ROW_46_811 VDD VSS gf180mcu_fd_sc_mcu7t5v0__filltie
X_1802_ _1992_/A1 _1818_/A2 _1838_/B1 _2728_/I _1803_/I VDD VDD VSS VSS gf180mcu_fd_sc_mcu7t5v0__aoi22_1
X_1733_ _1733_/I _1733_/ZN VDD VDD VSS VSS gf180mcu_fd_sc_mcu7t5v0__clkinv_1
X_1664_ _1880_/B2 _1609_/Z _1664_/S _1664_/Z VDD VDD VSS VSS gf180mcu_fd_sc_mcu7t5v0__mux2_2
X_1595_ _2752_/I _2722_/I _1594_/Z _1595_/Z VDD VDD VSS VSS gf180mcu_fd_sc_mcu7t5v0__xor3_1
XFILLER_98_543 VDD VDD VSS VSS gf180mcu_fd_sc_mcu7t5v0__fillcap_32
XFILLER_39_632 VDD VDD VSS VSS gf180mcu_fd_sc_mcu7t5v0__fillcap_16
X_2216_ input51/Z _2230_/B _2236_/B _2217_/B2 VDD VDD VSS VSS gf180mcu_fd_sc_mcu7t5v0__aoi21_1
XFILLER_66_473 VDD VDD VSS VSS gf180mcu_fd_sc_mcu7t5v0__fillcap_8
X_2147_ _2147_/A1 _2147_/A2 _2147_/ZN VDD VDD VSS VSS gf180mcu_fd_sc_mcu7t5v0__nand2_1
XFILLER_93_270 VDD VDD VSS VSS gf180mcu_fd_sc_mcu7t5v0__fill_1
X_2078_ input74/Z _2315_/A2 _2277_/A1 _2174_/A1 _2079_/I VDD VDD VSS VSS gf180mcu_fd_sc_mcu7t5v0__aoi22_1
XFILLER_53_178 VDD VDD VSS VSS gf180mcu_fd_sc_mcu7t5v0__fill_1
XTAP_TAPCELL_ROW_62_1002 VDD VSS gf180mcu_fd_sc_mcu7t5v0__filltie
XFILLER_34_381 VDD VDD VSS VSS gf180mcu_fd_sc_mcu7t5v0__fillcap_4
XTAP_TAPCELL_ROW_24_549 VDD VSS gf180mcu_fd_sc_mcu7t5v0__filltie
XTAP_TAPCELL_ROW_73_1131 VDD VSS gf180mcu_fd_sc_mcu7t5v0__filltie
XFILLER_89_510 VDD VDD VSS VSS gf180mcu_fd_sc_mcu7t5v0__fillcap_32
XFILLER_103_386 VDD VDD VSS VSS gf180mcu_fd_sc_mcu7t5v0__fillcap_16
XFILLER_39_55 VDD VDD VSS VSS gf180mcu_fd_sc_mcu7t5v0__fillcap_8
XFILLER_57_484 VDD VDD VSS VSS gf180mcu_fd_sc_mcu7t5v0__fillcap_4
XTAP_TAPCELL_ROW_84_1260 VDD VSS gf180mcu_fd_sc_mcu7t5v0__filltie
XPHY_EDGE_ROW_105_Right_105 VDD VSS gf180mcu_fd_sc_mcu7t5v0__endcap
XFILLER_40_362 VDD VDD VSS VSS gf180mcu_fd_sc_mcu7t5v0__fillcap_8
XFILLER_41_863 VDD VDD VSS VSS gf180mcu_fd_sc_mcu7t5v0__fill_2
XFILLER_99_318 VDD VDD VSS VSS gf180mcu_fd_sc_mcu7t5v0__fillcap_16
X_1380_ input26/Z _1468_/A2 _1380_/B1 _2160_/A2 _1381_/I VDD VDD VSS VSS gf180mcu_fd_sc_mcu7t5v0__aoi22_1
XFILLER_95_524 VDD VDD VSS VSS gf180mcu_fd_sc_mcu7t5v0__fillcap_4
Xinput370 tl_h_d_i[91] _2750_/I VDD VDD VSS VSS gf180mcu_fd_sc_mcu7t5v0__clkbuf_2
Xinput381 tl_h_i_i[100] _2398_/I0 VDD VDD VSS VSS gf180mcu_fd_sc_mcu7t5v0__dlyd_1
X_2001_ _2001_/I _2001_/ZN VDD VDD VSS VSS gf180mcu_fd_sc_mcu7t5v0__clkinv_1
XFILLER_36_624 VDD VDD VSS VSS gf180mcu_fd_sc_mcu7t5v0__fillcap_32
Xinput392 tl_h_i_i[110] _2389_/I0 VDD VDD VSS VSS gf180mcu_fd_sc_mcu7t5v0__dlyd_1
XFILLER_63_454 VDD VDD VSS VSS gf180mcu_fd_sc_mcu7t5v0__fill_2
XFILLER_23_329 VDD VDD VSS VSS gf180mcu_fd_sc_mcu7t5v0__fillcap_4
XFILLER_35_167 VDD VDD VSS VSS gf180mcu_fd_sc_mcu7t5v0__fillcap_4
XFILLER_51_627 VDD VDD VSS VSS gf180mcu_fd_sc_mcu7t5v0__fill_2
XFILLER_16_381 VDD VDD VSS VSS gf180mcu_fd_sc_mcu7t5v0__fillcap_4
XTAP_TAPCELL_ROW_21_508 VDD VSS gf180mcu_fd_sc_mcu7t5v0__filltie
XTAP_TAPCELL_ROW_98_1429 VDD VSS gf180mcu_fd_sc_mcu7t5v0__filltie
XFILLER_117_445 VDD VDD VSS VSS gf180mcu_fd_sc_mcu7t5v0__fill_2
X_2765_ _2765_/I _2765_/Z VDD VDD VSS VSS gf180mcu_fd_sc_mcu7t5v0__buf_1
X_2696_ _2768_/I _2696_/Z VDD VDD VSS VSS gf180mcu_fd_sc_mcu7t5v0__buf_1
Xoutput811 _2764_/Z tl_d_uart_o[105] VDD VDD VSS VSS gf180mcu_fd_sc_mcu7t5v0__dlyd_1
Xoutput800 _1681_/ZN tl_d_rom_o[8] VDD VDD VSS VSS gf180mcu_fd_sc_mcu7t5v0__dlyd_1
X_1716_ _1906_/A1 _1728_/A2 _1722_/B1 _2717_/I _1717_/I VDD VDD VSS VSS gf180mcu_fd_sc_mcu7t5v0__aoi22_1
XFILLER_117_489 VDD VDD VSS VSS gf180mcu_fd_sc_mcu7t5v0__fill_1
Xoutput855 _1633_/Z tl_d_uart_o[42] VDD VDD VSS VSS gf180mcu_fd_sc_mcu7t5v0__dlyd_1
Xoutput844 _1623_/Z tl_d_uart_o[32] VDD VDD VSS VSS gf180mcu_fd_sc_mcu7t5v0__dlyd_1
Xoutput833 _2713_/Z tl_d_uart_o[22] VDD VDD VSS VSS gf180mcu_fd_sc_mcu7t5v0__dlyd_1
Xoutput822 _1663_/Z tl_d_uart_o[12] VDD VDD VSS VSS gf180mcu_fd_sc_mcu7t5v0__dlyd_1
X_1647_ _1966_/B2 _1651_/A2 _1647_/Z VDD VDD VSS VSS gf180mcu_fd_sc_mcu7t5v0__or2_1
Xoutput888 _2731_/Z tl_d_uart_o[72] VDD VDD VSS VSS gf180mcu_fd_sc_mcu7t5v0__dlyd_1
Xoutput877 _2721_/Z tl_d_uart_o[62] VDD VDD VSS VSS gf180mcu_fd_sc_mcu7t5v0__dlyd_1
Xoutput866 _1643_/Z tl_d_uart_o[52] VDD VDD VSS VSS gf180mcu_fd_sc_mcu7t5v0__dlyd_1
Xoutput899 _2741_/Z tl_d_uart_o[82] VDD VDD VSS VSS gf180mcu_fd_sc_mcu7t5v0__dlyd_1
X_1578_ _1553_/Z _1575_/Z _1577_/Z _1578_/Z VDD VDD VSS VSS gf180mcu_fd_sc_mcu7t5v0__xor3_1
XFILLER_100_345 VDD VDD VSS VSS gf180mcu_fd_sc_mcu7t5v0__fill_2
XFILLER_100_378 VDD VDD VSS VSS gf180mcu_fd_sc_mcu7t5v0__fillcap_4
XTAP_TAPCELL_ROW_29_608 VDD VSS gf180mcu_fd_sc_mcu7t5v0__filltie
XTAP_TAPCELL_ROW_57_939 VDD VSS gf180mcu_fd_sc_mcu7t5v0__filltie
XFILLER_73_218 VDD VDD VSS VSS gf180mcu_fd_sc_mcu7t5v0__fill_1
XTAP_TAPCELL_ROW_1_266 VDD VSS gf180mcu_fd_sc_mcu7t5v0__filltie
XTAP_TAPCELL_ROW_107_1536 VDD VSS gf180mcu_fd_sc_mcu7t5v0__filltie
XFILLER_41_126 VDD VDD VSS VSS gf180mcu_fd_sc_mcu7t5v0__fillcap_8
XTAP_TAPCELL_ROW_37_696 VDD VSS gf180mcu_fd_sc_mcu7t5v0__filltie
XTAP_TAPCELL_ROW_118_1687 VDD VSS gf180mcu_fd_sc_mcu7t5v0__filltie
XTAP_TAPCELL_ROW_118_1676 VDD VSS gf180mcu_fd_sc_mcu7t5v0__filltie
XFILLER_108_489 VDD VDD VSS VSS gf180mcu_fd_sc_mcu7t5v0__fill_2
XTAP_TAPCELL_ROW_9_366 VDD VSS gf180mcu_fd_sc_mcu7t5v0__filltie
XFILLER_106_71 VDD VDD VSS VSS gf180mcu_fd_sc_mcu7t5v0__fill_1
XFILLER_92_527 VDD VDD VSS VSS gf180mcu_fd_sc_mcu7t5v0__fillcap_32
XFILLER_45_487 VDD VDD VSS VSS gf180mcu_fd_sc_mcu7t5v0__fill_2
XFILLER_60_457 VDD VDD VSS VSS gf180mcu_fd_sc_mcu7t5v0__fillcap_32
X_2550_ _2550_/D _2550_/RN clkload0/I _2550_/Q VDD VDD VSS VSS gf180mcu_fd_sc_mcu7t5v0__dffrnq_1
X_2481_ _2493_/A1 _2507_/B _2589_/D VDD VDD VSS VSS gf180mcu_fd_sc_mcu7t5v0__xor2_1
X_1501_ _1501_/I _1502_/B1 VDD VDD VSS VSS gf180mcu_fd_sc_mcu7t5v0__clkinv_1
X_1432_ _1432_/A1 _1432_/A2 _2341_/A2 VDD VDD VSS VSS gf180mcu_fd_sc_mcu7t5v0__nand2_1
X_1363_ _1467_/A1 _1361_/Z _1363_/B _1364_/B1 VDD VDD VSS VSS gf180mcu_fd_sc_mcu7t5v0__oai21_1
X_1294_ _1294_/A1 _1398_/A2 _1294_/B1 _1390_/B2 _1295_/A2 VDD VDD VSS VSS gf180mcu_fd_sc_mcu7t5v0__aoi22_1
XFILLER_95_376 VDD VDD VSS VSS gf180mcu_fd_sc_mcu7t5v0__fill_1
XTAP_TAPCELL_ROW_54_909 VDD VSS gf180mcu_fd_sc_mcu7t5v0__filltie
XFILLER_63_273 VDD VDD VSS VSS gf180mcu_fd_sc_mcu7t5v0__fillcap_4
XTAP_TAPCELL_ROW_34_666 VDD VSS gf180mcu_fd_sc_mcu7t5v0__filltie
XTAP_TAPCELL_ROW_62_997 VDD VSS gf180mcu_fd_sc_mcu7t5v0__filltie
XTAP_TAPCELL_ROW_102_1477 VDD VSS gf180mcu_fd_sc_mcu7t5v0__filltie
X_2748_ _2748_/I _2748_/Z VDD VDD VSS VSS gf180mcu_fd_sc_mcu7t5v0__buf_1
X_2679_ _2751_/I _2679_/Z VDD VDD VSS VSS gf180mcu_fd_sc_mcu7t5v0__buf_1
Xoutput630 _1889_/ZN tl_d_esram_o[17] VDD VDD VSS VSS gf180mcu_fd_sc_mcu7t5v0__dlyd_1
Xoutput641 _1909_/ZN tl_d_esram_o[27] VDD VDD VSS VSS gf180mcu_fd_sc_mcu7t5v0__dlyd_1
Xoutput652 _1929_/ZN tl_d_esram_o[37] VDD VDD VSS VSS gf180mcu_fd_sc_mcu7t5v0__dlyd_1
Xoutput663 _1949_/ZN tl_d_esram_o[47] VDD VDD VSS VSS gf180mcu_fd_sc_mcu7t5v0__dlyd_1
Xoutput696 _2009_/ZN tl_d_esram_o[77] VDD VDD VSS VSS gf180mcu_fd_sc_mcu7t5v0__dlyd_1
Xoutput685 _1989_/ZN tl_d_esram_o[67] VDD VDD VSS VSS gf180mcu_fd_sc_mcu7t5v0__dlyd_1
Xoutput674 _1969_/ZN tl_d_esram_o[57] VDD VDD VSS VSS gf180mcu_fd_sc_mcu7t5v0__dlyd_1
XTAP_TAPCELL_ROW_70_1101 VDD VSS gf180mcu_fd_sc_mcu7t5v0__filltie
XTAP_TAPCELL_ROW_6_325 VDD VSS gf180mcu_fd_sc_mcu7t5v0__filltie
XFILLER_39_270 VDD VDD VSS VSS gf180mcu_fd_sc_mcu7t5v0__fillcap_8
XFILLER_86_387 VDD VDD VSS VSS gf180mcu_fd_sc_mcu7t5v0__fillcap_64
XFILLER_74_527 VDD VDD VSS VSS gf180mcu_fd_sc_mcu7t5v0__fillcap_32
XTAP_TAPCELL_ROW_68_1074 VDD VSS gf180mcu_fd_sc_mcu7t5v0__filltie
XFILLER_82_593 VDD VDD VSS VSS gf180mcu_fd_sc_mcu7t5v0__fill_2
XFILLER_42_457 VDD VDD VSS VSS gf180mcu_fd_sc_mcu7t5v0__fillcap_16
XTAP_TAPCELL_ROW_81_1230 VDD VSS gf180mcu_fd_sc_mcu7t5v0__filltie
XFILLER_10_387 VDD VDD VSS VSS gf180mcu_fd_sc_mcu7t5v0__fillcap_32
XFILLER_96_107 VDD VDD VSS VSS gf180mcu_fd_sc_mcu7t5v0__fill_2
XFILLER_77_321 VDD VDD VSS VSS gf180mcu_fd_sc_mcu7t5v0__fillcap_16
XFILLER_77_310 VDD VDD VSS VSS gf180mcu_fd_sc_mcu7t5v0__fillcap_4
XFILLER_92_302 VDD VDD VSS VSS gf180mcu_fd_sc_mcu7t5v0__fillcap_4
XFILLER_46_730 VDD VDD VSS VSS gf180mcu_fd_sc_mcu7t5v0__fillcap_4
XFILLER_45_262 VDD VDD VSS VSS gf180mcu_fd_sc_mcu7t5v0__fill_2
XFILLER_61_766 VDD VDD VSS VSS gf180mcu_fd_sc_mcu7t5v0__fillcap_4
X_1981_ _1981_/I _1981_/ZN VDD VDD VSS VSS gf180mcu_fd_sc_mcu7t5v0__clkinv_1
XTAP_TAPCELL_ROW_31_625 VDD VSS gf180mcu_fd_sc_mcu7t5v0__filltie
XFILLER_54_2 VDD VDD VSS VSS gf180mcu_fd_sc_mcu7t5v0__fillcap_32
X_2533_ _1078_/I _2533_/A2 _2533_/B _2599_/D VDD VDD VSS VSS gf180mcu_fd_sc_mcu7t5v0__aoi21_1
XTAP_TAPCELL_ROW_11_393 VDD VSS gf180mcu_fd_sc_mcu7t5v0__filltie
X_2464_ _2698_/I _2576_/Q _2471_/S _2576_/D VDD VDD VSS VSS gf180mcu_fd_sc_mcu7t5v0__mux2_2
XFILLER_68_321 VDD VDD VSS VSS gf180mcu_fd_sc_mcu7t5v0__fill_2
X_2395_ _2395_/I0 _2551_/Q _2397_/S _2551_/D VDD VDD VSS VSS gf180mcu_fd_sc_mcu7t5v0__mux2_2
X_1415_ _1487_/A1 _1415_/A2 _1415_/ZN VDD VDD VSS VSS gf180mcu_fd_sc_mcu7t5v0__nor2_1
X_1346_ input87/Z _1490_/A2 _2363_/A3 _1347_/B VDD VDD VSS VSS gf180mcu_fd_sc_mcu7t5v0__nand3_1
XFILLER_56_527 VDD VDD VSS VSS gf180mcu_fd_sc_mcu7t5v0__fillcap_8
XFILLER_68_387 VDD VDD VSS VSS gf180mcu_fd_sc_mcu7t5v0__fillcap_16
XTAP_TAPCELL_ROW_39_725 VDD VSS gf180mcu_fd_sc_mcu7t5v0__filltie
XFILLER_83_324 VDD VDD VSS VSS gf180mcu_fd_sc_mcu7t5v0__fillcap_16
XFILLER_110_495 VDD VDD VSS VSS gf180mcu_fd_sc_mcu7t5v0__fill_2
XFILLER_56_549 VDD VDD VSS VSS gf180mcu_fd_sc_mcu7t5v0__fill_2
X_1277_ _1277_/I _1278_/B1 VDD VDD VSS VSS gf180mcu_fd_sc_mcu7t5v0__clkinv_1
XTAP_TAPCELL_ROW_104_1506 VDD VSS gf180mcu_fd_sc_mcu7t5v0__filltie
XFILLER_36_284 VDD VDD VSS VSS gf180mcu_fd_sc_mcu7t5v0__fillcap_4
XFILLER_51_221 VDD VDD VSS VSS gf180mcu_fd_sc_mcu7t5v0__fill_1
XFILLER_52_722 VDD VDD VSS VSS gf180mcu_fd_sc_mcu7t5v0__fillcap_8
XTAP_TAPCELL_ROW_19_482 VDD VSS gf180mcu_fd_sc_mcu7t5v0__filltie
XFILLER_24_457 VDD VDD VSS VSS gf180mcu_fd_sc_mcu7t5v0__fillcap_8
XFILLER_4_807 VDD VDD VSS VSS gf180mcu_fd_sc_mcu7t5v0__fillcap_16
XTAP_TAPCELL_ROW_115_1635 VDD VSS gf180mcu_fd_sc_mcu7t5v0__filltie
XFILLER_98_18 VDD VDD VSS VSS gf180mcu_fd_sc_mcu7t5v0__fill_1
Xfanout1107 _1550_/A2 fanout1107/Z VDD VDD VSS VSS gf180mcu_fd_sc_mcu7t5v0__dlyd_1
XFILLER_74_313 VDD VDD VSS VSS gf180mcu_fd_sc_mcu7t5v0__fill_2
XFILLER_47_549 VDD VDD VSS VSS gf180mcu_fd_sc_mcu7t5v0__fillcap_8
XFILLER_75_858 VDD VDD VSS VSS gf180mcu_fd_sc_mcu7t5v0__fillcap_8
XFILLER_74_357 VDD VDD VSS VSS gf180mcu_fd_sc_mcu7t5v0__fill_1
XFILLER_43_766 VDD VDD VSS VSS gf180mcu_fd_sc_mcu7t5v0__fillcap_4
X_2180_ _2180_/A1 _2180_/A2 _2180_/B _2180_/ZN VDD VDD VSS VSS gf180mcu_fd_sc_mcu7t5v0__oai21_1
X_1200_ _1200_/A1 _1200_/A2 _1200_/B _1200_/C _1201_/A2 VDD VDD VSS VSS gf180mcu_fd_sc_mcu7t5v0__aoi211_1
XFILLER_38_527 VDD VDD VSS VSS gf180mcu_fd_sc_mcu7t5v0__fillcap_8
XFILLER_65_302 VDD VDD VSS VSS gf180mcu_fd_sc_mcu7t5v0__fill_1
XFILLER_77_162 VDD VDD VSS VSS gf180mcu_fd_sc_mcu7t5v0__fill_2
X_1131_ _1141_/A1 _1141_/A2 _1145_/B VDD VDD VSS VSS gf180mcu_fd_sc_mcu7t5v0__and2_1
X_1062_ _1062_/I _1257_/A1 VDD VDD VSS VSS gf180mcu_fd_sc_mcu7t5v0__clkinv_1
XTAP_TAPCELL_ROW_44_783 VDD VSS gf180mcu_fd_sc_mcu7t5v0__filltie
XTAP_TAPCELL_ROW_16_452 VDD VSS gf180mcu_fd_sc_mcu7t5v0__filltie
XFILLER_21_438 VDD VDD VSS VSS gf180mcu_fd_sc_mcu7t5v0__fillcap_8
X_1964_ _1964_/A1 _1964_/A2 _2014_/B1 _1964_/B2 _1965_/I VDD VDD VSS VSS gf180mcu_fd_sc_mcu7t5v0__aoi22_1
X_1895_ _1895_/I _1895_/ZN VDD VDD VSS VSS gf180mcu_fd_sc_mcu7t5v0__clkinv_1
X_2516_ _2516_/A1 _2512_/Z _2526_/C VDD VDD VSS VSS gf180mcu_fd_sc_mcu7t5v0__or2_1
X_2447_ _2566_/Q _2451_/B _2448_/B VDD VDD VSS VSS gf180mcu_fd_sc_mcu7t5v0__nand2_1
XFILLER_69_641 VDD VDD VSS VSS gf180mcu_fd_sc_mcu7t5v0__fillcap_32
X_2378_ _2378_/A1 _2378_/A2 _2380_/A1 VDD VDD VSS VSS gf180mcu_fd_sc_mcu7t5v0__nand2_1
XTAP_TAPCELL_ROW_110_1576 VDD VSS gf180mcu_fd_sc_mcu7t5v0__filltie
XFILLER_69_685 VDD VDD VSS VSS gf180mcu_fd_sc_mcu7t5v0__fill_1
X_1329_ _1441_/A1 _2289_/A2 _1329_/Z VDD VDD VSS VSS gf180mcu_fd_sc_mcu7t5v0__and2_1
XFILLER_56_379 VDD VDD VSS VSS gf180mcu_fd_sc_mcu7t5v0__fillcap_4
XFILLER_25_766 VDD VDD VSS VSS gf180mcu_fd_sc_mcu7t5v0__fillcap_4
XTAP_TAPCELL_ROW_65_1033 VDD VSS gf180mcu_fd_sc_mcu7t5v0__filltie
XFILLER_40_714 VDD VDD VSS VSS gf180mcu_fd_sc_mcu7t5v0__fillcap_16
XFILLER_40_769 VDD VDD VSS VSS gf180mcu_fd_sc_mcu7t5v0__fill_2
XFILLER_116_4 VDD VDD VSS VSS gf180mcu_fd_sc_mcu7t5v0__fill_2
XTAP_TAPCELL_ROW_76_1173 VDD VSS gf180mcu_fd_sc_mcu7t5v0__filltie
XFILLER_15_298 VDD VDD VSS VSS gf180mcu_fd_sc_mcu7t5v0__fillcap_4
XFILLER_30_224 VDD VDD VSS VSS gf180mcu_fd_sc_mcu7t5v0__fillcap_4
XTAP_TAPCELL_ROW_13_411 VDD VSS gf180mcu_fd_sc_mcu7t5v0__filltie
XFILLER_70_382 VDD VDD VSS VSS gf180mcu_fd_sc_mcu7t5v0__fill_2
XTAP_TAPCELL_ROW_41_753 VDD VSS gf180mcu_fd_sc_mcu7t5v0__filltie
X_1680_ _1870_/A1 _1720_/A2 _1720_/B1 _1870_/B2 _1681_/I VDD VDD VSS VSS gf180mcu_fd_sc_mcu7t5v0__aoi22_1
X_2301_ _2333_/A1 _2301_/A2 _2302_/A2 VDD VDD VSS VSS gf180mcu_fd_sc_mcu7t5v0__nand2_1
XFILLER_38_313 VDD VDD VSS VSS gf180mcu_fd_sc_mcu7t5v0__fill_2
X_2232_ _2232_/A1 _2232_/A2 _2232_/ZN VDD VDD VSS VSS gf180mcu_fd_sc_mcu7t5v0__nor2_1
XFILLER_97_279 VDD VDD VSS VSS gf180mcu_fd_sc_mcu7t5v0__fill_1
XFILLER_66_633 VDD VDD VSS VSS gf180mcu_fd_sc_mcu7t5v0__fillcap_32
X_2163_ _2163_/A1 _2233_/A2 _2165_/A2 VDD VDD VSS VSS gf180mcu_fd_sc_mcu7t5v0__nand2_1
XTAP_TAPCELL_ROW_49_842 VDD VSS gf180mcu_fd_sc_mcu7t5v0__filltie
X_1114_ _2569_/Q _1114_/A2 _1114_/Z VDD VDD VSS VSS gf180mcu_fd_sc_mcu7t5v0__or2_1
XFILLER_81_614 VDD VDD VSS VSS gf180mcu_fd_sc_mcu7t5v0__fillcap_4
XFILLER_53_316 VDD VDD VSS VSS gf180mcu_fd_sc_mcu7t5v0__fillcap_8
X_2094_ _1066_/I _2555_/Q _2209_/A1 _2375_/A2 _2095_/A2 VDD VDD VSS VSS gf180mcu_fd_sc_mcu7t5v0__aoi22_1
XFILLER_93_496 VDD VDD VSS VSS gf180mcu_fd_sc_mcu7t5v0__fill_1
XFILLER_0_72 VDD VDD VSS VSS gf180mcu_fd_sc_mcu7t5v0__fill_1
XFILLER_34_574 VDD VDD VSS VSS gf180mcu_fd_sc_mcu7t5v0__fill_2
X_1947_ _1947_/I _1947_/ZN VDD VDD VSS VSS gf180mcu_fd_sc_mcu7t5v0__clkinv_1
X_1878_ _1878_/A1 _1912_/A2 _1914_/B1 _1878_/B2 _1879_/I VDD VDD VSS VSS gf180mcu_fd_sc_mcu7t5v0__aoi22_1
XTAP_TAPCELL_ROW_112_1605 VDD VSS gf180mcu_fd_sc_mcu7t5v0__filltie
XFILLER_103_557 VDD VDD VSS VSS gf180mcu_fd_sc_mcu7t5v0__fill_2
XFILLER_88_279 VDD VDD VSS VSS gf180mcu_fd_sc_mcu7t5v0__fillcap_16
XFILLER_57_677 VDD VDD VSS VSS gf180mcu_fd_sc_mcu7t5v0__fillcap_16
Xload_slew1139 _1854_/B1 _1768_/B1 VDD VDD VSS VSS gf180mcu_fd_sc_mcu7t5v0__buf_4
XFILLER_84_452 VDD VDD VSS VSS gf180mcu_fd_sc_mcu7t5v0__fill_2
XFILLER_72_603 VDD VDD VSS VSS gf180mcu_fd_sc_mcu7t5v0__fillcap_32
XFILLER_57_699 VDD VDD VSS VSS gf180mcu_fd_sc_mcu7t5v0__fill_1
XFILLER_84_496 VDD VDD VSS VSS gf180mcu_fd_sc_mcu7t5v0__fillcap_16
XFILLER_44_12 VDD VDD VSS VSS gf180mcu_fd_sc_mcu7t5v0__fill_1
XFILLER_106_362 VDD VDD VSS VSS gf180mcu_fd_sc_mcu7t5v0__fill_1
XFILLER_106_395 VDD VDD VSS VSS gf180mcu_fd_sc_mcu7t5v0__fillcap_4
XFILLER_67_408 VDD VDD VSS VSS gf180mcu_fd_sc_mcu7t5v0__fill_1
XTAP_TAPCELL_ROW_89_1320 VDD VSS gf180mcu_fd_sc_mcu7t5v0__filltie
XFILLER_87_290 VDD VDD VSS VSS gf180mcu_fd_sc_mcu7t5v0__fill_1
XFILLER_35_338 VDD VDD VSS VSS gf180mcu_fd_sc_mcu7t5v0__fillcap_4
XFILLER_48_699 VDD VDD VSS VSS gf180mcu_fd_sc_mcu7t5v0__fillcap_16
XFILLER_63_625 VDD VDD VSS VSS gf180mcu_fd_sc_mcu7t5v0__fillcap_4
XTAP_TAPCELL_ROW_46_812 VDD VSS gf180mcu_fd_sc_mcu7t5v0__filltie
XFILLER_75_474 VDD VDD VSS VSS gf180mcu_fd_sc_mcu7t5v0__fillcap_16
XFILLER_90_477 VDD VDD VSS VSS gf180mcu_fd_sc_mcu7t5v0__fillcap_16
X_1801_ _1801_/I _1801_/ZN VDD VDD VSS VSS gf180mcu_fd_sc_mcu7t5v0__clkinv_1
X_1732_ _1922_/A1 _1732_/A2 _1772_/B1 _1922_/B2 _1733_/I VDD VDD VSS VSS gf180mcu_fd_sc_mcu7t5v0__aoi22_1
X_1663_ _1878_/B2 _1599_/Z _1664_/S _1663_/Z VDD VDD VSS VSS gf180mcu_fd_sc_mcu7t5v0__mux2_2
X_1594_ _2726_/I _2730_/I _1594_/Z VDD VDD VSS VSS gf180mcu_fd_sc_mcu7t5v0__xor2_1
XFILLER_98_522 VDD VDD VSS VSS gf180mcu_fd_sc_mcu7t5v0__fill_2
XFILLER_98_511 VDD VDD VSS VSS gf180mcu_fd_sc_mcu7t5v0__fill_1
XFILLER_100_527 VDD VDD VSS VSS gf180mcu_fd_sc_mcu7t5v0__fillcap_4
XFILLER_58_419 VDD VDD VSS VSS gf180mcu_fd_sc_mcu7t5v0__fillcap_8
XPHY_EDGE_ROW_7_Right_7 VDD VSS gf180mcu_fd_sc_mcu7t5v0__endcap
XFILLER_85_205 VDD VDD VSS VSS gf180mcu_fd_sc_mcu7t5v0__fillcap_4
X_2215_ _2215_/A1 _1116_/B _2215_/B _2215_/C _2217_/B1 VDD VDD VSS VSS gf180mcu_fd_sc_mcu7t5v0__oai211_1
XFILLER_39_699 VDD VDD VSS VSS gf180mcu_fd_sc_mcu7t5v0__fill_1
X_2146_ input67/Z _2160_/A2 _2146_/B _2146_/C _2147_/A2 VDD VDD VSS VSS gf180mcu_fd_sc_mcu7t5v0__oai211_1
XFILLER_26_349 VDD VDD VSS VSS gf180mcu_fd_sc_mcu7t5v0__fill_2
X_2077_ _2077_/I _2077_/ZN VDD VDD VSS VSS gf180mcu_fd_sc_mcu7t5v0__clkinv_1
XTAP_TAPCELL_ROW_62_1003 VDD VSS gf180mcu_fd_sc_mcu7t5v0__filltie
XFILLER_50_831 VDD VDD VSS VSS gf180mcu_fd_sc_mcu7t5v0__fill_1
XFILLER_62_691 VDD VDD VSS VSS gf180mcu_fd_sc_mcu7t5v0__fillcap_4
XTAP_TAPCELL_ROW_24_539 VDD VSS gf180mcu_fd_sc_mcu7t5v0__filltie
XFILLER_1_404 VDD VDD VSS VSS gf180mcu_fd_sc_mcu7t5v0__fillcap_16
XTAP_TAPCELL_ROW_73_1132 VDD VSS gf180mcu_fd_sc_mcu7t5v0__filltie
XFILLER_89_500 VDD VDD VSS VSS gf180mcu_fd_sc_mcu7t5v0__fillcap_4
XFILLER_103_321 VDD VDD VSS VSS gf180mcu_fd_sc_mcu7t5v0__fill_2
XFILLER_49_419 VDD VDD VSS VSS gf180mcu_fd_sc_mcu7t5v0__fill_1
XFILLER_39_67 VDD VDD VSS VSS gf180mcu_fd_sc_mcu7t5v0__fill_2
XFILLER_39_78 VDD VDD VSS VSS gf180mcu_fd_sc_mcu7t5v0__fill_1
XFILLER_57_452 VDD VDD VSS VSS gf180mcu_fd_sc_mcu7t5v0__fillcap_32
XFILLER_29_187 VDD VDD VSS VSS gf180mcu_fd_sc_mcu7t5v0__fillcap_16
XFILLER_25_360 VDD VDD VSS VSS gf180mcu_fd_sc_mcu7t5v0__fillcap_16
XTAP_TAPCELL_ROW_84_1261 VDD VSS gf180mcu_fd_sc_mcu7t5v0__filltie
XFILLER_72_477 VDD VDD VSS VSS gf180mcu_fd_sc_mcu7t5v0__fill_2
XFILLER_41_842 VDD VDD VSS VSS gf180mcu_fd_sc_mcu7t5v0__fillcap_4
XTAP_TAPCELL_ROW_51_870 VDD VSS gf180mcu_fd_sc_mcu7t5v0__filltie
XFILLER_95_536 VDD VDD VSS VSS gf180mcu_fd_sc_mcu7t5v0__fillcap_8
Xinput360 tl_h_d_i[82] _2741_/I VDD VDD VSS VSS gf180mcu_fd_sc_mcu7t5v0__clkbuf_2
Xinput371 tl_h_d_i[92] _2751_/I VDD VDD VSS VSS gf180mcu_fd_sc_mcu7t5v0__clkbuf_2
X_2000_ _2000_/A1 _2030_/A2 _2030_/B1 _2732_/I _2001_/I VDD VDD VSS VSS gf180mcu_fd_sc_mcu7t5v0__aoi22_1
XFILLER_48_474 VDD VDD VSS VSS gf180mcu_fd_sc_mcu7t5v0__fill_2
XFILLER_63_422 VDD VDD VSS VSS gf180mcu_fd_sc_mcu7t5v0__fillcap_32
Xinput382 tl_h_i_i[101] _2399_/I0 VDD VDD VSS VSS gf180mcu_fd_sc_mcu7t5v0__dlyd_1
Xinput393 tl_h_i_i[111] _2390_/I0 VDD VDD VSS VSS gf180mcu_fd_sc_mcu7t5v0__dlyd_1
XTAP_TAPCELL_ROW_59_970 VDD VSS gf180mcu_fd_sc_mcu7t5v0__filltie
XFILLER_75_282 VDD VDD VSS VSS gf180mcu_fd_sc_mcu7t5v0__fillcap_64
XPHY_EDGE_ROW_11_Left_130 VDD VSS gf180mcu_fd_sc_mcu7t5v0__endcap
XFILLER_63_488 VDD VDD VSS VSS gf180mcu_fd_sc_mcu7t5v0__fill_2
XFILLER_32_831 VDD VDD VSS VSS gf180mcu_fd_sc_mcu7t5v0__fill_1
XFILLER_90_296 VDD VDD VSS VSS gf180mcu_fd_sc_mcu7t5v0__fillcap_16
XTAP_TAPCELL_ROW_21_509 VDD VSS gf180mcu_fd_sc_mcu7t5v0__filltie
X_2764_ _2764_/I _2764_/Z VDD VDD VSS VSS gf180mcu_fd_sc_mcu7t5v0__buf_1
X_1715_ _1715_/I _1715_/ZN VDD VDD VSS VSS gf180mcu_fd_sc_mcu7t5v0__clkinv_1
X_2695_ _2767_/I _2695_/Z VDD VDD VSS VSS gf180mcu_fd_sc_mcu7t5v0__buf_1
Xoutput812 _2765_/Z tl_d_uart_o[106] VDD VDD VSS VSS gf180mcu_fd_sc_mcu7t5v0__dlyd_1
Xoutput801 _1854_/B1 tl_d_rom_o[97] VDD VDD VSS VSS gf180mcu_fd_sc_mcu7t5v0__dlyd_1
Xoutput845 _1624_/Z tl_d_uart_o[33] VDD VDD VSS VSS gf180mcu_fd_sc_mcu7t5v0__dlyd_1
Xoutput834 _2714_/Z tl_d_uart_o[23] VDD VDD VSS VSS gf180mcu_fd_sc_mcu7t5v0__dlyd_1
Xoutput823 _1664_/Z tl_d_uart_o[13] VDD VDD VSS VSS gf180mcu_fd_sc_mcu7t5v0__dlyd_1
X_1646_ _1964_/B2 _1651_/A2 _1646_/Z VDD VDD VSS VSS gf180mcu_fd_sc_mcu7t5v0__or2_1
Xoutput878 _2722_/Z tl_d_uart_o[63] VDD VDD VSS VSS gf180mcu_fd_sc_mcu7t5v0__dlyd_1
Xoutput867 _1644_/Z tl_d_uart_o[53] VDD VDD VSS VSS gf180mcu_fd_sc_mcu7t5v0__dlyd_1
Xoutput856 _1634_/Z tl_d_uart_o[43] VDD VDD VSS VSS gf180mcu_fd_sc_mcu7t5v0__dlyd_1
X_1577_ _2747_/I _2720_/I _1576_/Z _1577_/Z VDD VDD VSS VSS gf180mcu_fd_sc_mcu7t5v0__xor3_1
XFILLER_99_864 VDD VDD VSS VSS gf180mcu_fd_sc_mcu7t5v0__fill_2
XFILLER_99_842 VDD VDD VSS VSS gf180mcu_fd_sc_mcu7t5v0__fillcap_4
Xoutput889 _2732_/Z tl_d_uart_o[73] VDD VDD VSS VSS gf180mcu_fd_sc_mcu7t5v0__dlyd_1
XFILLER_98_363 VDD VDD VSS VSS gf180mcu_fd_sc_mcu7t5v0__fillcap_8
XFILLER_101_858 VDD VDD VSS VSS gf180mcu_fd_sc_mcu7t5v0__fillcap_8
XFILLER_58_216 VDD VDD VSS VSS gf180mcu_fd_sc_mcu7t5v0__fillcap_4
XTAP_TAPCELL_ROW_29_609 VDD VSS gf180mcu_fd_sc_mcu7t5v0__filltie
XFILLER_73_208 VDD VDD VSS VSS gf180mcu_fd_sc_mcu7t5v0__fill_2
XFILLER_67_772 VDD VDD VSS VSS gf180mcu_fd_sc_mcu7t5v0__fillcap_32
X_2129_ _2129_/A1 _2171_/B _2132_/B VDD VDD VSS VSS gf180mcu_fd_sc_mcu7t5v0__nand2_1
XTAP_TAPCELL_ROW_1_267 VDD VSS gf180mcu_fd_sc_mcu7t5v0__filltie
XTAP_TAPCELL_ROW_107_1537 VDD VSS gf180mcu_fd_sc_mcu7t5v0__filltie
XFILLER_23_842 VDD VDD VSS VSS gf180mcu_fd_sc_mcu7t5v0__fillcap_16
XFILLER_41_138 VDD VDD VSS VSS gf180mcu_fd_sc_mcu7t5v0__fill_2
XTAP_TAPCELL_ROW_37_697 VDD VSS gf180mcu_fd_sc_mcu7t5v0__filltie
XFILLER_81_296 VDD VDD VSS VSS gf180mcu_fd_sc_mcu7t5v0__fillcap_32
XFILLER_22_330 VDD VDD VSS VSS gf180mcu_fd_sc_mcu7t5v0__fillcap_16
XFILLER_108_457 VDD VDD VSS VSS gf180mcu_fd_sc_mcu7t5v0__fillcap_32
XTAP_TAPCELL_ROW_118_1688 VDD VSS gf180mcu_fd_sc_mcu7t5v0__filltie
XTAP_TAPCELL_ROW_118_1677 VDD VSS gf180mcu_fd_sc_mcu7t5v0__filltie
XTAP_TAPCELL_ROW_9_367 VDD VSS gf180mcu_fd_sc_mcu7t5v0__filltie
XFILLER_89_352 VDD VDD VSS VSS gf180mcu_fd_sc_mcu7t5v0__fillcap_64
XFILLER_49_238 VDD VDD VSS VSS gf180mcu_fd_sc_mcu7t5v0__fill_1
XFILLER_45_411 VDD VDD VSS VSS gf180mcu_fd_sc_mcu7t5v0__fillcap_8
XFILLER_45_422 VDD VDD VSS VSS gf180mcu_fd_sc_mcu7t5v0__fillcap_16
XFILLER_45_455 VDD VDD VSS VSS gf180mcu_fd_sc_mcu7t5v0__fillcap_32
XFILLER_57_282 VDD VDD VSS VSS gf180mcu_fd_sc_mcu7t5v0__fillcap_8
XFILLER_14_831 VDD VDD VSS VSS gf180mcu_fd_sc_mcu7t5v0__fill_1
XFILLER_13_352 VDD VDD VSS VSS gf180mcu_fd_sc_mcu7t5v0__fillcap_64
XFILLER_40_171 VDD VDD VSS VSS gf180mcu_fd_sc_mcu7t5v0__fillcap_4
XFILLER_41_694 VDD VDD VSS VSS gf180mcu_fd_sc_mcu7t5v0__fillcap_4
X_2480_ _2773_/I _2527_/A2 _2507_/B VDD VDD VSS VSS gf180mcu_fd_sc_mcu7t5v0__xor2_2
X_1500_ input42/Z _1500_/A2 _1500_/B1 _2247_/A2 _1501_/I VDD VDD VSS VSS gf180mcu_fd_sc_mcu7t5v0__aoi22_1
X_1431_ _1487_/A1 _1431_/A2 _1431_/ZN VDD VDD VSS VSS gf180mcu_fd_sc_mcu7t5v0__nor2_1
XFILLER_96_823 VDD VDD VSS VSS gf180mcu_fd_sc_mcu7t5v0__fillcap_8
X_1362_ input89/Z _1490_/A2 _2363_/A3 _1363_/B VDD VDD VSS VSS gf180mcu_fd_sc_mcu7t5v0__nand3_1
X_1293_ _1293_/I _1294_/B1 VDD VDD VSS VSS gf180mcu_fd_sc_mcu7t5v0__clkinv_1
Xinput190 tl_d_rom_i[60] _2242_/A1 VDD VDD VSS VSS gf180mcu_fd_sc_mcu7t5v0__dlyd_1
XFILLER_76_591 VDD VDD VSS VSS gf180mcu_fd_sc_mcu7t5v0__fillcap_4
XFILLER_51_414 VDD VDD VSS VSS gf180mcu_fd_sc_mcu7t5v0__fillcap_4
XTAP_TAPCELL_ROW_34_667 VDD VSS gf180mcu_fd_sc_mcu7t5v0__filltie
XFILLER_20_823 VDD VDD VSS VSS gf180mcu_fd_sc_mcu7t5v0__fillcap_8
XFILLER_32_661 VDD VDD VSS VSS gf180mcu_fd_sc_mcu7t5v0__fillcap_4
XTAP_TAPCELL_ROW_62_998 VDD VSS gf180mcu_fd_sc_mcu7t5v0__filltie
XTAP_TAPCELL_ROW_102_1478 VDD VSS gf180mcu_fd_sc_mcu7t5v0__filltie
X_2747_ _2747_/I _2747_/Z VDD VDD VSS VSS gf180mcu_fd_sc_mcu7t5v0__buf_1
X_2678_ _2750_/I _2678_/Z VDD VDD VSS VSS gf180mcu_fd_sc_mcu7t5v0__buf_1
Xoutput620 _2041_/ZN tl_d_esram_o[110] VDD VDD VSS VSS gf180mcu_fd_sc_mcu7t5v0__dlyd_1
Xoutput631 _1891_/ZN tl_d_esram_o[18] VDD VDD VSS VSS gf180mcu_fd_sc_mcu7t5v0__dlyd_1
Xoutput642 _1911_/ZN tl_d_esram_o[28] VDD VDD VSS VSS gf180mcu_fd_sc_mcu7t5v0__dlyd_1
Xoutput653 _1931_/ZN tl_d_esram_o[38] VDD VDD VSS VSS gf180mcu_fd_sc_mcu7t5v0__dlyd_1
X_1629_ _1930_/B2 _1641_/A2 _1629_/Z VDD VDD VSS VSS gf180mcu_fd_sc_mcu7t5v0__or2_1
Xoutput697 _2011_/ZN tl_d_esram_o[78] VDD VDD VSS VSS gf180mcu_fd_sc_mcu7t5v0__dlyd_1
Xoutput686 _1991_/ZN tl_d_esram_o[68] VDD VDD VSS VSS gf180mcu_fd_sc_mcu7t5v0__dlyd_1
Xoutput675 _1971_/ZN tl_d_esram_o[58] VDD VDD VSS VSS gf180mcu_fd_sc_mcu7t5v0__dlyd_1
Xoutput664 _1951_/ZN tl_d_esram_o[48] VDD VDD VSS VSS gf180mcu_fd_sc_mcu7t5v0__dlyd_1
XTAP_TAPCELL_ROW_70_1102 VDD VSS gf180mcu_fd_sc_mcu7t5v0__filltie
XTAP_TAPCELL_ROW_6_326 VDD VSS gf180mcu_fd_sc_mcu7t5v0__filltie
XFILLER_86_333 VDD VDD VSS VSS gf180mcu_fd_sc_mcu7t5v0__fillcap_8
XFILLER_27_422 VDD VDD VSS VSS gf180mcu_fd_sc_mcu7t5v0__fillcap_4
XFILLER_27_433 VDD VDD VSS VSS gf180mcu_fd_sc_mcu7t5v0__fillcap_32
XFILLER_39_282 VDD VDD VSS VSS gf180mcu_fd_sc_mcu7t5v0__fillcap_16
XTAP_TAPCELL_ROW_68_1075 VDD VSS gf180mcu_fd_sc_mcu7t5v0__filltie
XFILLER_70_734 VDD VDD VSS VSS gf180mcu_fd_sc_mcu7t5v0__fill_1
XFILLER_30_609 VDD VDD VSS VSS gf180mcu_fd_sc_mcu7t5v0__fillcap_32
XTAP_TAPCELL_ROW_81_1231 VDD VSS gf180mcu_fd_sc_mcu7t5v0__filltie
XFILLER_50_491 VDD VDD VSS VSS gf180mcu_fd_sc_mcu7t5v0__fill_2
XTAP_TAPCELL_ROW_92_1360 VDD VSS gf180mcu_fd_sc_mcu7t5v0__filltie
XFILLER_78_823 VDD VDD VSS VSS gf180mcu_fd_sc_mcu7t5v0__fillcap_8
XFILLER_73_572 VDD VDD VSS VSS gf180mcu_fd_sc_mcu7t5v0__fill_1
XFILLER_45_274 VDD VDD VSS VSS gf180mcu_fd_sc_mcu7t5v0__fillcap_4
X_1980_ _1980_/A1 _1982_/A2 _1998_/B1 _2722_/I _1981_/I VDD VDD VSS VSS gf180mcu_fd_sc_mcu7t5v0__aoi22_1
XFILLER_14_661 VDD VDD VSS VSS gf180mcu_fd_sc_mcu7t5v0__fillcap_4
XTAP_TAPCELL_ROW_31_626 VDD VSS gf180mcu_fd_sc_mcu7t5v0__filltie
X_2601_ _2601_/D _2601_/RN clkload5/I _2601_/Q VDD VDD VSS VSS gf180mcu_fd_sc_mcu7t5v0__dffrnq_1
XTAP_TAPCELL_ROW_11_383 VDD VSS gf180mcu_fd_sc_mcu7t5v0__filltie
X_2532_ _2599_/Q _2704_/I _2533_/B VDD VDD VSS VSS gf180mcu_fd_sc_mcu7t5v0__nor2_1
XTAP_TAPCELL_ROW_11_394 VDD VSS gf180mcu_fd_sc_mcu7t5v0__filltie
X_2463_ _2697_/I _2575_/Q _2471_/S _2575_/D VDD VDD VSS VSS gf180mcu_fd_sc_mcu7t5v0__mux2_2
XFILLER_68_300 VDD VDD VSS VSS gf180mcu_fd_sc_mcu7t5v0__fillcap_8
X_2394_ _2394_/I0 _2550_/Q _2394_/S _2550_/D VDD VDD VSS VSS gf180mcu_fd_sc_mcu7t5v0__mux2_2
X_1414_ _1414_/A1 _1486_/A2 _1414_/B1 _2208_/B _1415_/A2 VDD VDD VSS VSS gf180mcu_fd_sc_mcu7t5v0__aoi22_1
X_1345_ _1393_/A1 _2297_/A2 _1345_/Z VDD VDD VSS VSS gf180mcu_fd_sc_mcu7t5v0__and2_1
XTAP_TAPCELL_ROW_39_726 VDD VSS gf180mcu_fd_sc_mcu7t5v0__filltie
X_1276_ input11/Z _1348_/A2 _1276_/B1 _2155_/B1 _1277_/I VDD VDD VSS VSS gf180mcu_fd_sc_mcu7t5v0__aoi22_1
XFILLER_36_274 VDD VDD VSS VSS gf180mcu_fd_sc_mcu7t5v0__fill_1
XFILLER_52_734 VDD VDD VSS VSS gf180mcu_fd_sc_mcu7t5v0__fill_1
XFILLER_64_594 VDD VDD VSS VSS gf180mcu_fd_sc_mcu7t5v0__fill_1
XTAP_TAPCELL_ROW_19_483 VDD VSS gf180mcu_fd_sc_mcu7t5v0__filltie
XTAP_TAPCELL_ROW_104_1507 VDD VSS gf180mcu_fd_sc_mcu7t5v0__filltie
XTAP_TAPCELL_ROW_115_1636 VDD VSS gf180mcu_fd_sc_mcu7t5v0__filltie
Xfanout1119 _1508_/A2 wire1121/I VDD VDD VSS VSS gf180mcu_fd_sc_mcu7t5v0__dlyd_1
Xoutput494 _2633_/Z tl_d_dmem_o[0] VDD VDD VSS VSS gf180mcu_fd_sc_mcu7t5v0__dlyd_1
XFILLER_87_664 VDD VDD VSS VSS gf180mcu_fd_sc_mcu7t5v0__fillcap_4
XFILLER_86_141 VDD VDD VSS VSS gf180mcu_fd_sc_mcu7t5v0__fill_1
XFILLER_47_517 VDD VDD VSS VSS gf180mcu_fd_sc_mcu7t5v0__fillcap_32
Xwire1247 _2600_/RN _2597_/RN VDD VDD VSS VSS gf180mcu_fd_sc_mcu7t5v0__buf_4
XFILLER_86_174 VDD VDD VSS VSS gf180mcu_fd_sc_mcu7t5v0__fill_1
XFILLER_101_496 VDD VDD VSS VSS gf180mcu_fd_sc_mcu7t5v0__fill_2
XFILLER_28_731 VDD VDD VSS VSS gf180mcu_fd_sc_mcu7t5v0__fillcap_4
XFILLER_90_807 VDD VDD VSS VSS gf180mcu_fd_sc_mcu7t5v0__fillcap_16
XFILLER_86_185 VDD VDD VSS VSS gf180mcu_fd_sc_mcu7t5v0__fillcap_4
XFILLER_42_211 VDD VDD VSS VSS gf180mcu_fd_sc_mcu7t5v0__fill_1
XFILLER_42_244 VDD VDD VSS VSS gf180mcu_fd_sc_mcu7t5v0__fill_1
XFILLER_70_564 VDD VDD VSS VSS gf180mcu_fd_sc_mcu7t5v0__fillcap_4
XFILLER_70_531 VDD VDD VSS VSS gf180mcu_fd_sc_mcu7t5v0__fill_2
XFILLER_70_597 VDD VDD VSS VSS gf180mcu_fd_sc_mcu7t5v0__fillcap_16
XFILLER_8_28 VDD VDD VSS VSS gf180mcu_fd_sc_mcu7t5v0__fill_1
XFILLER_11_697 VDD VDD VSS VSS gf180mcu_fd_sc_mcu7t5v0__fill_2
XFILLER_19_6 VDD VDD VSS VSS gf180mcu_fd_sc_mcu7t5v0__fill_2
X_1130_ _2750_/I _2751_/I _2753_/I _2754_/I _1141_/A2 VDD VDD VSS VSS gf180mcu_fd_sc_mcu7t5v0__nor4_1
XFILLER_93_623 VDD VDD VSS VSS gf180mcu_fd_sc_mcu7t5v0__fillcap_4
XFILLER_38_539 VDD VDD VSS VSS gf180mcu_fd_sc_mcu7t5v0__fill_1
XFILLER_18_230 VDD VDD VSS VSS gf180mcu_fd_sc_mcu7t5v0__fillcap_8
X_1061_ _2568_/Q _1109_/A2 VDD VDD VSS VSS gf180mcu_fd_sc_mcu7t5v0__clkinv_1
XFILLER_18_263 VDD VDD VSS VSS gf180mcu_fd_sc_mcu7t5v0__fill_1
XFILLER_46_594 VDD VDD VSS VSS gf180mcu_fd_sc_mcu7t5v0__fill_1
XFILLER_80_317 VDD VDD VSS VSS gf180mcu_fd_sc_mcu7t5v0__fillcap_4
XFILLER_33_244 VDD VDD VSS VSS gf180mcu_fd_sc_mcu7t5v0__fillcap_16
XTAP_TAPCELL_ROW_44_784 VDD VSS gf180mcu_fd_sc_mcu7t5v0__filltie
XTAP_TAPCELL_ROW_16_453 VDD VSS gf180mcu_fd_sc_mcu7t5v0__filltie
X_1963_ _1963_/I _1963_/ZN VDD VDD VSS VSS gf180mcu_fd_sc_mcu7t5v0__clkinv_1
X_1894_ _1894_/A1 _1912_/A2 _1926_/B1 _2711_/I _1895_/I VDD VDD VSS VSS gf180mcu_fd_sc_mcu7t5v0__aoi22_1
X_2515_ _2595_/Q _2773_/I _2526_/B VDD VDD VSS VSS gf180mcu_fd_sc_mcu7t5v0__xor2_1
X_2446_ _2566_/Q _2434_/B _2446_/A3 _2446_/Z VDD VDD VSS VSS gf180mcu_fd_sc_mcu7t5v0__xor3_1
XFILLER_57_804 VDD VDD VSS VSS gf180mcu_fd_sc_mcu7t5v0__fill_2
X_2377_ _2377_/A1 _2377_/A2 _2378_/A2 VDD VDD VSS VSS gf180mcu_fd_sc_mcu7t5v0__nand2_1
XTAP_TAPCELL_ROW_110_1577 VDD VSS gf180mcu_fd_sc_mcu7t5v0__filltie
XFILLER_56_325 VDD VDD VSS VSS gf180mcu_fd_sc_mcu7t5v0__fill_2
XFILLER_68_174 VDD VDD VSS VSS gf180mcu_fd_sc_mcu7t5v0__fill_1
XFILLER_68_185 VDD VDD VSS VSS gf180mcu_fd_sc_mcu7t5v0__fillcap_32
X_1328_ _1328_/A1 _1368_/A2 _2289_/A2 VDD VDD VSS VSS gf180mcu_fd_sc_mcu7t5v0__nand2_1
XPHY_EDGE_ROW_3_Left_122 VDD VSS gf180mcu_fd_sc_mcu7t5v0__endcap
XFILLER_84_645 VDD VDD VSS VSS gf180mcu_fd_sc_mcu7t5v0__fillcap_16
X_1259_ _1253_/Z _1339_/A1 _1259_/B _1260_/B1 VDD VDD VSS VSS gf180mcu_fd_sc_mcu7t5v0__oai21_1
XFILLER_84_667 VDD VDD VSS VSS gf180mcu_fd_sc_mcu7t5v0__fillcap_8
XFILLER_72_807 VDD VDD VSS VSS gf180mcu_fd_sc_mcu7t5v0__fillcap_16
XFILLER_37_594 VDD VDD VSS VSS gf180mcu_fd_sc_mcu7t5v0__fillcap_8
XFILLER_24_244 VDD VDD VSS VSS gf180mcu_fd_sc_mcu7t5v0__fill_1
XTAP_TAPCELL_ROW_65_1034 VDD VSS gf180mcu_fd_sc_mcu7t5v0__filltie
XFILLER_40_737 VDD VDD VSS VSS gf180mcu_fd_sc_mcu7t5v0__fillcap_32
XFILLER_52_597 VDD VDD VSS VSS gf180mcu_fd_sc_mcu7t5v0__fillcap_16
XPHY_EDGE_ROW_49_Left_168 VDD VSS gf180mcu_fd_sc_mcu7t5v0__endcap
XTAP_TAPCELL_ROW_76_1174 VDD VSS gf180mcu_fd_sc_mcu7t5v0__filltie
XTAP_TAPCELL_ROW_76_1163 VDD VSS gf180mcu_fd_sc_mcu7t5v0__filltie
XFILLER_58_99 VDD VDD VSS VSS gf180mcu_fd_sc_mcu7t5v0__fillcap_4
XPHY_EDGE_ROW_58_Left_177 VDD VSS gf180mcu_fd_sc_mcu7t5v0__endcap
XFILLER_75_612 VDD VDD VSS VSS gf180mcu_fd_sc_mcu7t5v0__fillcap_16
XFILLER_101_282 VDD VDD VSS VSS gf180mcu_fd_sc_mcu7t5v0__fill_1
XFILLER_59_174 VDD VDD VSS VSS gf180mcu_fd_sc_mcu7t5v0__fillcap_16
XFILLER_87_494 VDD VDD VSS VSS gf180mcu_fd_sc_mcu7t5v0__fill_1
XFILLER_47_369 VDD VDD VSS VSS gf180mcu_fd_sc_mcu7t5v0__fillcap_4
XFILLER_75_689 VDD VDD VSS VSS gf180mcu_fd_sc_mcu7t5v0__fill_1
XFILLER_28_572 VDD VDD VSS VSS gf180mcu_fd_sc_mcu7t5v0__fillcap_16
XFILLER_28_594 VDD VDD VSS VSS gf180mcu_fd_sc_mcu7t5v0__fill_1
XFILLER_62_317 VDD VDD VSS VSS gf180mcu_fd_sc_mcu7t5v0__fillcap_16
XFILLER_74_177 VDD VDD VSS VSS gf180mcu_fd_sc_mcu7t5v0__fillcap_64
XTAP_TAPCELL_ROW_13_412 VDD VSS gf180mcu_fd_sc_mcu7t5v0__filltie
XFILLER_30_247 VDD VDD VSS VSS gf180mcu_fd_sc_mcu7t5v0__fillcap_16
XTAP_TAPCELL_ROW_41_754 VDD VSS gf180mcu_fd_sc_mcu7t5v0__filltie
XTAP_TAPCELL_ROW_41_743 VDD VSS gf180mcu_fd_sc_mcu7t5v0__filltie
XPHY_EDGE_ROW_67_Left_186 VDD VSS gf180mcu_fd_sc_mcu7t5v0__endcap
X_2300_ _2300_/A1 _2300_/A2 _2360_/B _2300_/ZN VDD VDD VSS VSS gf180mcu_fd_sc_mcu7t5v0__aoi21_1
X_2231_ input54/Z _2230_/B _2231_/B1 _2231_/B2 _2231_/C _2232_/A2 VDD VDD VSS VSS
+ gf180mcu_fd_sc_mcu7t5v0__aoi221_1
XPHY_EDGE_ROW_76_Left_195 VDD VSS gf180mcu_fd_sc_mcu7t5v0__endcap
XFILLER_39_859 VDD VDD VSS VSS gf180mcu_fd_sc_mcu7t5v0__fillcap_4
X_2162_ _2162_/A1 _2162_/A2 _2162_/ZN VDD VDD VSS VSS gf180mcu_fd_sc_mcu7t5v0__nand2_1
XTAP_TAPCELL_ROW_49_843 VDD VSS gf180mcu_fd_sc_mcu7t5v0__filltie
XFILLER_54_807 VDD VDD VSS VSS gf180mcu_fd_sc_mcu7t5v0__fillcap_16
XFILLER_66_667 VDD VDD VSS VSS gf180mcu_fd_sc_mcu7t5v0__fillcap_8
X_2093_ _2205_/A1 _2373_/A1 _2095_/A1 VDD VDD VSS VSS gf180mcu_fd_sc_mcu7t5v0__nand2_1
X_1113_ _2569_/Q _1114_/A2 _2207_/B VDD VDD VSS VSS gf180mcu_fd_sc_mcu7t5v0__nor2_1
XFILLER_22_737 VDD VDD VSS VSS gf180mcu_fd_sc_mcu7t5v0__fillcap_64
X_1946_ _1946_/A1 _1976_/A2 _2537_/A2 _1946_/B2 _1947_/I VDD VDD VSS VSS gf180mcu_fd_sc_mcu7t5v0__aoi22_1
X_1877_ _1877_/I _1877_/ZN VDD VDD VSS VSS gf180mcu_fd_sc_mcu7t5v0__clkinv_1
XTAP_TAPCELL_ROW_112_1606 VDD VSS gf180mcu_fd_sc_mcu7t5v0__filltie
XFILLER_88_214 VDD VDD VSS VSS gf180mcu_fd_sc_mcu7t5v0__fillcap_16
XFILLER_88_247 VDD VDD VSS VSS gf180mcu_fd_sc_mcu7t5v0__fillcap_32
X_2429_ _2429_/A1 _2429_/A2 _2429_/B _2433_/C VDD VDD VSS VSS gf180mcu_fd_sc_mcu7t5v0__aoi21_1
XFILLER_57_645 VDD VDD VSS VSS gf180mcu_fd_sc_mcu7t5v0__fillcap_32
XFILLER_29_347 VDD VDD VSS VSS gf180mcu_fd_sc_mcu7t5v0__fill_2
Xload_slew1118 _1500_/A2 _1468_/A2 VDD VDD VSS VSS gf180mcu_fd_sc_mcu7t5v0__buf_4
Xload_slew1129 _1718_/B1 _1722_/B1 VDD VDD VSS VSS gf180mcu_fd_sc_mcu7t5v0__buf_4
XFILLER_84_464 VDD VDD VSS VSS gf180mcu_fd_sc_mcu7t5v0__fillcap_32
XFILLER_44_317 VDD VDD VSS VSS gf180mcu_fd_sc_mcu7t5v0__fillcap_4
XFILLER_56_177 VDD VDD VSS VSS gf180mcu_fd_sc_mcu7t5v0__fillcap_8
XFILLER_72_659 VDD VDD VSS VSS gf180mcu_fd_sc_mcu7t5v0__fillcap_4
XFILLER_40_523 VDD VDD VSS VSS gf180mcu_fd_sc_mcu7t5v0__fill_2
XFILLER_80_681 VDD VDD VSS VSS gf180mcu_fd_sc_mcu7t5v0__fill_1
XFILLER_12_269 VDD VDD VSS VSS gf180mcu_fd_sc_mcu7t5v0__fill_1
XFILLER_60_12 VDD VDD VSS VSS gf180mcu_fd_sc_mcu7t5v0__fill_1
XFILLER_107_842 VDD VDD VSS VSS gf180mcu_fd_sc_mcu7t5v0__fillcap_4
XFILLER_107_864 VDD VDD VSS VSS gf180mcu_fd_sc_mcu7t5v0__fill_2
XFILLER_106_374 VDD VDD VSS VSS gf180mcu_fd_sc_mcu7t5v0__fill_1
XFILLER_47_111 VDD VDD VSS VSS gf180mcu_fd_sc_mcu7t5v0__fillcap_16
XTAP_TAPCELL_ROW_89_1321 VDD VSS gf180mcu_fd_sc_mcu7t5v0__filltie
XFILLER_36_807 VDD VDD VSS VSS gf180mcu_fd_sc_mcu7t5v0__fillcap_16
XFILLER_48_656 VDD VDD VSS VSS gf180mcu_fd_sc_mcu7t5v0__fillcap_8
XFILLER_48_667 VDD VDD VSS VSS gf180mcu_fd_sc_mcu7t5v0__fillcap_32
XFILLER_62_103 VDD VDD VSS VSS gf180mcu_fd_sc_mcu7t5v0__fill_2
XTAP_TAPCELL_ROW_46_813 VDD VSS gf180mcu_fd_sc_mcu7t5v0__filltie
XFILLER_62_158 VDD VDD VSS VSS gf180mcu_fd_sc_mcu7t5v0__fillcap_8
XFILLER_16_597 VDD VDD VSS VSS gf180mcu_fd_sc_mcu7t5v0__fillcap_64
XTAP_TAPCELL_ROW_26_570 VDD VSS gf180mcu_fd_sc_mcu7t5v0__filltie
XFILLER_31_556 VDD VDD VSS VSS gf180mcu_fd_sc_mcu7t5v0__fillcap_4
X_1800_ _1990_/A1 _1818_/A2 _1838_/B1 _2727_/I _1801_/I VDD VDD VSS VSS gf180mcu_fd_sc_mcu7t5v0__aoi22_1
X_1731_ _1731_/I _1731_/ZN VDD VDD VSS VSS gf180mcu_fd_sc_mcu7t5v0__clkinv_1
X_1662_ _1876_/B2 _1587_/Z _1662_/S _1662_/Z VDD VDD VSS VSS gf180mcu_fd_sc_mcu7t5v0__mux2_2
X_1593_ _2699_/I _2729_/I _1552_/Z _1593_/Z VDD VDD VSS VSS gf180mcu_fd_sc_mcu7t5v0__xor3_1
XPHY_EDGE_ROW_84_Left_203 VDD VSS gf180mcu_fd_sc_mcu7t5v0__endcap
XFILLER_100_506 VDD VDD VSS VSS gf180mcu_fd_sc_mcu7t5v0__fill_2
X_2214_ _1116_/B _2214_/A2 _2214_/A3 _2215_/C VDD VDD VSS VSS gf180mcu_fd_sc_mcu7t5v0__nand3_1
XFILLER_85_228 VDD VDD VSS VSS gf180mcu_fd_sc_mcu7t5v0__fillcap_8
XFILLER_39_656 VDD VDD VSS VSS gf180mcu_fd_sc_mcu7t5v0__fillcap_4
X_2145_ _2150_/B1 _2145_/A2 _2145_/B _2170_/C _2146_/B VDD VDD VSS VSS gf180mcu_fd_sc_mcu7t5v0__oai211_1
XFILLER_26_317 VDD VDD VSS VSS gf180mcu_fd_sc_mcu7t5v0__fillcap_32
XFILLER_38_177 VDD VDD VSS VSS gf180mcu_fd_sc_mcu7t5v0__fillcap_8
XFILLER_81_412 VDD VDD VSS VSS gf180mcu_fd_sc_mcu7t5v0__fillcap_8
XFILLER_54_659 VDD VDD VSS VSS gf180mcu_fd_sc_mcu7t5v0__fillcap_4
X_2076_ _1066_/I _2076_/A2 _2291_/A2 input73/Z _2251_/A3 _2169_/A1 _2077_/I VDD VDD
+ VSS VSS gf180mcu_fd_sc_mcu7t5v0__aoi222_1
XPHY_EDGE_ROW_93_Left_212 VDD VSS gf180mcu_fd_sc_mcu7t5v0__endcap
XTAP_TAPCELL_ROW_62_1004 VDD VSS gf180mcu_fd_sc_mcu7t5v0__filltie
XFILLER_10_707 VDD VDD VSS VSS gf180mcu_fd_sc_mcu7t5v0__fillcap_4
XFILLER_10_718 VDD VDD VSS VSS gf180mcu_fd_sc_mcu7t5v0__fillcap_16
X_1929_ _1929_/I _1929_/ZN VDD VDD VSS VSS gf180mcu_fd_sc_mcu7t5v0__clkinv_1
XFILLER_30_26 VDD VDD VSS VSS gf180mcu_fd_sc_mcu7t5v0__fill_2
XTAP_TAPCELL_ROW_73_1133 VDD VSS gf180mcu_fd_sc_mcu7t5v0__filltie
XFILLER_18_807 VDD VDD VSS VSS gf180mcu_fd_sc_mcu7t5v0__fillcap_16
XFILLER_91_209 VDD VDD VSS VSS gf180mcu_fd_sc_mcu7t5v0__fill_1
XFILLER_29_177 VDD VDD VSS VSS gf180mcu_fd_sc_mcu7t5v0__fillcap_4
XFILLER_45_626 VDD VDD VSS VSS gf180mcu_fd_sc_mcu7t5v0__fillcap_4
XFILLER_72_445 VDD VDD VSS VSS gf180mcu_fd_sc_mcu7t5v0__fillcap_8
XTAP_TAPCELL_ROW_84_1262 VDD VSS gf180mcu_fd_sc_mcu7t5v0__filltie
XFILLER_13_556 VDD VDD VSS VSS gf180mcu_fd_sc_mcu7t5v0__fillcap_4
XFILLER_40_353 VDD VDD VSS VSS gf180mcu_fd_sc_mcu7t5v0__fill_1
XFILLER_41_865 VDD VDD VSS VSS gf180mcu_fd_sc_mcu7t5v0__fill_1
XTAP_TAPCELL_ROW_51_871 VDD VSS gf180mcu_fd_sc_mcu7t5v0__filltie
XTAP_TAPCELL_ROW_95_1391 VDD VSS gf180mcu_fd_sc_mcu7t5v0__filltie
XFILLER_67_206 VDD VDD VSS VSS gf180mcu_fd_sc_mcu7t5v0__fillcap_4
XFILLER_48_442 VDD VDD VSS VSS gf180mcu_fd_sc_mcu7t5v0__fillcap_8
Xinput350 tl_h_d_i[73] wire1229/I VDD VDD VSS VSS gf180mcu_fd_sc_mcu7t5v0__clkbuf_2
Xinput361 tl_h_d_i[83] _2742_/I VDD VDD VSS VSS gf180mcu_fd_sc_mcu7t5v0__clkbuf_2
Xinput372 tl_h_d_i[93] _2752_/I VDD VDD VSS VSS gf180mcu_fd_sc_mcu7t5v0__clkbuf_2
Xinput383 tl_h_i_i[102] _2400_/I0 VDD VDD VSS VSS gf180mcu_fd_sc_mcu7t5v0__dlyd_1
Xinput394 tl_h_i_i[112] _2391_/I0 VDD VDD VSS VSS gf180mcu_fd_sc_mcu7t5v0__dlyd_1
XTAP_TAPCELL_ROW_59_960 VDD VSS gf180mcu_fd_sc_mcu7t5v0__filltie
XFILLER_91_732 VDD VDD VSS VSS gf180mcu_fd_sc_mcu7t5v0__fillcap_4
XFILLER_17_851 VDD VDD VSS VSS gf180mcu_fd_sc_mcu7t5v0__fillcap_8
XFILLER_51_629 VDD VDD VSS VSS gf180mcu_fd_sc_mcu7t5v0__fill_1
XFILLER_90_242 VDD VDD VSS VSS gf180mcu_fd_sc_mcu7t5v0__fill_2
XFILLER_50_128 VDD VDD VSS VSS gf180mcu_fd_sc_mcu7t5v0__fill_2
XFILLER_31_364 VDD VDD VSS VSS gf180mcu_fd_sc_mcu7t5v0__fillcap_16
X_2763_ _2763_/I _2763_/Z VDD VDD VSS VSS gf180mcu_fd_sc_mcu7t5v0__buf_1
X_1714_ _1904_/A1 _1720_/A2 _1736_/B1 _2716_/I _1715_/I VDD VDD VSS VSS gf180mcu_fd_sc_mcu7t5v0__aoi22_1
X_2694_ _2766_/I _2694_/Z VDD VDD VSS VSS gf180mcu_fd_sc_mcu7t5v0__buf_1
Xoutput802 _1827_/ZN tl_d_rom_o[98] VDD VDD VSS VSS gf180mcu_fd_sc_mcu7t5v0__dlyd_1
Xoutput846 _1625_/Z tl_d_uart_o[34] VDD VDD VSS VSS gf180mcu_fd_sc_mcu7t5v0__dlyd_1
Xoutput835 _2715_/Z tl_d_uart_o[24] VDD VDD VSS VSS gf180mcu_fd_sc_mcu7t5v0__dlyd_1
Xoutput824 _1665_/Z tl_d_uart_o[14] VDD VDD VSS VSS gf180mcu_fd_sc_mcu7t5v0__dlyd_1
Xoutput813 _2766_/Z tl_d_uart_o[107] VDD VDD VSS VSS gf180mcu_fd_sc_mcu7t5v0__dlyd_1
X_1645_ _1962_/B2 _1651_/A2 _1645_/Z VDD VDD VSS VSS gf180mcu_fd_sc_mcu7t5v0__or2_1
Xoutput879 _2723_/Z tl_d_uart_o[64] VDD VDD VSS VSS gf180mcu_fd_sc_mcu7t5v0__dlyd_1
Xoutput868 _1645_/Z tl_d_uart_o[54] VDD VDD VSS VSS gf180mcu_fd_sc_mcu7t5v0__dlyd_1
Xoutput857 _1635_/Z tl_d_uart_o[44] VDD VDD VSS VSS gf180mcu_fd_sc_mcu7t5v0__dlyd_1
X_1576_ _2744_/I _2742_/I _2743_/I _1576_/Z VDD VDD VSS VSS gf180mcu_fd_sc_mcu7t5v0__xor3_1
XFILLER_98_375 VDD VDD VSS VSS gf180mcu_fd_sc_mcu7t5v0__fill_1
XFILLER_100_325 VDD VDD VSS VSS gf180mcu_fd_sc_mcu7t5v0__fillcap_8
XFILLER_27_626 VDD VDD VSS VSS gf180mcu_fd_sc_mcu7t5v0__fillcap_4
XFILLER_39_486 VDD VDD VSS VSS gf180mcu_fd_sc_mcu7t5v0__fillcap_4
X_2128_ _2128_/A1 _2172_/A2 _2154_/A2 _2128_/B2 _2128_/C _2128_/ZN VDD VDD VSS VSS
+ gf180mcu_fd_sc_mcu7t5v0__aoi221_2
XTAP_TAPCELL_ROW_107_1538 VDD VSS gf180mcu_fd_sc_mcu7t5v0__filltie
XFILLER_82_732 VDD VDD VSS VSS gf180mcu_fd_sc_mcu7t5v0__fill_2
XFILLER_42_618 VDD VDD VSS VSS gf180mcu_fd_sc_mcu7t5v0__fill_1
X_2059_ _2059_/I _2059_/ZN VDD VDD VSS VSS gf180mcu_fd_sc_mcu7t5v0__clkinv_1
XTAP_TAPCELL_ROW_1_268 VDD VSS gf180mcu_fd_sc_mcu7t5v0__filltie
XTAP_TAPCELL_ROW_37_698 VDD VSS gf180mcu_fd_sc_mcu7t5v0__filltie
XFILLER_50_651 VDD VDD VSS VSS gf180mcu_fd_sc_mcu7t5v0__fill_1
XFILLER_10_559 VDD VDD VSS VSS gf180mcu_fd_sc_mcu7t5v0__fill_2
XFILLER_6_519 VDD VDD VSS VSS gf180mcu_fd_sc_mcu7t5v0__fillcap_4
XTAP_TAPCELL_ROW_118_1678 VDD VSS gf180mcu_fd_sc_mcu7t5v0__filltie
XTAP_TAPCELL_ROW_118_1667 VDD VSS gf180mcu_fd_sc_mcu7t5v0__filltie
XTAP_TAPCELL_ROW_118_1689 VDD VSS gf180mcu_fd_sc_mcu7t5v0__filltie
XTAP_TAPCELL_ROW_9_368 VDD VSS gf180mcu_fd_sc_mcu7t5v0__filltie
XFILLER_49_228 VDD VDD VSS VSS gf180mcu_fd_sc_mcu7t5v0__fillcap_8
XFILLER_92_518 VDD VDD VSS VSS gf180mcu_fd_sc_mcu7t5v0__fillcap_4
XFILLER_85_570 VDD VDD VSS VSS gf180mcu_fd_sc_mcu7t5v0__fill_2
XFILLER_57_294 VDD VDD VSS VSS gf180mcu_fd_sc_mcu7t5v0__fill_2
XFILLER_66_99 VDD VDD VSS VSS gf180mcu_fd_sc_mcu7t5v0__fillcap_4
XTAP_TAPCELL_ROW_56_930 VDD VSS gf180mcu_fd_sc_mcu7t5v0__filltie
XFILLER_82_10 VDD VDD VSS VSS gf180mcu_fd_sc_mcu7t5v0__fill_1
XFILLER_72_242 VDD VDD VSS VSS gf180mcu_fd_sc_mcu7t5v0__fill_2
XFILLER_45_489 VDD VDD VSS VSS gf180mcu_fd_sc_mcu7t5v0__fill_1
XTAP_TAPCELL_ROW_97_1420 VDD VSS gf180mcu_fd_sc_mcu7t5v0__filltie
X_1430_ _1430_/A1 _1486_/A2 _1430_/B1 _2208_/B _1431_/A2 VDD VDD VSS VSS gf180mcu_fd_sc_mcu7t5v0__aoi22_1
X_1361_ _1393_/A1 _2305_/A2 _1361_/Z VDD VDD VSS VSS gf180mcu_fd_sc_mcu7t5v0__and2_1
X_1292_ input14/Z _1396_/A2 _1292_/B1 _1444_/B2 _1293_/I VDD VDD VSS VSS gf180mcu_fd_sc_mcu7t5v0__aoi22_1
Xinput180 tl_d_rom_i[51] _2187_/A1 VDD VDD VSS VSS gf180mcu_fd_sc_mcu7t5v0__dlyd_1
Xinput191 tl_d_rom_i[61] _2246_/A1 VDD VDD VSS VSS gf180mcu_fd_sc_mcu7t5v0__dlyd_1
XFILLER_63_264 VDD VDD VSS VSS gf180mcu_fd_sc_mcu7t5v0__fill_2
XFILLER_91_562 VDD VDD VSS VSS gf180mcu_fd_sc_mcu7t5v0__fillcap_64
XTAP_TAPCELL_ROW_34_668 VDD VSS gf180mcu_fd_sc_mcu7t5v0__filltie
XTAP_TAPCELL_ROW_62_999 VDD VSS gf180mcu_fd_sc_mcu7t5v0__filltie
XTAP_TAPCELL_ROW_102_1479 VDD VSS gf180mcu_fd_sc_mcu7t5v0__filltie
X_2746_ _2746_/I _2746_/Z VDD VDD VSS VSS gf180mcu_fd_sc_mcu7t5v0__buf_1
X_2677_ _2749_/I _2677_/Z VDD VDD VSS VSS gf180mcu_fd_sc_mcu7t5v0__buf_1
Xoutput610 _2023_/ZN tl_d_esram_o[101] VDD VDD VSS VSS gf180mcu_fd_sc_mcu7t5v0__dlyd_1
Xoutput621 _2043_/ZN tl_d_esram_o[111] VDD VDD VSS VSS gf180mcu_fd_sc_mcu7t5v0__dlyd_1
Xoutput632 _1893_/ZN tl_d_esram_o[19] VDD VDD VSS VSS gf180mcu_fd_sc_mcu7t5v0__dlyd_1
Xoutput643 _1913_/ZN tl_d_esram_o[29] VDD VDD VSS VSS gf180mcu_fd_sc_mcu7t5v0__dlyd_1
Xoutput654 _1933_/ZN tl_d_esram_o[39] VDD VDD VSS VSS gf180mcu_fd_sc_mcu7t5v0__dlyd_1
X_1628_ _1928_/B2 _1641_/A2 _1628_/Z VDD VDD VSS VSS gf180mcu_fd_sc_mcu7t5v0__or2_1
Xoutput687 _1993_/ZN tl_d_esram_o[69] VDD VDD VSS VSS gf180mcu_fd_sc_mcu7t5v0__dlyd_1
Xoutput676 _1973_/ZN tl_d_esram_o[59] VDD VDD VSS VSS gf180mcu_fd_sc_mcu7t5v0__dlyd_1
Xoutput665 _1953_/ZN tl_d_esram_o[49] VDD VDD VSS VSS gf180mcu_fd_sc_mcu7t5v0__dlyd_1
Xoutput698 _2013_/ZN tl_d_esram_o[79] VDD VDD VSS VSS gf180mcu_fd_sc_mcu7t5v0__dlyd_1
X_1559_ _2698_/I _2724_/I _2699_/I _1574_/A1 VDD VDD VSS VSS gf180mcu_fd_sc_mcu7t5v0__xnor3_1
XTAP_TAPCELL_ROW_6_327 VDD VSS gf180mcu_fd_sc_mcu7t5v0__filltie
XFILLER_86_356 VDD VDD VSS VSS gf180mcu_fd_sc_mcu7t5v0__fill_1
XFILLER_100_177 VDD VDD VSS VSS gf180mcu_fd_sc_mcu7t5v0__fill_1
XFILLER_67_570 VDD VDD VSS VSS gf180mcu_fd_sc_mcu7t5v0__fill_2
XFILLER_86_378 VDD VDD VSS VSS gf180mcu_fd_sc_mcu7t5v0__fillcap_4
XFILLER_82_540 VDD VDD VSS VSS gf180mcu_fd_sc_mcu7t5v0__fillcap_4
XTAP_TAPCELL_ROW_68_1076 VDD VSS gf180mcu_fd_sc_mcu7t5v0__filltie
XTAP_TAPCELL_ROW_81_1232 VDD VSS gf180mcu_fd_sc_mcu7t5v0__filltie
XFILLER_11_846 VDD VDD VSS VSS gf180mcu_fd_sc_mcu7t5v0__fill_1
XPHY_EDGE_ROW_30_Left_149 VDD VSS gf180mcu_fd_sc_mcu7t5v0__endcap
XTAP_TAPCELL_ROW_92_1361 VDD VSS gf180mcu_fd_sc_mcu7t5v0__filltie
XFILLER_77_301 VDD VDD VSS VSS gf180mcu_fd_sc_mcu7t5v0__fillcap_4
XFILLER_77_345 VDD VDD VSS VSS gf180mcu_fd_sc_mcu7t5v0__fillcap_4
XFILLER_37_209 VDD VDD VSS VSS gf180mcu_fd_sc_mcu7t5v0__fill_1
XFILLER_61_702 VDD VDD VSS VSS gf180mcu_fd_sc_mcu7t5v0__fillcap_64
XFILLER_73_562 VDD VDD VSS VSS gf180mcu_fd_sc_mcu7t5v0__fillcap_8
XFILLER_33_404 VDD VDD VSS VSS gf180mcu_fd_sc_mcu7t5v0__fillcap_16
XFILLER_45_264 VDD VDD VSS VSS gf180mcu_fd_sc_mcu7t5v0__fill_1
XFILLER_41_492 VDD VDD VSS VSS gf180mcu_fd_sc_mcu7t5v0__fill_2
XTAP_TAPCELL_ROW_31_627 VDD VSS gf180mcu_fd_sc_mcu7t5v0__filltie
X_2600_ _2600_/D _2600_/RN clkload5/I _2600_/Q VDD VDD VSS VSS gf180mcu_fd_sc_mcu7t5v0__dffrnq_1
X_2531_ _1078_/I _2531_/A2 _2704_/I _2531_/B2 _2598_/D VDD VDD VSS VSS gf180mcu_fd_sc_mcu7t5v0__oai22_1
XTAP_TAPCELL_ROW_11_384 VDD VSS gf180mcu_fd_sc_mcu7t5v0__filltie
X_2462_ _2709_/I _2574_/Q _2462_/S _2574_/D VDD VDD VSS VSS gf180mcu_fd_sc_mcu7t5v0__mux2_2
XFILLER_68_312 VDD VDD VSS VSS gf180mcu_fd_sc_mcu7t5v0__fill_2
X_2393_ _2393_/I0 _2549_/Q _2394_/S _2549_/D VDD VDD VSS VSS gf180mcu_fd_sc_mcu7t5v0__mux2_2
X_1413_ _1413_/I _1414_/B1 VDD VDD VSS VSS gf180mcu_fd_sc_mcu7t5v0__clkinv_1
X_1344_ _1344_/A1 _1368_/A2 _2297_/A2 VDD VDD VSS VSS gf180mcu_fd_sc_mcu7t5v0__nand2_1
X_1275_ _1339_/A1 _1273_/Z _1275_/B _1276_/B1 VDD VDD VSS VSS gf180mcu_fd_sc_mcu7t5v0__oai21_1
XTAP_TAPCELL_ROW_39_727 VDD VSS gf180mcu_fd_sc_mcu7t5v0__filltie
XFILLER_83_348 VDD VDD VSS VSS gf180mcu_fd_sc_mcu7t5v0__fill_2
XFILLER_24_426 VDD VDD VSS VSS gf180mcu_fd_sc_mcu7t5v0__fillcap_16
XTAP_TAPCELL_ROW_104_1508 VDD VSS gf180mcu_fd_sc_mcu7t5v0__filltie
XTAP_TAPCELL_ROW_19_484 VDD VSS gf180mcu_fd_sc_mcu7t5v0__filltie
XFILLER_118_575 VDD VDD VSS VSS gf180mcu_fd_sc_mcu7t5v0__fill_2
X_2729_ _2729_/I _2729_/Z VDD VDD VSS VSS gf180mcu_fd_sc_mcu7t5v0__buf_1
XTAP_TAPCELL_ROW_115_1637 VDD VSS gf180mcu_fd_sc_mcu7t5v0__filltie
Xoutput495 _2687_/Z tl_d_dmem_o[100] VDD VDD VSS VSS gf180mcu_fd_sc_mcu7t5v0__dlyd_1
XFILLER_99_492 VDD VDD VSS VSS gf180mcu_fd_sc_mcu7t5v0__fillcap_16
XFILLER_87_632 VDD VDD VSS VSS gf180mcu_fd_sc_mcu7t5v0__fillcap_32
XFILLER_101_486 VDD VDD VSS VSS gf180mcu_fd_sc_mcu7t5v0__fillcap_4
XPHY_EDGE_ROW_29_Right_29 VDD VSS gf180mcu_fd_sc_mcu7t5v0__endcap
XFILLER_27_220 VDD VDD VSS VSS gf180mcu_fd_sc_mcu7t5v0__fillcap_4
XFILLER_43_702 VDD VDD VSS VSS gf180mcu_fd_sc_mcu7t5v0__fillcap_64
XFILLER_55_562 VDD VDD VSS VSS gf180mcu_fd_sc_mcu7t5v0__fillcap_16
XFILLER_82_381 VDD VDD VSS VSS gf180mcu_fd_sc_mcu7t5v0__fillcap_4
XFILLER_70_521 VDD VDD VSS VSS gf180mcu_fd_sc_mcu7t5v0__fillcap_4
XFILLER_11_632 VDD VDD VSS VSS gf180mcu_fd_sc_mcu7t5v0__fillcap_16
XFILLER_23_470 VDD VDD VSS VSS gf180mcu_fd_sc_mcu7t5v0__fillcap_16
XFILLER_23_492 VDD VDD VSS VSS gf180mcu_fd_sc_mcu7t5v0__fillcap_64
XFILLER_8_18 VDD VDD VSS VSS gf180mcu_fd_sc_mcu7t5v0__fillcap_8
XPHY_EDGE_ROW_38_Right_38 VDD VSS gf180mcu_fd_sc_mcu7t5v0__endcap
XFILLER_3_842 VDD VDD VSS VSS gf180mcu_fd_sc_mcu7t5v0__fillcap_16
XFILLER_97_418 VDD VDD VSS VSS gf180mcu_fd_sc_mcu7t5v0__fill_2
XPHY_EDGE_ROW_47_Right_47 VDD VSS gf180mcu_fd_sc_mcu7t5v0__endcap
XFILLER_77_142 VDD VDD VSS VSS gf180mcu_fd_sc_mcu7t5v0__fillcap_16
XFILLER_65_337 VDD VDD VSS VSS gf180mcu_fd_sc_mcu7t5v0__fillcap_8
XFILLER_18_242 VDD VDD VSS VSS gf180mcu_fd_sc_mcu7t5v0__fill_2
X_1060_ _2570_/Q _2458_/A1 VDD VDD VSS VSS gf180mcu_fd_sc_mcu7t5v0__clkinv_1
XFILLER_33_212 VDD VDD VSS VSS gf180mcu_fd_sc_mcu7t5v0__fillcap_32
XTAP_TAPCELL_ROW_16_454 VDD VSS gf180mcu_fd_sc_mcu7t5v0__filltie
XTAP_TAPCELL_ROW_16_443 VDD VSS gf180mcu_fd_sc_mcu7t5v0__filltie
X_1962_ _1962_/A1 _1982_/A2 _1998_/B1 _1962_/B2 _1963_/I VDD VDD VSS VSS gf180mcu_fd_sc_mcu7t5v0__aoi22_1
XTAP_TAPCELL_ROW_44_785 VDD VSS gf180mcu_fd_sc_mcu7t5v0__filltie
XPHY_EDGE_ROW_56_Right_56 VDD VSS gf180mcu_fd_sc_mcu7t5v0__endcap
X_1893_ _1893_/I _1893_/ZN VDD VDD VSS VSS gf180mcu_fd_sc_mcu7t5v0__clkinv_1
X_2514_ _2507_/B _2513_/Z _2514_/B _2594_/D VDD VDD VSS VSS gf180mcu_fd_sc_mcu7t5v0__oai21_1
X_2445_ _2565_/Q _2434_/B _2445_/B _2446_/A3 VDD VDD VSS VSS gf180mcu_fd_sc_mcu7t5v0__aoi21_1
XPHY_EDGE_ROW_65_Right_65 VDD VSS gf180mcu_fd_sc_mcu7t5v0__endcap
XFILLER_68_153 VDD VDD VSS VSS gf180mcu_fd_sc_mcu7t5v0__fill_2
XFILLER_68_164 VDD VDD VSS VSS gf180mcu_fd_sc_mcu7t5v0__fillcap_8
X_2376_ _2376_/A1 _2376_/A2 _2376_/B _2376_/ZN VDD VDD VSS VSS gf180mcu_fd_sc_mcu7t5v0__aoi21_1
XTAP_TAPCELL_ROW_110_1578 VDD VSS gf180mcu_fd_sc_mcu7t5v0__filltie
X_1327_ _1399_/A1 _1327_/A2 _1327_/ZN VDD VDD VSS VSS gf180mcu_fd_sc_mcu7t5v0__nor2_1
XFILLER_69_698 VDD VDD VSS VSS gf180mcu_fd_sc_mcu7t5v0__fill_2
XFILLER_56_348 VDD VDD VSS VSS gf180mcu_fd_sc_mcu7t5v0__fillcap_8
X_1258_ input75/Z _2116_/B1 _2259_/A3 _1259_/B VDD VDD VSS VSS gf180mcu_fd_sc_mcu7t5v0__nand3_1
XFILLER_84_679 VDD VDD VSS VSS gf180mcu_fd_sc_mcu7t5v0__fill_2
XFILLER_25_702 VDD VDD VSS VSS gf180mcu_fd_sc_mcu7t5v0__fillcap_64
XFILLER_37_562 VDD VDD VSS VSS gf180mcu_fd_sc_mcu7t5v0__fillcap_32
X_1189_ _1191_/A1 _2383_/A1 _1190_/B VDD VDD VSS VSS gf180mcu_fd_sc_mcu7t5v0__nand2_1
XFILLER_83_167 VDD VDD VSS VSS gf180mcu_fd_sc_mcu7t5v0__fillcap_4
XFILLER_52_521 VDD VDD VSS VSS gf180mcu_fd_sc_mcu7t5v0__fillcap_4
XTAP_TAPCELL_ROW_65_1035 VDD VSS gf180mcu_fd_sc_mcu7t5v0__filltie
XPHY_EDGE_ROW_74_Right_74 VDD VSS gf180mcu_fd_sc_mcu7t5v0__endcap
XFILLER_20_451 VDD VDD VSS VSS gf180mcu_fd_sc_mcu7t5v0__fillcap_4
XPHY_EDGE_ROW_104_Left_223 VDD VSS gf180mcu_fd_sc_mcu7t5v0__endcap
XFILLER_116_6 VDD VDD VSS VSS gf180mcu_fd_sc_mcu7t5v0__fill_1
XTAP_TAPCELL_ROW_76_1164 VDD VSS gf180mcu_fd_sc_mcu7t5v0__filltie
XPHY_EDGE_ROW_83_Right_83 VDD VSS gf180mcu_fd_sc_mcu7t5v0__endcap
XFILLER_79_418 VDD VDD VSS VSS gf180mcu_fd_sc_mcu7t5v0__fill_2
XFILLER_59_142 VDD VDD VSS VSS gf180mcu_fd_sc_mcu7t5v0__fillcap_32
XPHY_EDGE_ROW_113_Left_232 VDD VSS gf180mcu_fd_sc_mcu7t5v0__endcap
XFILLER_75_679 VDD VDD VSS VSS gf180mcu_fd_sc_mcu7t5v0__fillcap_8
XPHY_EDGE_ROW_92_Right_92 VDD VSS gf180mcu_fd_sc_mcu7t5v0__endcap
XFILLER_15_278 VDD VDD VSS VSS gf180mcu_fd_sc_mcu7t5v0__fill_2
XTAP_TAPCELL_ROW_13_413 VDD VSS gf180mcu_fd_sc_mcu7t5v0__filltie
XFILLER_70_384 VDD VDD VSS VSS gf180mcu_fd_sc_mcu7t5v0__fill_1
XTAP_TAPCELL_ROW_41_744 VDD VSS gf180mcu_fd_sc_mcu7t5v0__filltie
XFILLER_7_488 VDD VDD VSS VSS gf180mcu_fd_sc_mcu7t5v0__fill_2
X_2230_ _2230_/A1 _2230_/A2 _2230_/B _2231_/B2 VDD VDD VSS VSS gf180mcu_fd_sc_mcu7t5v0__aoi21_1
XFILLER_66_613 VDD VDD VSS VSS gf180mcu_fd_sc_mcu7t5v0__fillcap_4
X_2161_ _2161_/A1 _2171_/B _2162_/A2 VDD VDD VSS VSS gf180mcu_fd_sc_mcu7t5v0__nand2_1
XFILLER_47_860 VDD VDD VSS VSS gf180mcu_fd_sc_mcu7t5v0__fillcap_4
XFILLER_66_679 VDD VDD VSS VSS gf180mcu_fd_sc_mcu7t5v0__fill_2
X_2092_ _2092_/I _2092_/ZN VDD VDD VSS VSS gf180mcu_fd_sc_mcu7t5v0__clkinv_1
X_1112_ _1063_/I _2140_/B _1119_/B2 VDD VDD VSS VSS gf180mcu_fd_sc_mcu7t5v0__nor2_1
XTAP_TAPCELL_ROW_49_844 VDD VSS gf180mcu_fd_sc_mcu7t5v0__filltie
XFILLER_0_52 VDD VDD VSS VSS gf180mcu_fd_sc_mcu7t5v0__fillcap_8
XFILLER_19_562 VDD VDD VSS VSS gf180mcu_fd_sc_mcu7t5v0__fillcap_64
XFILLER_93_487 VDD VDD VSS VSS gf180mcu_fd_sc_mcu7t5v0__fill_2
XFILLER_81_627 VDD VDD VSS VSS gf180mcu_fd_sc_mcu7t5v0__fill_2
XFILLER_34_543 VDD VDD VSS VSS gf180mcu_fd_sc_mcu7t5v0__fillcap_8
XPHY_EDGE_ROW_100_Right_100 VDD VSS gf180mcu_fd_sc_mcu7t5v0__endcap
X_1945_ _1945_/I _1945_/ZN VDD VDD VSS VSS gf180mcu_fd_sc_mcu7t5v0__clkinv_1
X_1876_ _1876_/A1 _1900_/A2 _1900_/B1 _1876_/B2 _1877_/I VDD VDD VSS VSS gf180mcu_fd_sc_mcu7t5v0__aoi22_1
XFILLER_116_865 VDD VDD VSS VSS gf180mcu_fd_sc_mcu7t5v0__fill_1
XFILLER_0_119 VDD VDD VSS VSS gf180mcu_fd_sc_mcu7t5v0__fill_1
XFILLER_103_559 VDD VDD VSS VSS gf180mcu_fd_sc_mcu7t5v0__fill_1
X_2428_ _2429_/A1 _2429_/A2 _2430_/A2 VDD VDD VSS VSS gf180mcu_fd_sc_mcu7t5v0__nand2_1
X_2359_ _2359_/A1 _2363_/A2 _2363_/A3 _2360_/A2 VDD VDD VSS VSS gf180mcu_fd_sc_mcu7t5v0__nand3_1
Xload_slew1108 _1619_/S _1600_/S VDD VDD VSS VSS gf180mcu_fd_sc_mcu7t5v0__buf_4
XFILLER_84_454 VDD VDD VSS VSS gf180mcu_fd_sc_mcu7t5v0__fill_1
XFILLER_44_329 VDD VDD VSS VSS gf180mcu_fd_sc_mcu7t5v0__fillcap_32
XFILLER_56_189 VDD VDD VSS VSS gf180mcu_fd_sc_mcu7t5v0__fill_2
XFILLER_44_25 VDD VDD VSS VSS gf180mcu_fd_sc_mcu7t5v0__fillcap_8
XFILLER_52_351 VDD VDD VSS VSS gf180mcu_fd_sc_mcu7t5v0__fillcap_4
XFILLER_52_384 VDD VDD VSS VSS gf180mcu_fd_sc_mcu7t5v0__fill_1
XFILLER_48_624 VDD VDD VSS VSS gf180mcu_fd_sc_mcu7t5v0__fillcap_8
XTAP_TAPCELL_ROW_89_1322 VDD VSS gf180mcu_fd_sc_mcu7t5v0__filltie
XTAP_TAPCELL_ROW_46_814 VDD VSS gf180mcu_fd_sc_mcu7t5v0__filltie
XTAP_TAPCELL_ROW_46_803 VDD VSS gf180mcu_fd_sc_mcu7t5v0__filltie
XFILLER_16_521 VDD VDD VSS VSS gf180mcu_fd_sc_mcu7t5v0__fillcap_4
XFILLER_28_381 VDD VDD VSS VSS gf180mcu_fd_sc_mcu7t5v0__fillcap_4
XFILLER_90_457 VDD VDD VSS VSS gf180mcu_fd_sc_mcu7t5v0__fill_2
XTAP_TAPCELL_ROW_26_571 VDD VSS gf180mcu_fd_sc_mcu7t5v0__filltie
XFILLER_71_693 VDD VDD VSS VSS gf180mcu_fd_sc_mcu7t5v0__fillcap_4
X_1730_ _1920_/A1 _1768_/A2 _1762_/B1 _1920_/B2 _1731_/I VDD VDD VSS VSS gf180mcu_fd_sc_mcu7t5v0__aoi22_1
X_1661_ _1874_/B2 _1579_/Z _1662_/S _1661_/Z VDD VDD VSS VSS gf180mcu_fd_sc_mcu7t5v0__mux2_2
X_1592_ _1590_/Z _1591_/Z _1592_/Z VDD VDD VSS VSS gf180mcu_fd_sc_mcu7t5v0__xor2_1
XFILLER_98_524 VDD VDD VSS VSS gf180mcu_fd_sc_mcu7t5v0__fill_1
XFILLER_98_535 VDD VDD VSS VSS gf180mcu_fd_sc_mcu7t5v0__fillcap_4
XFILLER_22_2 VDD VDD VSS VSS gf180mcu_fd_sc_mcu7t5v0__fill_2
X_2213_ _2586_/Q _2140_/B _2214_/A3 VDD VDD VSS VSS gf180mcu_fd_sc_mcu7t5v0__nand2_1
XFILLER_66_454 VDD VDD VSS VSS gf180mcu_fd_sc_mcu7t5v0__fill_1
X_2144_ _2144_/A1 _2171_/B _2147_/A1 VDD VDD VSS VSS gf180mcu_fd_sc_mcu7t5v0__nand2_1
XFILLER_93_251 VDD VDD VSS VSS gf180mcu_fd_sc_mcu7t5v0__fill_1
XFILLER_19_370 VDD VDD VSS VSS gf180mcu_fd_sc_mcu7t5v0__fillcap_32
XFILLER_38_189 VDD VDD VSS VSS gf180mcu_fd_sc_mcu7t5v0__fill_1
X_2075_ _2105_/A1 _2075_/A2 _2075_/ZN VDD VDD VSS VSS gf180mcu_fd_sc_mcu7t5v0__nand2_1
XTAP_TAPCELL_ROW_62_1005 VDD VSS gf180mcu_fd_sc_mcu7t5v0__filltie
X_1928_ _1928_/A1 _1964_/A2 _1930_/B1 _1928_/B2 _1929_/I VDD VDD VSS VSS gf180mcu_fd_sc_mcu7t5v0__aoi22_1
X_1859_ _1859_/I _1859_/ZN VDD VDD VSS VSS gf180mcu_fd_sc_mcu7t5v0__clkinv_1
XFILLER_103_323 VDD VDD VSS VSS gf180mcu_fd_sc_mcu7t5v0__fill_1
XFILLER_1_428 VDD VDD VSS VSS gf180mcu_fd_sc_mcu7t5v0__fillcap_16
XTAP_TAPCELL_ROW_73_1134 VDD VSS gf180mcu_fd_sc_mcu7t5v0__filltie
XFILLER_39_36 VDD VDD VSS VSS gf180mcu_fd_sc_mcu7t5v0__fill_1
XFILLER_39_69 VDD VDD VSS VSS gf180mcu_fd_sc_mcu7t5v0__fill_1
XFILLER_84_240 VDD VDD VSS VSS gf180mcu_fd_sc_mcu7t5v0__fillcap_4
XTAP_TAPCELL_ROW_4_299 VDD VSS gf180mcu_fd_sc_mcu7t5v0__filltie
XFILLER_84_295 VDD VDD VSS VSS gf180mcu_fd_sc_mcu7t5v0__fillcap_8
XFILLER_72_457 VDD VDD VSS VSS gf180mcu_fd_sc_mcu7t5v0__fillcap_4
XFILLER_25_384 VDD VDD VSS VSS gf180mcu_fd_sc_mcu7t5v0__fillcap_4
XTAP_TAPCELL_ROW_84_1263 VDD VSS gf180mcu_fd_sc_mcu7t5v0__filltie
XTAP_TAPCELL_ROW_23_530 VDD VSS gf180mcu_fd_sc_mcu7t5v0__filltie
XTAP_TAPCELL_ROW_51_872 VDD VSS gf180mcu_fd_sc_mcu7t5v0__filltie
XTAP_TAPCELL_ROW_95_1392 VDD VSS gf180mcu_fd_sc_mcu7t5v0__filltie
XFILLER_48_454 VDD VDD VSS VSS gf180mcu_fd_sc_mcu7t5v0__fill_1
Xinput340 tl_h_d_i[64] _2723_/I VDD VDD VSS VSS gf180mcu_fd_sc_mcu7t5v0__clkbuf_2
Xinput351 tl_h_d_i[74] _2733_/I VDD VDD VSS VSS gf180mcu_fd_sc_mcu7t5v0__clkbuf_2
Xinput362 tl_h_d_i[84] _2743_/I VDD VDD VSS VSS gf180mcu_fd_sc_mcu7t5v0__clkbuf_2
XFILLER_48_476 VDD VDD VSS VSS gf180mcu_fd_sc_mcu7t5v0__fill_1
Xinput373 tl_h_d_i[94] _2753_/I VDD VDD VSS VSS gf180mcu_fd_sc_mcu7t5v0__clkbuf_2
Xinput384 tl_h_i_i[103] _2401_/I0 VDD VDD VSS VSS gf180mcu_fd_sc_mcu7t5v0__dlyd_1
Xinput395 tl_h_i_i[113] _1071_/I VDD VDD VSS VSS gf180mcu_fd_sc_mcu7t5v0__dlyd_1
XTAP_TAPCELL_ROW_59_961 VDD VSS gf180mcu_fd_sc_mcu7t5v0__filltie
XFILLER_17_863 VDD VDD VSS VSS gf180mcu_fd_sc_mcu7t5v0__fill_2
X_2762_ _2762_/I _2762_/Z VDD VDD VSS VSS gf180mcu_fd_sc_mcu7t5v0__buf_1
X_1713_ _1713_/I _1713_/ZN VDD VDD VSS VSS gf180mcu_fd_sc_mcu7t5v0__clkinv_1
X_2693_ _2765_/I _2693_/Z VDD VDD VSS VSS gf180mcu_fd_sc_mcu7t5v0__buf_1
Xoutput803 _1829_/ZN tl_d_rom_o[99] VDD VDD VSS VSS gf180mcu_fd_sc_mcu7t5v0__dlyd_1
Xoutput836 _2716_/Z tl_d_uart_o[25] VDD VDD VSS VSS gf180mcu_fd_sc_mcu7t5v0__dlyd_1
Xoutput825 _2706_/Z tl_d_uart_o[15] VDD VDD VSS VSS gf180mcu_fd_sc_mcu7t5v0__dlyd_1
Xoutput814 _2767_/Z tl_d_uart_o[108] VDD VDD VSS VSS gf180mcu_fd_sc_mcu7t5v0__dlyd_1
X_1644_ _1960_/B2 _1651_/A2 _1644_/Z VDD VDD VSS VSS gf180mcu_fd_sc_mcu7t5v0__or2_1
Xoutput869 _1646_/Z tl_d_uart_o[55] VDD VDD VSS VSS gf180mcu_fd_sc_mcu7t5v0__dlyd_1
Xoutput858 _1636_/Z tl_d_uart_o[45] VDD VDD VSS VSS gf180mcu_fd_sc_mcu7t5v0__dlyd_1
Xoutput847 _1626_/Z tl_d_uart_o[35] VDD VDD VSS VSS gf180mcu_fd_sc_mcu7t5v0__dlyd_1
X_1575_ _2725_/I _2707_/I _2732_/I _1575_/Z VDD VDD VSS VSS gf180mcu_fd_sc_mcu7t5v0__xor3_1
XFILLER_98_387 VDD VDD VSS VSS gf180mcu_fd_sc_mcu7t5v0__fillcap_32
XFILLER_86_527 VDD VDD VSS VSS gf180mcu_fd_sc_mcu7t5v0__fillcap_16
XFILLER_54_402 VDD VDD VSS VSS gf180mcu_fd_sc_mcu7t5v0__fillcap_16
XFILLER_54_435 VDD VDD VSS VSS gf180mcu_fd_sc_mcu7t5v0__fillcap_4
X_2127_ input57/Z _2154_/A2 _2128_/C VDD VDD VSS VSS gf180mcu_fd_sc_mcu7t5v0__nor2_1
XTAP_TAPCELL_ROW_107_1539 VDD VSS gf180mcu_fd_sc_mcu7t5v0__filltie
XFILLER_81_221 VDD VDD VSS VSS gf180mcu_fd_sc_mcu7t5v0__fillcap_4
XFILLER_54_457 VDD VDD VSS VSS gf180mcu_fd_sc_mcu7t5v0__fillcap_16
X_2058_ _2133_/B2 _2064_/B _2102_/B2 _2133_/A1 _2059_/I VDD VDD VSS VSS gf180mcu_fd_sc_mcu7t5v0__oai22_1
XTAP_TAPCELL_ROW_1_269 VDD VSS gf180mcu_fd_sc_mcu7t5v0__filltie
XTAP_TAPCELL_ROW_37_699 VDD VSS gf180mcu_fd_sc_mcu7t5v0__filltie
XFILLER_81_276 VDD VDD VSS VSS gf180mcu_fd_sc_mcu7t5v0__fillcap_4
XFILLER_22_365 VDD VDD VSS VSS gf180mcu_fd_sc_mcu7t5v0__fillcap_16
XFILLER_10_527 VDD VDD VSS VSS gf180mcu_fd_sc_mcu7t5v0__fillcap_32
XFILLER_22_387 VDD VDD VSS VSS gf180mcu_fd_sc_mcu7t5v0__fillcap_16
XTAP_TAPCELL_ROW_20_500 VDD VSS gf180mcu_fd_sc_mcu7t5v0__filltie
XTAP_TAPCELL_ROW_118_1679 VDD VSS gf180mcu_fd_sc_mcu7t5v0__filltie
XTAP_TAPCELL_ROW_118_1668 VDD VSS gf180mcu_fd_sc_mcu7t5v0__filltie
XTAP_TAPCELL_ROW_9_369 VDD VSS gf180mcu_fd_sc_mcu7t5v0__filltie
XFILLER_106_74 VDD VDD VSS VSS gf180mcu_fd_sc_mcu7t5v0__fillcap_16
XFILLER_66_34 VDD VDD VSS VSS gf180mcu_fd_sc_mcu7t5v0__fill_1
XFILLER_45_446 VDD VDD VSS VSS gf180mcu_fd_sc_mcu7t5v0__fill_2
XTAP_TAPCELL_ROW_56_931 VDD VSS gf180mcu_fd_sc_mcu7t5v0__filltie
XFILLER_73_766 VDD VDD VSS VSS gf180mcu_fd_sc_mcu7t5v0__fillcap_4
XFILLER_9_347 VDD VDD VSS VSS gf180mcu_fd_sc_mcu7t5v0__fill_2
XTAP_TAPCELL_ROW_97_1421 VDD VSS gf180mcu_fd_sc_mcu7t5v0__filltie
XFILLER_107_481 VDD VDD VSS VSS gf180mcu_fd_sc_mcu7t5v0__fillcap_4
X_1360_ _1360_/A1 _1496_/A2 _2305_/A2 VDD VDD VSS VSS gf180mcu_fd_sc_mcu7t5v0__nand2_1
XFILLER_68_527 VDD VDD VSS VSS gf180mcu_fd_sc_mcu7t5v0__fillcap_4
X_1291_ _1339_/A1 _1289_/Z _1291_/B _1292_/B1 VDD VDD VSS VSS gf180mcu_fd_sc_mcu7t5v0__oai21_1
XFILLER_48_251 VDD VDD VSS VSS gf180mcu_fd_sc_mcu7t5v0__fill_2
Xinput170 tl_d_rom_i[42] _1464_/A1 VDD VDD VSS VSS gf180mcu_fd_sc_mcu7t5v0__dlyd_1
Xinput181 tl_d_rom_i[52] _2193_/A1 VDD VDD VSS VSS gf180mcu_fd_sc_mcu7t5v0__dlyd_1
XFILLER_64_733 VDD VDD VSS VSS gf180mcu_fd_sc_mcu7t5v0__fill_2
Xinput192 tl_d_rom_i[62] _1063_/I VDD VDD VSS VSS gf180mcu_fd_sc_mcu7t5v0__dlyd_1
XFILLER_91_530 VDD VDD VSS VSS gf180mcu_fd_sc_mcu7t5v0__fillcap_16
XTAP_TAPCELL_ROW_34_669 VDD VSS gf180mcu_fd_sc_mcu7t5v0__filltie
XFILLER_118_713 VDD VDD VSS VSS gf180mcu_fd_sc_mcu7t5v0__fill_1
X_2745_ _2745_/I _2745_/Z VDD VDD VSS VSS gf180mcu_fd_sc_mcu7t5v0__buf_1
X_2676_ _2748_/I _2676_/Z VDD VDD VSS VSS gf180mcu_fd_sc_mcu7t5v0__buf_1
Xoutput600 _2680_/Z tl_d_dmem_o[93] VDD VDD VSS VSS gf180mcu_fd_sc_mcu7t5v0__dlyd_1
Xoutput611 _2025_/ZN tl_d_esram_o[102] VDD VDD VSS VSS gf180mcu_fd_sc_mcu7t5v0__dlyd_1
Xoutput622 _2045_/ZN tl_d_esram_o[112] VDD VDD VSS VSS gf180mcu_fd_sc_mcu7t5v0__dlyd_1
Xoutput633 _1857_/ZN tl_d_esram_o[1] VDD VDD VSS VSS gf180mcu_fd_sc_mcu7t5v0__dlyd_1
Xoutput644 _1859_/ZN tl_d_esram_o[2] VDD VDD VSS VSS gf180mcu_fd_sc_mcu7t5v0__dlyd_1
X_1627_ _1926_/B2 _1641_/A2 _1627_/Z VDD VDD VSS VSS gf180mcu_fd_sc_mcu7t5v0__or2_1
Xoutput655 _1861_/ZN tl_d_esram_o[3] VDD VDD VSS VSS gf180mcu_fd_sc_mcu7t5v0__dlyd_1
Xoutput688 _1867_/ZN tl_d_esram_o[6] VDD VDD VSS VSS gf180mcu_fd_sc_mcu7t5v0__dlyd_1
Xoutput677 _1865_/ZN tl_d_esram_o[5] VDD VDD VSS VSS gf180mcu_fd_sc_mcu7t5v0__dlyd_1
Xoutput666 _1863_/ZN tl_d_esram_o[4] VDD VDD VSS VSS gf180mcu_fd_sc_mcu7t5v0__dlyd_1
XFILLER_101_613 VDD VDD VSS VSS gf180mcu_fd_sc_mcu7t5v0__fill_2
Xclkbuf_3_7__f_clk_i clkbuf_0_clk_i/Z clkload6/I VDD VDD VSS VSS gf180mcu_fd_sc_mcu7t5v0__clkbuf_16
Xoutput699 _1869_/ZN tl_d_esram_o[7] VDD VDD VSS VSS gf180mcu_fd_sc_mcu7t5v0__dlyd_1
X_1558_ _1553_/Z _1555_/Z _1557_/Z _1558_/Z VDD VDD VSS VSS gf180mcu_fd_sc_mcu7t5v0__xor3_1
XTAP_TAPCELL_ROW_6_328 VDD VSS gf180mcu_fd_sc_mcu7t5v0__filltie
X_1489_ _1489_/A1 _2369_/A2 _1489_/Z VDD VDD VSS VSS gf180mcu_fd_sc_mcu7t5v0__and2_1
XFILLER_87_858 VDD VDD VSS VSS gf180mcu_fd_sc_mcu7t5v0__fillcap_8
XFILLER_27_402 VDD VDD VSS VSS gf180mcu_fd_sc_mcu7t5v0__fillcap_8
XFILLER_74_508 VDD VDD VSS VSS gf180mcu_fd_sc_mcu7t5v0__fillcap_16
XFILLER_54_243 VDD VDD VSS VSS gf180mcu_fd_sc_mcu7t5v0__fill_2
XFILLER_55_766 VDD VDD VSS VSS gf180mcu_fd_sc_mcu7t5v0__fillcap_4
XTAP_TAPCELL_ROW_68_1077 VDD VSS gf180mcu_fd_sc_mcu7t5v0__filltie
XFILLER_82_585 VDD VDD VSS VSS gf180mcu_fd_sc_mcu7t5v0__fillcap_8
XFILLER_42_449 VDD VDD VSS VSS gf180mcu_fd_sc_mcu7t5v0__fillcap_4
XTAP_TAPCELL_ROW_81_1233 VDD VSS gf180mcu_fd_sc_mcu7t5v0__filltie
XFILLER_23_696 VDD VDD VSS VSS gf180mcu_fd_sc_mcu7t5v0__fillcap_4
XFILLER_50_493 VDD VDD VSS VSS gf180mcu_fd_sc_mcu7t5v0__fill_1
XFILLER_22_195 VDD VDD VSS VSS gf180mcu_fd_sc_mcu7t5v0__fill_1
XTAP_TAPCELL_ROW_92_1362 VDD VSS gf180mcu_fd_sc_mcu7t5v0__filltie
XFILLER_104_473 VDD VDD VSS VSS gf180mcu_fd_sc_mcu7t5v0__fillcap_4
XFILLER_77_368 VDD VDD VSS VSS gf180mcu_fd_sc_mcu7t5v0__fill_2
XFILLER_58_593 VDD VDD VSS VSS gf180mcu_fd_sc_mcu7t5v0__fill_2
XFILLER_18_457 VDD VDD VSS VSS gf180mcu_fd_sc_mcu7t5v0__fillcap_64
XFILLER_73_585 VDD VDD VSS VSS gf180mcu_fd_sc_mcu7t5v0__fillcap_32
XTAP_TAPCELL_ROW_31_628 VDD VSS gf180mcu_fd_sc_mcu7t5v0__filltie
X_2530_ _2597_/Q _2530_/A2 _2597_/D VDD VDD VSS VSS gf180mcu_fd_sc_mcu7t5v0__xor2_1
XTAP_TAPCELL_ROW_11_385 VDD VSS gf180mcu_fd_sc_mcu7t5v0__filltie
X_2461_ _2708_/I _2573_/Q _2462_/S _2573_/D VDD VDD VSS VSS gf180mcu_fd_sc_mcu7t5v0__mux2_2
X_1412_ input30/Z _1468_/A2 _1412_/B1 _2160_/A2 _1413_/I VDD VDD VSS VSS gf180mcu_fd_sc_mcu7t5v0__aoi22_1
X_2392_ _2392_/A1 _2403_/A1 _2397_/S _2548_/D VDD VDD VSS VSS gf180mcu_fd_sc_mcu7t5v0__oai21_1
X_1343_ _1399_/A1 _1343_/A2 _1343_/ZN VDD VDD VSS VSS gf180mcu_fd_sc_mcu7t5v0__nor2_1
XFILLER_69_858 VDD VDD VSS VSS gf180mcu_fd_sc_mcu7t5v0__fillcap_8
X_1274_ input77/Z _2116_/B1 _2259_/A3 _1275_/B VDD VDD VSS VSS gf180mcu_fd_sc_mcu7t5v0__nand3_1
XTAP_TAPCELL_ROW_39_728 VDD VSS gf180mcu_fd_sc_mcu7t5v0__filltie
XFILLER_37_766 VDD VDD VSS VSS gf180mcu_fd_sc_mcu7t5v0__fillcap_4
XFILLER_64_563 VDD VDD VSS VSS gf180mcu_fd_sc_mcu7t5v0__fillcap_4
XTAP_TAPCELL_ROW_104_1509 VDD VSS gf180mcu_fd_sc_mcu7t5v0__filltie
XFILLER_91_360 VDD VDD VSS VSS gf180mcu_fd_sc_mcu7t5v0__fillcap_4
XFILLER_52_769 VDD VDD VSS VSS gf180mcu_fd_sc_mcu7t5v0__fill_2
XTAP_TAPCELL_ROW_19_485 VDD VSS gf180mcu_fd_sc_mcu7t5v0__filltie
XFILLER_51_279 VDD VDD VSS VSS gf180mcu_fd_sc_mcu7t5v0__fill_1
XFILLER_118_543 VDD VDD VSS VSS gf180mcu_fd_sc_mcu7t5v0__fill_1
XFILLER_118_565 VDD VDD VSS VSS gf180mcu_fd_sc_mcu7t5v0__fill_1
X_2728_ _2728_/I _2728_/Z VDD VDD VSS VSS gf180mcu_fd_sc_mcu7t5v0__buf_1
XTAP_TAPCELL_ROW_115_1638 VDD VSS gf180mcu_fd_sc_mcu7t5v0__filltie
X_2659_ _2731_/I _2659_/Z VDD VDD VSS VSS gf180mcu_fd_sc_mcu7t5v0__buf_1
Xoutput496 _2688_/Z tl_d_dmem_o[101] VDD VDD VSS VSS gf180mcu_fd_sc_mcu7t5v0__dlyd_1
XFILLER_59_335 VDD VDD VSS VSS gf180mcu_fd_sc_mcu7t5v0__fillcap_4
Xwire1205 wire1205/I _2375_/A3 VDD VDD VSS VSS gf180mcu_fd_sc_mcu7t5v0__clkbuf_4
XFILLER_87_677 VDD VDD VSS VSS gf180mcu_fd_sc_mcu7t5v0__fillcap_16
XPHY_EDGE_ROW_114_Right_114 VDD VSS gf180mcu_fd_sc_mcu7t5v0__endcap
XFILLER_15_416 VDD VDD VSS VSS gf180mcu_fd_sc_mcu7t5v0__fillcap_4
XFILLER_27_276 VDD VDD VSS VSS gf180mcu_fd_sc_mcu7t5v0__fillcap_4
XFILLER_70_533 VDD VDD VSS VSS gf180mcu_fd_sc_mcu7t5v0__fill_1
XFILLER_70_577 VDD VDD VSS VSS gf180mcu_fd_sc_mcu7t5v0__fillcap_16
XFILLER_11_699 VDD VDD VSS VSS gf180mcu_fd_sc_mcu7t5v0__fill_1
XFILLER_77_121 VDD VDD VSS VSS gf180mcu_fd_sc_mcu7t5v0__fillcap_8
XFILLER_19_8 VDD VDD VSS VSS gf180mcu_fd_sc_mcu7t5v0__fill_1
XFILLER_93_636 VDD VDD VSS VSS gf180mcu_fd_sc_mcu7t5v0__fill_2
XFILLER_78_699 VDD VDD VSS VSS gf180mcu_fd_sc_mcu7t5v0__fillcap_16
XFILLER_19_766 VDD VDD VSS VSS gf180mcu_fd_sc_mcu7t5v0__fillcap_4
XFILLER_65_349 VDD VDD VSS VSS gf180mcu_fd_sc_mcu7t5v0__fill_1
XFILLER_21_419 VDD VDD VSS VSS gf180mcu_fd_sc_mcu7t5v0__fill_1
XFILLER_33_279 VDD VDD VSS VSS gf180mcu_fd_sc_mcu7t5v0__fill_1
XFILLER_61_566 VDD VDD VSS VSS gf180mcu_fd_sc_mcu7t5v0__fill_1
XTAP_TAPCELL_ROW_16_444 VDD VSS gf180mcu_fd_sc_mcu7t5v0__filltie
X_1961_ _1961_/I _1961_/ZN VDD VDD VSS VSS gf180mcu_fd_sc_mcu7t5v0__clkinv_1
XTAP_TAPCELL_ROW_44_786 VDD VSS gf180mcu_fd_sc_mcu7t5v0__filltie
X_1892_ _1892_/A1 _1914_/A2 _1914_/B1 _2710_/I _1893_/I VDD VDD VSS VSS gf180mcu_fd_sc_mcu7t5v0__aoi22_1
XFILLER_52_2 VDD VDD VSS VSS gf180mcu_fd_sc_mcu7t5v0__fillcap_16
X_2513_ _2513_/A1 _2512_/Z _2513_/Z VDD VDD VSS VSS gf180mcu_fd_sc_mcu7t5v0__xor2_1
X_2444_ _2451_/B _2445_/B _2442_/Z _2444_/B _2565_/D VDD VDD VSS VSS gf180mcu_fd_sc_mcu7t5v0__oai31_1
XFILLER_88_419 VDD VDD VSS VSS gf180mcu_fd_sc_mcu7t5v0__fillcap_16
X_2375_ _2375_/A1 _2375_/A2 _2375_/A3 _2376_/A2 VDD VDD VSS VSS gf180mcu_fd_sc_mcu7t5v0__nand3_1
X_1326_ _1326_/A1 _1398_/A2 _1326_/B1 _1390_/B2 _1327_/A2 VDD VDD VSS VSS gf180mcu_fd_sc_mcu7t5v0__aoi22_1
XTAP_TAPCELL_ROW_110_1579 VDD VSS gf180mcu_fd_sc_mcu7t5v0__filltie
X_1257_ _1257_/A1 _1257_/A2 _1257_/A3 _1257_/ZN VDD VDD VSS VSS gf180mcu_fd_sc_mcu7t5v0__nor3_1
X_1188_ _1076_/I _1221_/A2 _1188_/A3 _1226_/A1 VDD VDD VSS VSS gf180mcu_fd_sc_mcu7t5v0__nand3_1
XFILLER_24_224 VDD VDD VSS VSS gf180mcu_fd_sc_mcu7t5v0__fillcap_4
XFILLER_64_393 VDD VDD VSS VSS gf180mcu_fd_sc_mcu7t5v0__fillcap_32
XTAP_TAPCELL_ROW_65_1036 VDD VSS gf180mcu_fd_sc_mcu7t5v0__filltie
XFILLER_80_831 VDD VDD VSS VSS gf180mcu_fd_sc_mcu7t5v0__fill_1
XFILLER_118_373 VDD VDD VSS VSS gf180mcu_fd_sc_mcu7t5v0__fill_1
XTAP_TAPCELL_ROW_76_1165 VDD VSS gf180mcu_fd_sc_mcu7t5v0__filltie
XFILLER_87_430 VDD VDD VSS VSS gf180mcu_fd_sc_mcu7t5v0__fill_2
XFILLER_87_485 VDD VDD VSS VSS gf180mcu_fd_sc_mcu7t5v0__fillcap_4
XFILLER_75_647 VDD VDD VSS VSS gf180mcu_fd_sc_mcu7t5v0__fillcap_32
XFILLER_74_146 VDD VDD VSS VSS gf180mcu_fd_sc_mcu7t5v0__fillcap_4
XFILLER_83_680 VDD VDD VSS VSS gf180mcu_fd_sc_mcu7t5v0__fillcap_4
XFILLER_71_842 VDD VDD VSS VSS gf180mcu_fd_sc_mcu7t5v0__fillcap_16
XFILLER_15_246 VDD VDD VSS VSS gf180mcu_fd_sc_mcu7t5v0__fillcap_32
XFILLER_16_769 VDD VDD VSS VSS gf180mcu_fd_sc_mcu7t5v0__fill_2
XFILLER_70_341 VDD VDD VSS VSS gf180mcu_fd_sc_mcu7t5v0__fillcap_4
XFILLER_30_216 VDD VDD VSS VSS gf180mcu_fd_sc_mcu7t5v0__fillcap_8
XTAP_TAPCELL_ROW_13_414 VDD VSS gf180mcu_fd_sc_mcu7t5v0__filltie
XTAP_TAPCELL_ROW_41_745 VDD VSS gf180mcu_fd_sc_mcu7t5v0__filltie
X_2160_ input5/Z _2160_/A2 _2160_/B _2160_/C _2162_/A1 VDD VDD VSS VSS gf180mcu_fd_sc_mcu7t5v0__oai211_1
XFILLER_93_422 VDD VDD VSS VSS gf180mcu_fd_sc_mcu7t5v0__fill_1
X_2091_ _1066_/I _2554_/Q _2202_/A1 _2375_/A2 _2373_/A1 _2199_/A1 _2092_/I VDD VDD
+ VSS VSS gf180mcu_fd_sc_mcu7t5v0__aoi222_1
X_1111_ _2569_/Q _2153_/A2 _2140_/B VDD VDD VSS VSS gf180mcu_fd_sc_mcu7t5v0__or2_1
XTAP_TAPCELL_ROW_49_845 VDD VSS gf180mcu_fd_sc_mcu7t5v0__filltie
XFILLER_81_606 VDD VDD VSS VSS gf180mcu_fd_sc_mcu7t5v0__fillcap_8
XFILLER_46_393 VDD VDD VSS VSS gf180mcu_fd_sc_mcu7t5v0__fill_1
XFILLER_62_831 VDD VDD VSS VSS gf180mcu_fd_sc_mcu7t5v0__fill_1
XFILLER_61_330 VDD VDD VSS VSS gf180mcu_fd_sc_mcu7t5v0__fill_2
XFILLER_61_352 VDD VDD VSS VSS gf180mcu_fd_sc_mcu7t5v0__fill_1
XFILLER_21_216 VDD VDD VSS VSS gf180mcu_fd_sc_mcu7t5v0__fillcap_4
XFILLER_34_588 VDD VDD VSS VSS gf180mcu_fd_sc_mcu7t5v0__fillcap_4
X_1944_ _1944_/A1 _1964_/A2 _1958_/B1 _1944_/B2 _1945_/I VDD VDD VSS VSS gf180mcu_fd_sc_mcu7t5v0__aoi22_1
X_1875_ _1875_/I _1875_/ZN VDD VDD VSS VSS gf180mcu_fd_sc_mcu7t5v0__clkinv_1
X_2427_ _2439_/A2 _2434_/B _2429_/B VDD VDD VSS VSS gf180mcu_fd_sc_mcu7t5v0__xor2_1
XFILLER_88_238 VDD VDD VSS VSS gf180mcu_fd_sc_mcu7t5v0__fillcap_4
XFILLER_57_603 VDD VDD VSS VSS gf180mcu_fd_sc_mcu7t5v0__fillcap_16
X_2358_ _2358_/A1 _2358_/A2 _2360_/A1 VDD VDD VSS VSS gf180mcu_fd_sc_mcu7t5v0__nand2_1
XFILLER_69_496 VDD VDD VSS VSS gf180mcu_fd_sc_mcu7t5v0__fill_1
XFILLER_29_349 VDD VDD VSS VSS gf180mcu_fd_sc_mcu7t5v0__fill_1
Xload_slew1109 fanout1107/Z _1619_/S VDD VDD VSS VSS gf180mcu_fd_sc_mcu7t5v0__clkbuf_4
X_2289_ _2333_/A1 _2289_/A2 _2290_/A2 VDD VDD VSS VSS gf180mcu_fd_sc_mcu7t5v0__nand2_1
X_1309_ _1309_/I _1310_/B1 VDD VDD VSS VSS gf180mcu_fd_sc_mcu7t5v0__clkinv_1
XFILLER_84_444 VDD VDD VSS VSS gf180mcu_fd_sc_mcu7t5v0__fillcap_8
XFILLER_37_360 VDD VDD VSS VSS gf180mcu_fd_sc_mcu7t5v0__fill_1
XFILLER_37_371 VDD VDD VSS VSS gf180mcu_fd_sc_mcu7t5v0__fillcap_32
XFILLER_53_842 VDD VDD VSS VSS gf180mcu_fd_sc_mcu7t5v0__fillcap_4
XFILLER_71_138 VDD VDD VSS VSS gf180mcu_fd_sc_mcu7t5v0__fill_2
XFILLER_53_864 VDD VDD VSS VSS gf180mcu_fd_sc_mcu7t5v0__fill_2
XFILLER_0_610 VDD VDD VSS VSS gf180mcu_fd_sc_mcu7t5v0__fill_2
XFILLER_106_387 VDD VDD VSS VSS gf180mcu_fd_sc_mcu7t5v0__fillcap_8
XFILLER_47_135 VDD VDD VSS VSS gf180mcu_fd_sc_mcu7t5v0__fillcap_4
XFILLER_47_146 VDD VDD VSS VSS gf180mcu_fd_sc_mcu7t5v0__fill_1
XTAP_TAPCELL_ROW_89_1323 VDD VSS gf180mcu_fd_sc_mcu7t5v0__filltie
XFILLER_63_617 VDD VDD VSS VSS gf180mcu_fd_sc_mcu7t5v0__fillcap_8
XTAP_TAPCELL_ROW_46_804 VDD VSS gf180mcu_fd_sc_mcu7t5v0__filltie
XFILLER_90_403 VDD VDD VSS VSS gf180mcu_fd_sc_mcu7t5v0__fillcap_8
XFILLER_44_831 VDD VDD VSS VSS gf180mcu_fd_sc_mcu7t5v0__fill_1
XFILLER_43_352 VDD VDD VSS VSS gf180mcu_fd_sc_mcu7t5v0__fillcap_16
XTAP_TAPCELL_ROW_26_572 VDD VSS gf180mcu_fd_sc_mcu7t5v0__filltie
XFILLER_71_672 VDD VDD VSS VSS gf180mcu_fd_sc_mcu7t5v0__fillcap_4
XFILLER_11_282 VDD VDD VSS VSS gf180mcu_fd_sc_mcu7t5v0__fillcap_32
X_1660_ _1872_/B2 _1571_/Z _1662_/S _1660_/Z VDD VDD VSS VSS gf180mcu_fd_sc_mcu7t5v0__mux2_2
X_1591_ _2736_/I _2739_/I _1556_/Z _1591_/Z VDD VDD VSS VSS gf180mcu_fd_sc_mcu7t5v0__xor3_1
XFILLER_66_400 VDD VDD VSS VSS gf180mcu_fd_sc_mcu7t5v0__fillcap_4
X_2212_ _2212_/A1 _2218_/A2 _2214_/A2 VDD VDD VSS VSS gf180mcu_fd_sc_mcu7t5v0__nand2_1
X_2143_ _2143_/A1 _2158_/A2 _2145_/B VDD VDD VSS VSS gf180mcu_fd_sc_mcu7t5v0__nand2_1
XFILLER_93_241 VDD VDD VSS VSS gf180mcu_fd_sc_mcu7t5v0__fill_1
XFILLER_35_842 VDD VDD VSS VSS gf180mcu_fd_sc_mcu7t5v0__fillcap_16
XFILLER_53_138 VDD VDD VSS VSS gf180mcu_fd_sc_mcu7t5v0__fill_2
X_2074_ input72/Z _2291_/A2 _2251_/A3 _2163_/A1 _2075_/A2 VDD VDD VSS VSS gf180mcu_fd_sc_mcu7t5v0__aoi22_1
XTAP_TAPCELL_ROW_109_1570 VDD VSS gf180mcu_fd_sc_mcu7t5v0__filltie
XFILLER_50_801 VDD VDD VSS VSS gf180mcu_fd_sc_mcu7t5v0__fillcap_4
XFILLER_81_469 VDD VDD VSS VSS gf180mcu_fd_sc_mcu7t5v0__fillcap_8
XFILLER_50_823 VDD VDD VSS VSS gf180mcu_fd_sc_mcu7t5v0__fillcap_8
XFILLER_62_683 VDD VDD VSS VSS gf180mcu_fd_sc_mcu7t5v0__fillcap_8
XTAP_TAPCELL_ROW_62_1006 VDD VSS gf180mcu_fd_sc_mcu7t5v0__filltie
X_1927_ _1927_/I _1927_/ZN VDD VDD VSS VSS gf180mcu_fd_sc_mcu7t5v0__clkinv_1
XFILLER_30_28 VDD VDD VSS VSS gf180mcu_fd_sc_mcu7t5v0__fill_1
X_1858_ _1858_/A1 _2534_/A2 _2537_/A2 _1084_/I _1859_/I VDD VDD VSS VSS gf180mcu_fd_sc_mcu7t5v0__aoi22_1
X_1789_ _1789_/I _1789_/ZN VDD VDD VSS VSS gf180mcu_fd_sc_mcu7t5v0__clkinv_1
XTAP_TAPCELL_ROW_73_1135 VDD VSS gf180mcu_fd_sc_mcu7t5v0__filltie
XFILLER_89_558 VDD VDD VSS VSS gf180mcu_fd_sc_mcu7t5v0__fill_2
XFILLER_57_488 VDD VDD VSS VSS gf180mcu_fd_sc_mcu7t5v0__fill_2
XFILLER_26_831 VDD VDD VSS VSS gf180mcu_fd_sc_mcu7t5v0__fill_1
XFILLER_25_330 VDD VDD VSS VSS gf180mcu_fd_sc_mcu7t5v0__fillcap_8
XFILLER_72_469 VDD VDD VSS VSS gf180mcu_fd_sc_mcu7t5v0__fillcap_8
XTAP_TAPCELL_ROW_84_1264 VDD VSS gf180mcu_fd_sc_mcu7t5v0__filltie
XTAP_TAPCELL_ROW_23_531 VDD VSS gf180mcu_fd_sc_mcu7t5v0__filltie
XTAP_TAPCELL_ROW_51_873 VDD VSS gf180mcu_fd_sc_mcu7t5v0__filltie
XTAP_TAPCELL_ROW_95_1393 VDD VSS gf180mcu_fd_sc_mcu7t5v0__filltie
XFILLER_0_451 VDD VDD VSS VSS gf180mcu_fd_sc_mcu7t5v0__fillcap_16
Xinput330 tl_h_d_i[55] _1964_/B2 VDD VDD VSS VSS gf180mcu_fd_sc_mcu7t5v0__dlyd_1
XFILLER_95_528 VDD VDD VSS VSS gf180mcu_fd_sc_mcu7t5v0__fill_2
Xinput341 tl_h_d_i[65] _2724_/I VDD VDD VSS VSS gf180mcu_fd_sc_mcu7t5v0__clkbuf_2
Xinput352 tl_h_d_i[75] _2734_/I VDD VDD VSS VSS gf180mcu_fd_sc_mcu7t5v0__clkbuf_2
Xinput363 tl_h_d_i[85] _2744_/I VDD VDD VSS VSS gf180mcu_fd_sc_mcu7t5v0__clkbuf_2
XFILLER_48_466 VDD VDD VSS VSS gf180mcu_fd_sc_mcu7t5v0__fillcap_8
Xinput374 tl_h_d_i[95] _2754_/I VDD VDD VSS VSS gf180mcu_fd_sc_mcu7t5v0__clkbuf_2
Xinput385 tl_h_i_i[104] _2402_/I0 VDD VDD VSS VSS gf180mcu_fd_sc_mcu7t5v0__dlyd_1
Xinput396 tl_h_i_i[11] _1876_/A1 VDD VDD VSS VSS gf180mcu_fd_sc_mcu7t5v0__dlyd_1
XTAP_TAPCELL_ROW_59_962 VDD VSS gf180mcu_fd_sc_mcu7t5v0__filltie
XFILLER_17_842 VDD VDD VSS VSS gf180mcu_fd_sc_mcu7t5v0__fillcap_4
XFILLER_90_244 VDD VDD VSS VSS gf180mcu_fd_sc_mcu7t5v0__fill_1
XFILLER_31_300 VDD VDD VSS VSS gf180mcu_fd_sc_mcu7t5v0__fill_1
XFILLER_32_823 VDD VDD VSS VSS gf180mcu_fd_sc_mcu7t5v0__fillcap_8
XFILLER_12_591 VDD VDD VSS VSS gf180mcu_fd_sc_mcu7t5v0__fillcap_4
XFILLER_31_388 VDD VDD VSS VSS gf180mcu_fd_sc_mcu7t5v0__fillcap_4
X_2761_ _2761_/I _2761_/Z VDD VDD VSS VSS gf180mcu_fd_sc_mcu7t5v0__buf_1
X_2692_ _2764_/I _2692_/Z VDD VDD VSS VSS gf180mcu_fd_sc_mcu7t5v0__buf_1
X_1712_ _1902_/A1 _1732_/A2 _1722_/B1 _2715_/I _1713_/I VDD VDD VSS VSS gf180mcu_fd_sc_mcu7t5v0__aoi22_1
XANTENNA_1 _2710_/I VDD VDD VSS VSS gf180mcu_fd_sc_mcu7t5v0__antenna
X_1643_ _1958_/B2 _1651_/A2 _1643_/Z VDD VDD VSS VSS gf180mcu_fd_sc_mcu7t5v0__or2_1
Xoutput837 _2717_/Z tl_d_uart_o[26] VDD VDD VSS VSS gf180mcu_fd_sc_mcu7t5v0__dlyd_1
Xoutput826 _2707_/Z tl_d_uart_o[16] VDD VDD VSS VSS gf180mcu_fd_sc_mcu7t5v0__dlyd_1
Xoutput815 _2768_/Z tl_d_uart_o[109] VDD VDD VSS VSS gf180mcu_fd_sc_mcu7t5v0__dlyd_1
Xoutput804 _1683_/ZN tl_d_rom_o[9] VDD VDD VSS VSS gf180mcu_fd_sc_mcu7t5v0__dlyd_1
Xoutput859 _1637_/Z tl_d_uart_o[46] VDD VDD VSS VSS gf180mcu_fd_sc_mcu7t5v0__dlyd_1
Xoutput848 _1627_/Z tl_d_uart_o[36] VDD VDD VSS VSS gf180mcu_fd_sc_mcu7t5v0__dlyd_1
X_1574_ _1574_/A1 _1566_/Z _1573_/Z _1574_/Z VDD VDD VSS VSS gf180mcu_fd_sc_mcu7t5v0__xor3_1
XFILLER_98_311 VDD VDD VSS VSS gf180mcu_fd_sc_mcu7t5v0__fillcap_4
XFILLER_98_333 VDD VDD VSS VSS gf180mcu_fd_sc_mcu7t5v0__fillcap_4
XFILLER_100_305 VDD VDD VSS VSS gf180mcu_fd_sc_mcu7t5v0__fill_1
XFILLER_58_208 VDD VDD VSS VSS gf180mcu_fd_sc_mcu7t5v0__fillcap_8
XFILLER_39_422 VDD VDD VSS VSS gf180mcu_fd_sc_mcu7t5v0__fillcap_64
XFILLER_66_241 VDD VDD VSS VSS gf180mcu_fd_sc_mcu7t5v0__fillcap_4
Xfanout1090 _1830_/A2 _1772_/A2 VDD VDD VSS VSS gf180mcu_fd_sc_mcu7t5v0__dlyd_1
X_2126_ _2126_/A1 _2153_/A2 _2142_/B _2126_/B2 _2128_/B2 VDD VDD VSS VSS gf180mcu_fd_sc_mcu7t5v0__oai22_1
XFILLER_82_734 VDD VDD VSS VSS gf180mcu_fd_sc_mcu7t5v0__fill_1
X_2057_ _2057_/I _2057_/ZN VDD VDD VSS VSS gf180mcu_fd_sc_mcu7t5v0__clkinv_1
XFILLER_50_664 VDD VDD VSS VSS gf180mcu_fd_sc_mcu7t5v0__fill_1
XTAP_TAPCELL_ROW_20_501 VDD VSS gf180mcu_fd_sc_mcu7t5v0__filltie
XTAP_TAPCELL_ROW_118_1669 VDD VSS gf180mcu_fd_sc_mcu7t5v0__filltie
XTAP_TAPCELL_ROW_9_359 VDD VSS gf180mcu_fd_sc_mcu7t5v0__filltie
XFILLER_77_528 VDD VDD VSS VSS gf180mcu_fd_sc_mcu7t5v0__fillcap_32
XFILLER_58_731 VDD VDD VSS VSS gf180mcu_fd_sc_mcu7t5v0__fillcap_4
XFILLER_57_263 VDD VDD VSS VSS gf180mcu_fd_sc_mcu7t5v0__fillcap_16
XFILLER_66_79 VDD VDD VSS VSS gf180mcu_fd_sc_mcu7t5v0__fill_2
XFILLER_85_572 VDD VDD VSS VSS gf180mcu_fd_sc_mcu7t5v0__fill_1
XFILLER_57_296 VDD VDD VSS VSS gf180mcu_fd_sc_mcu7t5v0__fill_1
XTAP_TAPCELL_ROW_56_932 VDD VSS gf180mcu_fd_sc_mcu7t5v0__filltie
XFILLER_72_222 VDD VDD VSS VSS gf180mcu_fd_sc_mcu7t5v0__fillcap_16
XFILLER_72_244 VDD VDD VSS VSS gf180mcu_fd_sc_mcu7t5v0__fill_1
XFILLER_14_823 VDD VDD VSS VSS gf180mcu_fd_sc_mcu7t5v0__fillcap_8
XFILLER_26_661 VDD VDD VSS VSS gf180mcu_fd_sc_mcu7t5v0__fillcap_4
XFILLER_13_344 VDD VDD VSS VSS gf180mcu_fd_sc_mcu7t5v0__fillcap_4
XTAP_TAPCELL_ROW_97_1422 VDD VSS gf180mcu_fd_sc_mcu7t5v0__filltie
XFILLER_95_314 VDD VDD VSS VSS gf180mcu_fd_sc_mcu7t5v0__fillcap_16
X_1290_ input80/Z _2116_/B1 _2259_/A3 _1291_/B VDD VDD VSS VSS gf180mcu_fd_sc_mcu7t5v0__nand3_1
XFILLER_48_241 VDD VDD VSS VSS gf180mcu_fd_sc_mcu7t5v0__fillcap_4
Xinput160 tl_d_rom_i[33] _1392_/A1 VDD VDD VSS VSS gf180mcu_fd_sc_mcu7t5v0__dlyd_1
Xinput171 tl_d_rom_i[43] _1472_/A1 VDD VDD VSS VSS gf180mcu_fd_sc_mcu7t5v0__dlyd_1
Xinput182 tl_d_rom_i[53] _2199_/A1 VDD VDD VSS VSS gf180mcu_fd_sc_mcu7t5v0__dlyd_1
Xinput193 tl_d_rom_i[63] _1251_/A2 VDD VDD VSS VSS gf180mcu_fd_sc_mcu7t5v0__dlyd_1
XFILLER_63_244 VDD VDD VSS VSS gf180mcu_fd_sc_mcu7t5v0__fillcap_4
XFILLER_51_406 VDD VDD VSS VSS gf180mcu_fd_sc_mcu7t5v0__fillcap_8
XFILLER_63_277 VDD VDD VSS VSS gf180mcu_fd_sc_mcu7t5v0__fill_2
XTAP_TAPCELL_ROW_34_659 VDD VSS gf180mcu_fd_sc_mcu7t5v0__filltie
XFILLER_118_747 VDD VDD VSS VSS gf180mcu_fd_sc_mcu7t5v0__fill_1
X_2744_ _2744_/I _2744_/Z VDD VDD VSS VSS gf180mcu_fd_sc_mcu7t5v0__buf_1
X_2675_ _2747_/I _2675_/Z VDD VDD VSS VSS gf180mcu_fd_sc_mcu7t5v0__buf_1
Xoutput601 _2681_/Z tl_d_dmem_o[94] VDD VDD VSS VSS gf180mcu_fd_sc_mcu7t5v0__dlyd_1
Xoutput612 _2027_/ZN tl_d_esram_o[103] VDD VDD VSS VSS gf180mcu_fd_sc_mcu7t5v0__dlyd_1
Xoutput623 _2702_/Z tl_d_esram_o[113] VDD VDD VSS VSS gf180mcu_fd_sc_mcu7t5v0__dlyd_1
Xoutput634 _1895_/ZN tl_d_esram_o[20] VDD VDD VSS VSS gf180mcu_fd_sc_mcu7t5v0__dlyd_1
Xoutput645 _1915_/ZN tl_d_esram_o[30] VDD VDD VSS VSS gf180mcu_fd_sc_mcu7t5v0__dlyd_1
X_1626_ _1924_/B2 _1665_/S _1626_/Z VDD VDD VSS VSS gf180mcu_fd_sc_mcu7t5v0__or2_1
XFILLER_113_441 VDD VDD VSS VSS gf180mcu_fd_sc_mcu7t5v0__fill_2
Xoutput656 _1935_/ZN tl_d_esram_o[40] VDD VDD VSS VSS gf180mcu_fd_sc_mcu7t5v0__dlyd_1
Xoutput678 _1975_/ZN tl_d_esram_o[60] VDD VDD VSS VSS gf180mcu_fd_sc_mcu7t5v0__dlyd_1
Xoutput667 _1955_/ZN tl_d_esram_o[50] VDD VDD VSS VSS gf180mcu_fd_sc_mcu7t5v0__dlyd_1
X_1557_ _2723_/I _2722_/I _1556_/Z _1557_/Z VDD VDD VSS VSS gf180mcu_fd_sc_mcu7t5v0__xor3_1
Xoutput689 _1995_/ZN tl_d_esram_o[70] VDD VDD VSS VSS gf180mcu_fd_sc_mcu7t5v0__dlyd_1
XTAP_TAPCELL_ROW_6_329 VDD VSS gf180mcu_fd_sc_mcu7t5v0__filltie
X_1488_ _1488_/A1 _1496_/A2 _2369_/A2 VDD VDD VSS VSS gf180mcu_fd_sc_mcu7t5v0__nand2_1
XFILLER_67_550 VDD VDD VSS VSS gf180mcu_fd_sc_mcu7t5v0__fillcap_8
XFILLER_67_572 VDD VDD VSS VSS gf180mcu_fd_sc_mcu7t5v0__fill_1
XFILLER_67_583 VDD VDD VSS VSS gf180mcu_fd_sc_mcu7t5v0__fillcap_32
X_2109_ _2109_/I _2109_/ZN VDD VDD VSS VSS gf180mcu_fd_sc_mcu7t5v0__clkinv_1
XFILLER_82_553 VDD VDD VSS VSS gf180mcu_fd_sc_mcu7t5v0__fillcap_32
XFILLER_42_406 VDD VDD VSS VSS gf180mcu_fd_sc_mcu7t5v0__fillcap_16
XTAP_TAPCELL_ROW_68_1078 VDD VSS gf180mcu_fd_sc_mcu7t5v0__filltie
XTAP_TAPCELL_ROW_68_1067 VDD VSS gf180mcu_fd_sc_mcu7t5v0__filltie
XFILLER_82_597 VDD VDD VSS VSS gf180mcu_fd_sc_mcu7t5v0__fillcap_16
XFILLER_70_737 VDD VDD VSS VSS gf180mcu_fd_sc_mcu7t5v0__fillcap_64
XFILLER_70_726 VDD VDD VSS VSS gf180mcu_fd_sc_mcu7t5v0__fillcap_8
XTAP_TAPCELL_ROW_81_1234 VDD VSS gf180mcu_fd_sc_mcu7t5v0__filltie
XTAP_TAPCELL_ROW_81_1223 VDD VSS gf180mcu_fd_sc_mcu7t5v0__filltie
XFILLER_50_461 VDD VDD VSS VSS gf180mcu_fd_sc_mcu7t5v0__fill_2
XFILLER_52_26 VDD VDD VSS VSS gf180mcu_fd_sc_mcu7t5v0__fillcap_4
XFILLER_50_483 VDD VDD VSS VSS gf180mcu_fd_sc_mcu7t5v0__fillcap_8
XTAP_TAPCELL_ROW_61_990 VDD VSS gf180mcu_fd_sc_mcu7t5v0__filltie
XFILLER_11_859 VDD VDD VSS VSS gf180mcu_fd_sc_mcu7t5v0__fillcap_4
XTAP_TAPCELL_ROW_92_1363 VDD VSS gf180mcu_fd_sc_mcu7t5v0__filltie
XFILLER_104_452 VDD VDD VSS VSS gf180mcu_fd_sc_mcu7t5v0__fill_2
XFILLER_46_723 VDD VDD VSS VSS gf180mcu_fd_sc_mcu7t5v0__fill_1
XFILLER_46_734 VDD VDD VSS VSS gf180mcu_fd_sc_mcu7t5v0__fill_1
XFILLER_92_317 VDD VDD VSS VSS gf180mcu_fd_sc_mcu7t5v0__fillcap_4
XFILLER_60_247 VDD VDD VSS VSS gf180mcu_fd_sc_mcu7t5v0__fillcap_64
XFILLER_41_494 VDD VDD VSS VSS gf180mcu_fd_sc_mcu7t5v0__fill_1
XTAP_TAPCELL_ROW_31_629 VDD VSS gf180mcu_fd_sc_mcu7t5v0__filltie
XTAP_TAPCELL_ROW_101_1470 VDD VSS gf180mcu_fd_sc_mcu7t5v0__filltie
XTAP_TAPCELL_ROW_11_386 VDD VSS gf180mcu_fd_sc_mcu7t5v0__filltie
X_2460_ _2707_/I _2572_/Q _2462_/S _2572_/D VDD VDD VSS VSS gf180mcu_fd_sc_mcu7t5v0__mux2_2
X_1411_ _1499_/A1 _1409_/Z _1411_/B _1412_/B1 VDD VDD VSS VSS gf180mcu_fd_sc_mcu7t5v0__oai21_1
X_2391_ _2391_/I0 _2547_/Q _2394_/S _2547_/D VDD VDD VSS VSS gf180mcu_fd_sc_mcu7t5v0__mux2_2
XFILLER_69_804 VDD VDD VSS VSS gf180mcu_fd_sc_mcu7t5v0__fill_2
XFILLER_68_314 VDD VDD VSS VSS gf180mcu_fd_sc_mcu7t5v0__fill_1
XFILLER_68_336 VDD VDD VSS VSS gf180mcu_fd_sc_mcu7t5v0__fill_2
X_1342_ _1342_/A1 _1398_/A2 _1342_/B1 _2160_/C _1343_/A2 VDD VDD VSS VSS gf180mcu_fd_sc_mcu7t5v0__aoi22_1
X_1273_ _1393_/A1 _2261_/A2 _1273_/Z VDD VDD VSS VSS gf180mcu_fd_sc_mcu7t5v0__and2_1
XFILLER_84_807 VDD VDD VSS VSS gf180mcu_fd_sc_mcu7t5v0__fillcap_16
XFILLER_83_306 VDD VDD VSS VSS gf180mcu_fd_sc_mcu7t5v0__fillcap_4
XFILLER_64_520 VDD VDD VSS VSS gf180mcu_fd_sc_mcu7t5v0__fillcap_4
XTAP_TAPCELL_ROW_39_729 VDD VSS gf180mcu_fd_sc_mcu7t5v0__filltie
XFILLER_36_244 VDD VDD VSS VSS gf180mcu_fd_sc_mcu7t5v0__fill_1
XFILLER_64_531 VDD VDD VSS VSS gf180mcu_fd_sc_mcu7t5v0__fill_1
XFILLER_36_288 VDD VDD VSS VSS gf180mcu_fd_sc_mcu7t5v0__fill_2
XFILLER_52_737 VDD VDD VSS VSS gf180mcu_fd_sc_mcu7t5v0__fillcap_32
XFILLER_64_597 VDD VDD VSS VSS gf180mcu_fd_sc_mcu7t5v0__fillcap_16
XTAP_TAPCELL_ROW_19_486 VDD VSS gf180mcu_fd_sc_mcu7t5v0__filltie
XFILLER_20_667 VDD VDD VSS VSS gf180mcu_fd_sc_mcu7t5v0__fillcap_64
X_2727_ _2727_/I _2727_/Z VDD VDD VSS VSS gf180mcu_fd_sc_mcu7t5v0__buf_1
XFILLER_9_690 VDD VDD VSS VSS gf180mcu_fd_sc_mcu7t5v0__fill_2
XFILLER_118_577 VDD VDD VSS VSS gf180mcu_fd_sc_mcu7t5v0__fill_1
XTAP_TAPCELL_ROW_115_1639 VDD VSS gf180mcu_fd_sc_mcu7t5v0__filltie
X_2658_ _2730_/I _2658_/Z VDD VDD VSS VSS gf180mcu_fd_sc_mcu7t5v0__buf_1
X_2589_ _2589_/D _2597_/RN clkload6/I _2589_/Q VDD VDD VSS VSS gf180mcu_fd_sc_mcu7t5v0__dffrnq_1
X_1609_ _1603_/Z _1605_/Z _1608_/Z _1609_/Z VDD VDD VSS VSS gf180mcu_fd_sc_mcu7t5v0__xor3_1
XFILLER_101_422 VDD VDD VSS VSS gf180mcu_fd_sc_mcu7t5v0__fillcap_64
Xoutput497 _2689_/Z tl_d_dmem_o[102] VDD VDD VSS VSS gf180mcu_fd_sc_mcu7t5v0__dlyd_1
XFILLER_86_177 VDD VDD VSS VSS gf180mcu_fd_sc_mcu7t5v0__fillcap_8
XFILLER_74_328 VDD VDD VSS VSS gf180mcu_fd_sc_mcu7t5v0__fill_1
XFILLER_74_317 VDD VDD VSS VSS gf180mcu_fd_sc_mcu7t5v0__fill_2
XFILLER_55_586 VDD VDD VSS VSS gf180mcu_fd_sc_mcu7t5v0__fill_1
XFILLER_82_361 VDD VDD VSS VSS gf180mcu_fd_sc_mcu7t5v0__fillcap_4
XFILLER_42_247 VDD VDD VSS VSS gf180mcu_fd_sc_mcu7t5v0__fillcap_64
XFILLER_11_689 VDD VDD VSS VSS gf180mcu_fd_sc_mcu7t5v0__fillcap_8
XFILLER_78_645 VDD VDD VSS VSS gf180mcu_fd_sc_mcu7t5v0__fillcap_16
XFILLER_66_807 VDD VDD VSS VSS gf180mcu_fd_sc_mcu7t5v0__fillcap_16
XFILLER_78_667 VDD VDD VSS VSS gf180mcu_fd_sc_mcu7t5v0__fillcap_16
XFILLER_93_615 VDD VDD VSS VSS gf180mcu_fd_sc_mcu7t5v0__fillcap_8
XFILLER_18_222 VDD VDD VSS VSS gf180mcu_fd_sc_mcu7t5v0__fill_2
XFILLER_46_531 VDD VDD VSS VSS gf180mcu_fd_sc_mcu7t5v0__fill_2
XFILLER_58_380 VDD VDD VSS VSS gf180mcu_fd_sc_mcu7t5v0__fillcap_4
XFILLER_18_244 VDD VDD VSS VSS gf180mcu_fd_sc_mcu7t5v0__fill_1
XFILLER_80_309 VDD VDD VSS VSS gf180mcu_fd_sc_mcu7t5v0__fillcap_4
XFILLER_34_737 VDD VDD VSS VSS gf180mcu_fd_sc_mcu7t5v0__fillcap_64
XFILLER_46_597 VDD VDD VSS VSS gf180mcu_fd_sc_mcu7t5v0__fillcap_64
XTAP_TAPCELL_ROW_16_445 VDD VSS gf180mcu_fd_sc_mcu7t5v0__filltie
X_1960_ _1960_/A1 _1982_/A2 _1998_/B1 _1960_/B2 _1961_/I VDD VDD VSS VSS gf180mcu_fd_sc_mcu7t5v0__aoi22_1
XTAP_TAPCELL_ROW_44_787 VDD VSS gf180mcu_fd_sc_mcu7t5v0__filltie
X_1891_ _1891_/I _1891_/ZN VDD VDD VSS VSS gf180mcu_fd_sc_mcu7t5v0__clkinv_1
X_2512_ _2594_/Q _2773_/I _2512_/Z VDD VDD VSS VSS gf180mcu_fd_sc_mcu7t5v0__xor2_1
X_2443_ _2565_/Q _2451_/B _2444_/B VDD VDD VSS VSS gf180mcu_fd_sc_mcu7t5v0__nand2_1
X_2374_ _2374_/A1 _2374_/A2 _2376_/A1 VDD VDD VSS VSS gf180mcu_fd_sc_mcu7t5v0__nand2_1
XFILLER_68_155 VDD VDD VSS VSS gf180mcu_fd_sc_mcu7t5v0__fill_1
X_1325_ _1325_/I _1326_/B1 VDD VDD VSS VSS gf180mcu_fd_sc_mcu7t5v0__clkinv_1
XFILLER_96_453 VDD VDD VSS VSS gf180mcu_fd_sc_mcu7t5v0__fill_2
XFILLER_56_317 VDD VDD VSS VSS gf180mcu_fd_sc_mcu7t5v0__fillcap_8
XFILLER_84_626 VDD VDD VSS VSS gf180mcu_fd_sc_mcu7t5v0__fillcap_4
X_1256_ _1213_/B _1256_/A2 _1475_/A1 VDD VDD VSS VSS gf180mcu_fd_sc_mcu7t5v0__nand2_1
X_1187_ _1076_/I _1188_/A3 _1196_/C VDD VDD VSS VSS gf180mcu_fd_sc_mcu7t5v0__nand2_1
XTAP_TAPCELL_ROW_65_1037 VDD VSS gf180mcu_fd_sc_mcu7t5v0__filltie
XFILLER_24_247 VDD VDD VSS VSS gf180mcu_fd_sc_mcu7t5v0__fillcap_64
XFILLER_32_291 VDD VDD VSS VSS gf180mcu_fd_sc_mcu7t5v0__fill_2
XTAP_TAPCELL_ROW_76_1166 VDD VSS gf180mcu_fd_sc_mcu7t5v0__filltie
XPHY_EDGE_ROW_18_Left_137 VDD VSS gf180mcu_fd_sc_mcu7t5v0__endcap
XFILLER_0_814 VDD VDD VSS VSS gf180mcu_fd_sc_mcu7t5v0__fill_2
XFILLER_48_807 VDD VDD VSS VSS gf180mcu_fd_sc_mcu7t5v0__fillcap_16
XFILLER_59_133 VDD VDD VSS VSS gf180mcu_fd_sc_mcu7t5v0__fillcap_4
XFILLER_114_20 VDD VDD VSS VSS gf180mcu_fd_sc_mcu7t5v0__fill_1
XFILLER_74_114 VDD VDD VSS VSS gf180mcu_fd_sc_mcu7t5v0__fillcap_32
XFILLER_28_520 VDD VDD VSS VSS gf180mcu_fd_sc_mcu7t5v0__fillcap_4
XFILLER_47_339 VDD VDD VSS VSS gf180mcu_fd_sc_mcu7t5v0__fill_2
XPHY_EDGE_ROW_27_Left_146 VDD VSS gf180mcu_fd_sc_mcu7t5v0__endcap
XFILLER_90_629 VDD VDD VSS VSS gf180mcu_fd_sc_mcu7t5v0__fillcap_16
XFILLER_16_737 VDD VDD VSS VSS gf180mcu_fd_sc_mcu7t5v0__fillcap_32
XTAP_TAPCELL_ROW_87_1295 VDD VSS gf180mcu_fd_sc_mcu7t5v0__filltie
XFILLER_83_692 VDD VDD VSS VSS gf180mcu_fd_sc_mcu7t5v0__fillcap_8
XFILLER_43_556 VDD VDD VSS VSS gf180mcu_fd_sc_mcu7t5v0__fillcap_4
XTAP_TAPCELL_ROW_13_415 VDD VSS gf180mcu_fd_sc_mcu7t5v0__filltie
XFILLER_90_34 VDD VDD VSS VSS gf180mcu_fd_sc_mcu7t5v0__fill_1
XTAP_TAPCELL_ROW_41_746 VDD VSS gf180mcu_fd_sc_mcu7t5v0__filltie
XFILLER_7_424 VDD VDD VSS VSS gf180mcu_fd_sc_mcu7t5v0__fillcap_64
XFILLER_11_486 VDD VDD VSS VSS gf180mcu_fd_sc_mcu7t5v0__fillcap_4
XPHY_EDGE_ROW_36_Left_155 VDD VSS gf180mcu_fd_sc_mcu7t5v0__endcap
XFILLER_38_317 VDD VDD VSS VSS gf180mcu_fd_sc_mcu7t5v0__fillcap_16
X_1110_ _2569_/Q _2153_/A2 _1110_/ZN VDD VDD VSS VSS gf180mcu_fd_sc_mcu7t5v0__nor2_1
XFILLER_78_497 VDD VDD VSS VSS gf180mcu_fd_sc_mcu7t5v0__fillcap_4
XFILLER_65_136 VDD VDD VSS VSS gf180mcu_fd_sc_mcu7t5v0__fillcap_4
X_2090_ _2090_/A1 _2090_/A2 _2090_/ZN VDD VDD VSS VSS gf180mcu_fd_sc_mcu7t5v0__nand2_1
XTAP_TAPCELL_ROW_49_846 VDD VSS gf180mcu_fd_sc_mcu7t5v0__filltie
XPHY_EDGE_ROW_45_Left_164 VDD VSS gf180mcu_fd_sc_mcu7t5v0__endcap
XFILLER_93_489 VDD VDD VSS VSS gf180mcu_fd_sc_mcu7t5v0__fill_1
XFILLER_81_629 VDD VDD VSS VSS gf180mcu_fd_sc_mcu7t5v0__fill_1
XFILLER_81_618 VDD VDD VSS VSS gf180mcu_fd_sc_mcu7t5v0__fill_2
XFILLER_34_523 VDD VDD VSS VSS gf180mcu_fd_sc_mcu7t5v0__fill_2
XFILLER_74_681 VDD VDD VSS VSS gf180mcu_fd_sc_mcu7t5v0__fill_1
XFILLER_73_191 VDD VDD VSS VSS gf180mcu_fd_sc_mcu7t5v0__fillcap_4
XFILLER_14_280 VDD VDD VSS VSS gf180mcu_fd_sc_mcu7t5v0__fill_1
X_1943_ _1943_/I _1943_/ZN VDD VDD VSS VSS gf180mcu_fd_sc_mcu7t5v0__clkinv_1
X_1874_ _1874_/A1 _1900_/A2 _1900_/B1 _1874_/B2 _1875_/I VDD VDD VSS VSS gf180mcu_fd_sc_mcu7t5v0__aoi22_1
XPHY_EDGE_ROW_54_Left_173 VDD VSS gf180mcu_fd_sc_mcu7t5v0__endcap
X_2426_ _2451_/B _2424_/Z _2426_/B _2562_/D VDD VDD VSS VSS gf180mcu_fd_sc_mcu7t5v0__oai21_1
X_2357_ _2357_/A1 _2357_/A2 _2358_/A2 VDD VDD VSS VSS gf180mcu_fd_sc_mcu7t5v0__nand2_1
XPHY_EDGE_ROW_63_Left_182 VDD VSS gf180mcu_fd_sc_mcu7t5v0__endcap
XFILLER_69_486 VDD VDD VSS VSS gf180mcu_fd_sc_mcu7t5v0__fillcap_4
X_2288_ _2288_/A1 _2288_/A2 _2348_/B _2288_/ZN VDD VDD VSS VSS gf180mcu_fd_sc_mcu7t5v0__aoi21_1
X_1308_ input16/Z _1348_/A2 _1308_/B1 _2160_/A2 _1309_/I VDD VDD VSS VSS gf180mcu_fd_sc_mcu7t5v0__aoi22_1
XFILLER_96_294 VDD VDD VSS VSS gf180mcu_fd_sc_mcu7t5v0__fillcap_16
X_1239_ _1251_/A3 _2238_/A2 _2238_/B1 _1257_/A3 _2246_/C _1241_/A1 VDD VDD VSS VSS
+ gf180mcu_fd_sc_mcu7t5v0__aoi221_1
XFILLER_71_106 VDD VDD VSS VSS gf180mcu_fd_sc_mcu7t5v0__fillcap_4
XFILLER_65_670 VDD VDD VSS VSS gf180mcu_fd_sc_mcu7t5v0__fillcap_8
XFILLER_25_556 VDD VDD VSS VSS gf180mcu_fd_sc_mcu7t5v0__fillcap_4
XFILLER_64_191 VDD VDD VSS VSS gf180mcu_fd_sc_mcu7t5v0__fill_1
XFILLER_40_515 VDD VDD VSS VSS gf180mcu_fd_sc_mcu7t5v0__fillcap_8
XFILLER_52_364 VDD VDD VSS VSS gf180mcu_fd_sc_mcu7t5v0__fillcap_16
XPHY_EDGE_ROW_72_Left_191 VDD VSS gf180mcu_fd_sc_mcu7t5v0__endcap
XFILLER_106_322 VDD VDD VSS VSS gf180mcu_fd_sc_mcu7t5v0__fill_1
XFILLER_106_399 VDD VDD VSS VSS gf180mcu_fd_sc_mcu7t5v0__fill_2
XFILLER_0_644 VDD VDD VSS VSS gf180mcu_fd_sc_mcu7t5v0__fill_2
XTAP_TAPCELL_ROW_89_1324 VDD VSS gf180mcu_fd_sc_mcu7t5v0__filltie
XFILLER_63_629 VDD VDD VSS VSS gf180mcu_fd_sc_mcu7t5v0__fill_1
XTAP_TAPCELL_ROW_46_805 VDD VSS gf180mcu_fd_sc_mcu7t5v0__filltie
XTAP_TAPCELL_ROW_26_573 VDD VSS gf180mcu_fd_sc_mcu7t5v0__filltie
X_1590_ _2740_/I _2733_/I _1614_/A3 _1590_/Z VDD VDD VSS VSS gf180mcu_fd_sc_mcu7t5v0__xor3_1
XFILLER_22_4 VDD VDD VSS VSS gf180mcu_fd_sc_mcu7t5v0__fill_1
XFILLER_39_626 VDD VDD VSS VSS gf180mcu_fd_sc_mcu7t5v0__fillcap_4
X_2211_ _2211_/A1 _2211_/A2 _2211_/B _2211_/ZN VDD VDD VSS VSS gf180mcu_fd_sc_mcu7t5v0__oai21_1
XFILLER_85_209 VDD VDD VSS VSS gf180mcu_fd_sc_mcu7t5v0__fill_1
XFILLER_39_648 VDD VDD VSS VSS gf180mcu_fd_sc_mcu7t5v0__fillcap_8
X_2142_ _2142_/A1 _2140_/B _2142_/B _2145_/A2 VDD VDD VSS VSS gf180mcu_fd_sc_mcu7t5v0__oai21_1
XFILLER_38_158 VDD VDD VSS VSS gf180mcu_fd_sc_mcu7t5v0__fillcap_16
X_2073_ _1066_/I _2550_/Q _2105_/A1 VDD VDD VSS VSS gf180mcu_fd_sc_mcu7t5v0__nand2_1
XFILLER_47_692 VDD VDD VSS VSS gf180mcu_fd_sc_mcu7t5v0__fillcap_8
XFILLER_53_106 VDD VDD VSS VSS gf180mcu_fd_sc_mcu7t5v0__fillcap_32
XTAP_TAPCELL_ROW_109_1560 VDD VSS gf180mcu_fd_sc_mcu7t5v0__filltie
XFILLER_81_437 VDD VDD VSS VSS gf180mcu_fd_sc_mcu7t5v0__fillcap_32
XFILLER_62_695 VDD VDD VSS VSS gf180mcu_fd_sc_mcu7t5v0__fill_2
X_1926_ _1926_/A1 _1938_/A2 _1926_/B1 _1926_/B2 _1927_/I VDD VDD VSS VSS gf180mcu_fd_sc_mcu7t5v0__aoi22_1
XFILLER_30_18 VDD VDD VSS VSS gf180mcu_fd_sc_mcu7t5v0__fillcap_8
X_1857_ _1857_/I _1857_/ZN VDD VDD VSS VSS gf180mcu_fd_sc_mcu7t5v0__clkinv_1
X_1788_ _1978_/A1 _1818_/A2 _1814_/B1 _2721_/I _1789_/I VDD VDD VSS VSS gf180mcu_fd_sc_mcu7t5v0__aoi22_1
XFILLER_89_504 VDD VDD VSS VSS gf180mcu_fd_sc_mcu7t5v0__fill_1
XTAP_TAPCELL_ROW_73_1136 VDD VSS gf180mcu_fd_sc_mcu7t5v0__filltie
X_2409_ _2409_/A1 _2409_/A2 _2409_/Z VDD VDD VSS VSS gf180mcu_fd_sc_mcu7t5v0__and2_1
XFILLER_69_250 VDD VDD VSS VSS gf180mcu_fd_sc_mcu7t5v0__fillcap_4
XFILLER_29_169 VDD VDD VSS VSS gf180mcu_fd_sc_mcu7t5v0__fillcap_8
XFILLER_44_139 VDD VDD VSS VSS gf180mcu_fd_sc_mcu7t5v0__fill_1
XTAP_TAPCELL_ROW_84_1265 VDD VSS gf180mcu_fd_sc_mcu7t5v0__filltie
XFILLER_40_312 VDD VDD VSS VSS gf180mcu_fd_sc_mcu7t5v0__fill_2
XFILLER_41_846 VDD VDD VSS VSS gf180mcu_fd_sc_mcu7t5v0__fill_1
XFILLER_53_695 VDD VDD VSS VSS gf180mcu_fd_sc_mcu7t5v0__fillcap_4
XTAP_TAPCELL_ROW_23_532 VDD VSS gf180mcu_fd_sc_mcu7t5v0__filltie
XTAP_TAPCELL_ROW_51_874 VDD VSS gf180mcu_fd_sc_mcu7t5v0__filltie
XTAP_TAPCELL_ROW_51_863 VDD VSS gf180mcu_fd_sc_mcu7t5v0__filltie
XPHY_EDGE_ROW_109_Right_109 VDD VSS gf180mcu_fd_sc_mcu7t5v0__endcap
XTAP_TAPCELL_ROW_95_1394 VDD VSS gf180mcu_fd_sc_mcu7t5v0__filltie
XFILLER_0_441 VDD VDD VSS VSS gf180mcu_fd_sc_mcu7t5v0__fill_1
Xinput320 tl_h_d_i[46] _1946_/B2 VDD VDD VSS VSS gf180mcu_fd_sc_mcu7t5v0__dlyd_1
Xinput331 tl_h_d_i[56] _1966_/B2 VDD VDD VSS VSS gf180mcu_fd_sc_mcu7t5v0__dlyd_1
Xinput342 tl_h_d_i[66] _2725_/I VDD VDD VSS VSS gf180mcu_fd_sc_mcu7t5v0__clkbuf_2
Xinput353 tl_h_d_i[76] _2735_/I VDD VDD VSS VSS gf180mcu_fd_sc_mcu7t5v0__clkbuf_2
Xinput364 tl_h_d_i[86] _2745_/I VDD VDD VSS VSS gf180mcu_fd_sc_mcu7t5v0__clkbuf_2
Xinput375 tl_h_d_i[96] _2755_/I VDD VDD VSS VSS gf180mcu_fd_sc_mcu7t5v0__clkbuf_2
Xinput386 tl_h_i_i[105] _2393_/I0 VDD VDD VSS VSS gf180mcu_fd_sc_mcu7t5v0__dlyd_1
Xinput397 tl_h_i_i[12] _1878_/A1 VDD VDD VSS VSS gf180mcu_fd_sc_mcu7t5v0__dlyd_1
XTAP_TAPCELL_ROW_59_963 VDD VSS gf180mcu_fd_sc_mcu7t5v0__filltie
XFILLER_91_702 VDD VDD VSS VSS gf180mcu_fd_sc_mcu7t5v0__fillcap_8
XFILLER_17_865 VDD VDD VSS VSS gf180mcu_fd_sc_mcu7t5v0__fill_1
XTAP_TAPCELL_ROW_3_290 VDD VSS gf180mcu_fd_sc_mcu7t5v0__filltie
XFILLER_43_150 VDD VDD VSS VSS gf180mcu_fd_sc_mcu7t5v0__fillcap_4
XFILLER_71_492 VDD VDD VSS VSS gf180mcu_fd_sc_mcu7t5v0__fillcap_8
X_2760_ _2760_/I _2760_/Z VDD VDD VSS VSS gf180mcu_fd_sc_mcu7t5v0__buf_1
X_2691_ _2763_/I _2691_/Z VDD VDD VSS VSS gf180mcu_fd_sc_mcu7t5v0__buf_1
X_1711_ _1711_/I _1711_/ZN VDD VDD VSS VSS gf180mcu_fd_sc_mcu7t5v0__clkinv_1
XANTENNA_2 _2711_/I VDD VDD VSS VSS gf180mcu_fd_sc_mcu7t5v0__antenna
X_1642_ _1956_/B2 _1651_/A2 _1642_/Z VDD VDD VSS VSS gf180mcu_fd_sc_mcu7t5v0__or2_1
Xoutput827 _2708_/Z tl_d_uart_o[17] VDD VDD VSS VSS gf180mcu_fd_sc_mcu7t5v0__dlyd_1
Xoutput816 _1661_/Z tl_d_uart_o[10] VDD VDD VSS VSS gf180mcu_fd_sc_mcu7t5v0__dlyd_1
Xoutput805 _2705_/Z tl_d_uart_o[0] VDD VDD VSS VSS gf180mcu_fd_sc_mcu7t5v0__dlyd_1
Xoutput849 _1628_/Z tl_d_uart_o[37] VDD VDD VSS VSS gf180mcu_fd_sc_mcu7t5v0__dlyd_1
Xoutput838 _2718_/Z tl_d_uart_o[27] VDD VDD VSS VSS gf180mcu_fd_sc_mcu7t5v0__dlyd_1
X_1573_ _2745_/I _2746_/I _1573_/Z VDD VDD VSS VSS gf180mcu_fd_sc_mcu7t5v0__xor2_1
XFILLER_39_401 VDD VDD VSS VSS gf180mcu_fd_sc_mcu7t5v0__fillcap_8
XFILLER_79_570 VDD VDD VSS VSS gf180mcu_fd_sc_mcu7t5v0__fill_1
XFILLER_79_581 VDD VDD VSS VSS gf180mcu_fd_sc_mcu7t5v0__fillcap_32
Xfanout1080 _2401_/S _2397_/S VDD VDD VSS VSS gf180mcu_fd_sc_mcu7t5v0__dlyd_1
Xfanout1091 _1830_/A2 _1722_/A2 VDD VDD VSS VSS gf180mcu_fd_sc_mcu7t5v0__dlyd_1
X_2125_ _2125_/A1 _2125_/A2 _2125_/B _2125_/ZN VDD VDD VSS VSS gf180mcu_fd_sc_mcu7t5v0__oai21_1
XFILLER_94_584 VDD VDD VSS VSS gf180mcu_fd_sc_mcu7t5v0__fill_2
XFILLER_81_212 VDD VDD VSS VSS gf180mcu_fd_sc_mcu7t5v0__fill_1
XFILLER_81_201 VDD VDD VSS VSS gf180mcu_fd_sc_mcu7t5v0__fillcap_4
X_2056_ _2130_/B2 _2315_/A2 _2277_/A1 _2130_/A1 _2057_/I VDD VDD VSS VSS gf180mcu_fd_sc_mcu7t5v0__aoi22_1
XFILLER_22_312 VDD VDD VSS VSS gf180mcu_fd_sc_mcu7t5v0__fill_2
XFILLER_34_172 VDD VDD VSS VSS gf180mcu_fd_sc_mcu7t5v0__fill_2
XTAP_TAPCELL_ROW_20_502 VDD VSS gf180mcu_fd_sc_mcu7t5v0__filltie
X_1909_ _1909_/I _1909_/ZN VDD VDD VSS VSS gf180mcu_fd_sc_mcu7t5v0__clkinv_1
XFILLER_106_10 VDD VDD VSS VSS gf180mcu_fd_sc_mcu7t5v0__fill_2
XFILLER_49_209 VDD VDD VSS VSS gf180mcu_fd_sc_mcu7t5v0__fill_1
XFILLER_57_220 VDD VDD VSS VSS gf180mcu_fd_sc_mcu7t5v0__fillcap_4
XFILLER_106_98 VDD VDD VSS VSS gf180mcu_fd_sc_mcu7t5v0__fillcap_4
XFILLER_57_231 VDD VDD VSS VSS gf180mcu_fd_sc_mcu7t5v0__fillcap_32
XFILLER_85_562 VDD VDD VSS VSS gf180mcu_fd_sc_mcu7t5v0__fillcap_8
XFILLER_73_702 VDD VDD VSS VSS gf180mcu_fd_sc_mcu7t5v0__fillcap_64
XTAP_TAPCELL_ROW_56_933 VDD VSS gf180mcu_fd_sc_mcu7t5v0__filltie
XFILLER_45_448 VDD VDD VSS VSS gf180mcu_fd_sc_mcu7t5v0__fill_1
XTAP_TAPCELL_ROW_0_260 VDD VSS gf180mcu_fd_sc_mcu7t5v0__filltie
XFILLER_53_492 VDD VDD VSS VSS gf180mcu_fd_sc_mcu7t5v0__fillcap_64
XTAP_TAPCELL_ROW_36_690 VDD VSS gf180mcu_fd_sc_mcu7t5v0__filltie
XFILLER_41_698 VDD VDD VSS VSS gf180mcu_fd_sc_mcu7t5v0__fill_2
XFILLER_9_349 VDD VDD VSS VSS gf180mcu_fd_sc_mcu7t5v0__fill_1
XTAP_TAPCELL_ROW_97_1423 VDD VSS gf180mcu_fd_sc_mcu7t5v0__filltie
XFILLER_31_72 VDD VDD VSS VSS gf180mcu_fd_sc_mcu7t5v0__fillcap_32
Xinput150 tl_d_rom_i[24] _1320_/A1 VDD VDD VSS VSS gf180mcu_fd_sc_mcu7t5v0__dlyd_1
Xinput161 tl_d_rom_i[34] _1400_/A1 VDD VDD VSS VSS gf180mcu_fd_sc_mcu7t5v0__dlyd_1
Xinput172 tl_d_rom_i[44] _1480_/A1 VDD VDD VSS VSS gf180mcu_fd_sc_mcu7t5v0__dlyd_1
XFILLER_63_212 VDD VDD VSS VSS gf180mcu_fd_sc_mcu7t5v0__fillcap_32
Xinput183 tl_d_rom_i[54] _2205_/A1 VDD VDD VSS VSS gf180mcu_fd_sc_mcu7t5v0__dlyd_1
Xinput194 tl_d_rom_i[64] _1251_/A3 VDD VDD VSS VSS gf180mcu_fd_sc_mcu7t5v0__dlyd_1
XTAP_TAPCELL_ROW_106_1530 VDD VSS gf180mcu_fd_sc_mcu7t5v0__filltie
XFILLER_91_554 VDD VDD VSS VSS gf180mcu_fd_sc_mcu7t5v0__fillcap_4
XFILLER_51_418 VDD VDD VSS VSS gf180mcu_fd_sc_mcu7t5v0__fill_2
XFILLER_63_256 VDD VDD VSS VSS gf180mcu_fd_sc_mcu7t5v0__fillcap_8
X_2743_ _2743_/I _2743_/Z VDD VDD VSS VSS gf180mcu_fd_sc_mcu7t5v0__buf_1
X_2674_ _2746_/I _2674_/Z VDD VDD VSS VSS gf180mcu_fd_sc_mcu7t5v0__buf_1
Xoutput602 _2682_/Z tl_d_dmem_o[95] VDD VDD VSS VSS gf180mcu_fd_sc_mcu7t5v0__dlyd_1
Xoutput613 _2029_/ZN tl_d_esram_o[104] VDD VDD VSS VSS gf180mcu_fd_sc_mcu7t5v0__dlyd_1
Xoutput624 _1877_/ZN tl_d_esram_o[11] VDD VDD VSS VSS gf180mcu_fd_sc_mcu7t5v0__dlyd_1
Xoutput635 _1897_/ZN tl_d_esram_o[21] VDD VDD VSS VSS gf180mcu_fd_sc_mcu7t5v0__dlyd_1
X_1625_ _1922_/B2 _1665_/S _1625_/Z VDD VDD VSS VSS gf180mcu_fd_sc_mcu7t5v0__or2_1
Xoutput646 _1917_/ZN tl_d_esram_o[31] VDD VDD VSS VSS gf180mcu_fd_sc_mcu7t5v0__dlyd_1
Xoutput657 _1937_/ZN tl_d_esram_o[41] VDD VDD VSS VSS gf180mcu_fd_sc_mcu7t5v0__dlyd_1
Xoutput679 _1977_/ZN tl_d_esram_o[61] VDD VDD VSS VSS gf180mcu_fd_sc_mcu7t5v0__dlyd_1
Xoutput668 _1957_/ZN tl_d_esram_o[51] VDD VDD VSS VSS gf180mcu_fd_sc_mcu7t5v0__dlyd_1
X_1556_ _2708_/I _2709_/I _1556_/Z VDD VDD VSS VSS gf180mcu_fd_sc_mcu7t5v0__xor2_1
XFILLER_101_615 VDD VDD VSS VSS gf180mcu_fd_sc_mcu7t5v0__fill_1
X_1487_ _1487_/A1 _1487_/A2 _1487_/ZN VDD VDD VSS VSS gf180mcu_fd_sc_mcu7t5v0__nor2_1
XFILLER_86_348 VDD VDD VSS VSS gf180mcu_fd_sc_mcu7t5v0__fillcap_8
XFILLER_55_702 VDD VDD VSS VSS gf180mcu_fd_sc_mcu7t5v0__fillcap_64
XFILLER_67_562 VDD VDD VSS VSS gf180mcu_fd_sc_mcu7t5v0__fillcap_8
X_2108_ _2242_/B2 _2371_/A2 _2369_/A1 _2242_/A1 _2109_/I VDD VDD VSS VSS gf180mcu_fd_sc_mcu7t5v0__aoi22_1
XTAP_TAPCELL_ROW_68_1068 VDD VSS gf180mcu_fd_sc_mcu7t5v0__filltie
XFILLER_23_632 VDD VDD VSS VSS gf180mcu_fd_sc_mcu7t5v0__fillcap_64
XFILLER_35_492 VDD VDD VSS VSS gf180mcu_fd_sc_mcu7t5v0__fillcap_64
X_2039_ _2039_/I _2039_/ZN VDD VDD VSS VSS gf180mcu_fd_sc_mcu7t5v0__clkinv_1
XTAP_TAPCELL_ROW_81_1224 VDD VSS gf180mcu_fd_sc_mcu7t5v0__filltie
XTAP_TAPCELL_ROW_61_991 VDD VSS gf180mcu_fd_sc_mcu7t5v0__filltie
XTAP_TAPCELL_ROW_92_1364 VDD VSS gf180mcu_fd_sc_mcu7t5v0__filltie
XFILLER_77_337 VDD VDD VSS VSS gf180mcu_fd_sc_mcu7t5v0__fillcap_8
XFILLER_45_278 VDD VDD VSS VSS gf180mcu_fd_sc_mcu7t5v0__fill_2
XFILLER_26_470 VDD VDD VSS VSS gf180mcu_fd_sc_mcu7t5v0__fillcap_32
XFILLER_60_237 VDD VDD VSS VSS gf180mcu_fd_sc_mcu7t5v0__fillcap_8
XTAP_TAPCELL_ROW_101_1471 VDD VSS gf180mcu_fd_sc_mcu7t5v0__filltie
XTAP_TAPCELL_ROW_11_387 VDD VSS gf180mcu_fd_sc_mcu7t5v0__filltie
XFILLER_6_831 VDD VDD VSS VSS gf180mcu_fd_sc_mcu7t5v0__fill_1
X_1410_ input96/Z _1418_/A2 _2375_/A3 _1411_/B VDD VDD VSS VSS gf180mcu_fd_sc_mcu7t5v0__nand3_1
X_2390_ _2390_/I0 _2546_/Q _2398_/S _2546_/D VDD VDD VSS VSS gf180mcu_fd_sc_mcu7t5v0__mux2_2
X_1341_ _1341_/I _1342_/B1 VDD VDD VSS VSS gf180mcu_fd_sc_mcu7t5v0__clkinv_1
X_1272_ _1272_/A1 _1368_/A2 _2261_/A2 VDD VDD VSS VSS gf180mcu_fd_sc_mcu7t5v0__nand2_1
XFILLER_37_702 VDD VDD VSS VSS gf180mcu_fd_sc_mcu7t5v0__fillcap_64
XFILLER_49_562 VDD VDD VSS VSS gf180mcu_fd_sc_mcu7t5v0__fillcap_16
XTAP_TAPCELL_ROW_39_719 VDD VSS gf180mcu_fd_sc_mcu7t5v0__filltie
XFILLER_36_256 VDD VDD VSS VSS gf180mcu_fd_sc_mcu7t5v0__fillcap_4
XFILLER_17_492 VDD VDD VSS VSS gf180mcu_fd_sc_mcu7t5v0__fillcap_64
XTAP_TAPCELL_ROW_19_487 VDD VSS gf180mcu_fd_sc_mcu7t5v0__filltie
XFILLER_51_259 VDD VDD VSS VSS gf180mcu_fd_sc_mcu7t5v0__fillcap_16
X_2726_ _2726_/I _2726_/Z VDD VDD VSS VSS gf180mcu_fd_sc_mcu7t5v0__buf_1
X_2657_ _2729_/I _2657_/Z VDD VDD VSS VSS gf180mcu_fd_sc_mcu7t5v0__buf_1
X_1608_ _2748_/I _2708_/I _1607_/Z _1608_/Z VDD VDD VSS VSS gf180mcu_fd_sc_mcu7t5v0__xor3_1
X_2588_ _2588_/D _2588_/RN clkload3/I _2588_/Q VDD VDD VSS VSS gf180mcu_fd_sc_mcu7t5v0__dffrnq_1
XFILLER_99_462 VDD VDD VSS VSS gf180mcu_fd_sc_mcu7t5v0__fillcap_16
XFILLER_101_412 VDD VDD VSS VSS gf180mcu_fd_sc_mcu7t5v0__fillcap_8
Xoutput498 _2690_/Z tl_d_dmem_o[103] VDD VDD VSS VSS gf180mcu_fd_sc_mcu7t5v0__dlyd_1
X_1539_ _1966_/B2 _1619_/S _1539_/Z VDD VDD VSS VSS gf180mcu_fd_sc_mcu7t5v0__or2_1
Xwire1229 wire1229/I _2732_/I VDD VDD VSS VSS gf180mcu_fd_sc_mcu7t5v0__buf_8
XFILLER_87_668 VDD VDD VSS VSS gf180mcu_fd_sc_mcu7t5v0__fill_2
XFILLER_27_201 VDD VDD VSS VSS gf180mcu_fd_sc_mcu7t5v0__fill_2
XFILLER_86_189 VDD VDD VSS VSS gf180mcu_fd_sc_mcu7t5v0__fill_2
XFILLER_27_212 VDD VDD VSS VSS gf180mcu_fd_sc_mcu7t5v0__fillcap_8
XFILLER_55_554 VDD VDD VSS VSS gf180mcu_fd_sc_mcu7t5v0__fillcap_4
XFILLER_42_226 VDD VDD VSS VSS gf180mcu_fd_sc_mcu7t5v0__fillcap_16
XFILLER_82_373 VDD VDD VSS VSS gf180mcu_fd_sc_mcu7t5v0__fillcap_8
XFILLER_70_568 VDD VDD VSS VSS gf180mcu_fd_sc_mcu7t5v0__fill_1
XFILLER_11_657 VDD VDD VSS VSS gf180mcu_fd_sc_mcu7t5v0__fillcap_32
XFILLER_109_501 VDD VDD VSS VSS gf180mcu_fd_sc_mcu7t5v0__fill_1
XFILLER_19_702 VDD VDD VSS VSS gf180mcu_fd_sc_mcu7t5v0__fillcap_64
XFILLER_93_638 VDD VDD VSS VSS gf180mcu_fd_sc_mcu7t5v0__fill_1
XFILLER_93_627 VDD VDD VSS VSS gf180mcu_fd_sc_mcu7t5v0__fill_2
XFILLER_46_521 VDD VDD VSS VSS gf180mcu_fd_sc_mcu7t5v0__fillcap_4
XPHY_EDGE_ROW_16_Right_16 VDD VSS gf180mcu_fd_sc_mcu7t5v0__endcap
XTAP_TAPCELL_ROW_16_446 VDD VSS gf180mcu_fd_sc_mcu7t5v0__filltie
XFILLER_14_451 VDD VDD VSS VSS gf180mcu_fd_sc_mcu7t5v0__fillcap_4
XTAP_TAPCELL_ROW_44_788 VDD VSS gf180mcu_fd_sc_mcu7t5v0__filltie
X_1890_ _2388_/I0 _1914_/A2 _1914_/B1 _2709_/I _1891_/I VDD VDD VSS VSS gf180mcu_fd_sc_mcu7t5v0__aoi22_1
XPHY_EDGE_ROW_25_Right_25 VDD VSS gf180mcu_fd_sc_mcu7t5v0__endcap
X_2511_ _2511_/A1 _2516_/A1 _2513_/A1 VDD VDD VSS VSS gf180mcu_fd_sc_mcu7t5v0__nand2_1
X_2442_ _2435_/I _2441_/B _2442_/A3 _2442_/Z VDD VDD VSS VSS gf180mcu_fd_sc_mcu7t5v0__and3_1
XFILLER_38_2 VDD VDD VSS VSS gf180mcu_fd_sc_mcu7t5v0__fillcap_8
X_2373_ _2373_/A1 _2373_/A2 _2374_/A2 VDD VDD VSS VSS gf180mcu_fd_sc_mcu7t5v0__nand2_1
X_1324_ input18/Z _1396_/A2 _1324_/B1 _1444_/B2 _1325_/I VDD VDD VSS VSS gf180mcu_fd_sc_mcu7t5v0__aoi22_1
XFILLER_56_307 VDD VDD VSS VSS gf180mcu_fd_sc_mcu7t5v0__fillcap_8
XFILLER_37_532 VDD VDD VSS VSS gf180mcu_fd_sc_mcu7t5v0__fill_2
X_1255_ _2572_/Q _2573_/Q _2140_/B _1255_/A4 _1256_/A2 VDD VDD VSS VSS gf180mcu_fd_sc_mcu7t5v0__nand4_1
XPHY_EDGE_ROW_34_Right_34 VDD VSS gf180mcu_fd_sc_mcu7t5v0__endcap
X_1186_ _2578_/Q _1188_/A3 _1201_/B _1197_/B VDD VDD VSS VSS gf180mcu_fd_sc_mcu7t5v0__oai21_1
XFILLER_64_373 VDD VDD VSS VSS gf180mcu_fd_sc_mcu7t5v0__fillcap_4
XFILLER_91_181 VDD VDD VSS VSS gf180mcu_fd_sc_mcu7t5v0__fill_2
XTAP_TAPCELL_ROW_65_1038 VDD VSS gf180mcu_fd_sc_mcu7t5v0__filltie
XPHY_EDGE_ROW_43_Right_43 VDD VSS gf180mcu_fd_sc_mcu7t5v0__endcap
XFILLER_118_364 VDD VDD VSS VSS gf180mcu_fd_sc_mcu7t5v0__fill_1
X_2709_ _2709_/I _2709_/Z VDD VDD VSS VSS gf180mcu_fd_sc_mcu7t5v0__buf_1
XTAP_TAPCELL_ROW_76_1167 VDD VSS gf180mcu_fd_sc_mcu7t5v0__filltie
XFILLER_58_26 VDD VDD VSS VSS gf180mcu_fd_sc_mcu7t5v0__fill_2
XFILLER_59_101 VDD VDD VSS VSS gf180mcu_fd_sc_mcu7t5v0__fillcap_32
XFILLER_87_432 VDD VDD VSS VSS gf180mcu_fd_sc_mcu7t5v0__fill_1
XFILLER_101_253 VDD VDD VSS VSS gf180mcu_fd_sc_mcu7t5v0__fill_1
XPHY_EDGE_ROW_52_Right_52 VDD VSS gf180mcu_fd_sc_mcu7t5v0__endcap
XFILLER_74_159 VDD VDD VSS VSS gf180mcu_fd_sc_mcu7t5v0__fillcap_16
XFILLER_15_204 VDD VDD VSS VSS gf180mcu_fd_sc_mcu7t5v0__fillcap_4
XFILLER_55_373 VDD VDD VSS VSS gf180mcu_fd_sc_mcu7t5v0__fillcap_4
XTAP_TAPCELL_ROW_87_1296 VDD VSS gf180mcu_fd_sc_mcu7t5v0__filltie
XFILLER_82_181 VDD VDD VSS VSS gf180mcu_fd_sc_mcu7t5v0__fill_2
XFILLER_70_387 VDD VDD VSS VSS gf180mcu_fd_sc_mcu7t5v0__fillcap_64
XTAP_TAPCELL_ROW_41_747 VDD VSS gf180mcu_fd_sc_mcu7t5v0__filltie
XTAP_TAPCELL_ROW_13_416 VDD VSS gf180mcu_fd_sc_mcu7t5v0__filltie
XPHY_EDGE_ROW_61_Right_61 VDD VSS gf180mcu_fd_sc_mcu7t5v0__endcap
XPHY_EDGE_ROW_70_Right_70 VDD VSS gf180mcu_fd_sc_mcu7t5v0__endcap
XTAP_TAPCELL_ROW_49_847 VDD VSS gf180mcu_fd_sc_mcu7t5v0__filltie
XFILLER_46_351 VDD VDD VSS VSS gf180mcu_fd_sc_mcu7t5v0__fillcap_16
XFILLER_61_387 VDD VDD VSS VSS gf180mcu_fd_sc_mcu7t5v0__fillcap_16
XFILLER_42_590 VDD VDD VSS VSS gf180mcu_fd_sc_mcu7t5v0__fillcap_4
X_1942_ _1942_/A1 _1964_/A2 _1952_/B1 _1942_/B2 _1943_/I VDD VDD VSS VSS gf180mcu_fd_sc_mcu7t5v0__aoi22_1
X_1873_ _1873_/I _1873_/ZN VDD VDD VSS VSS gf180mcu_fd_sc_mcu7t5v0__clkinv_1
XFILLER_89_708 VDD VDD VSS VSS gf180mcu_fd_sc_mcu7t5v0__fillcap_16
X_2425_ _2562_/Q _2451_/B _2426_/B VDD VDD VSS VSS gf180mcu_fd_sc_mcu7t5v0__nand2_1
XFILLER_28_18 VDD VDD VSS VSS gf180mcu_fd_sc_mcu7t5v0__fill_2
XFILLER_57_627 VDD VDD VSS VSS gf180mcu_fd_sc_mcu7t5v0__fill_2
X_2356_ _2356_/A1 _2356_/A2 _2360_/B _2356_/ZN VDD VDD VSS VSS gf180mcu_fd_sc_mcu7t5v0__aoi21_1
XFILLER_56_115 VDD VDD VSS VSS gf180mcu_fd_sc_mcu7t5v0__fillcap_4
X_2287_ input84/Z _2291_/A2 _2311_/A3 _2288_/A2 VDD VDD VSS VSS gf180mcu_fd_sc_mcu7t5v0__nand3_1
X_1307_ _1491_/A1 _1305_/Z _1307_/B _1308_/B1 VDD VDD VSS VSS gf180mcu_fd_sc_mcu7t5v0__oai21_1
XFILLER_56_159 VDD VDD VSS VSS gf180mcu_fd_sc_mcu7t5v0__fillcap_16
X_1238_ _1248_/A2 _2231_/C _1241_/B VDD VDD VSS VSS gf180mcu_fd_sc_mcu7t5v0__nand2_1
XFILLER_84_457 VDD VDD VSS VSS gf180mcu_fd_sc_mcu7t5v0__fill_2
XFILLER_64_170 VDD VDD VSS VSS gf180mcu_fd_sc_mcu7t5v0__fillcap_4
XFILLER_71_118 VDD VDD VSS VSS gf180mcu_fd_sc_mcu7t5v0__fillcap_16
XFILLER_52_343 VDD VDD VSS VSS gf180mcu_fd_sc_mcu7t5v0__fillcap_8
X_1169_ _1191_/A1 _1164_/Z _1173_/A2 _1207_/B VDD VDD VSS VSS gf180mcu_fd_sc_mcu7t5v0__nor3_2
XFILLER_80_630 VDD VDD VSS VSS gf180mcu_fd_sc_mcu7t5v0__fillcap_4
XFILLER_40_527 VDD VDD VSS VSS gf180mcu_fd_sc_mcu7t5v0__fillcap_64
XFILLER_52_387 VDD VDD VSS VSS gf180mcu_fd_sc_mcu7t5v0__fillcap_32
XFILLER_80_663 VDD VDD VSS VSS gf180mcu_fd_sc_mcu7t5v0__fill_2
XFILLER_0_678 VDD VDD VSS VSS gf180mcu_fd_sc_mcu7t5v0__fill_2
XFILLER_102_584 VDD VDD VSS VSS gf180mcu_fd_sc_mcu7t5v0__fill_2
XTAP_TAPCELL_ROW_89_1325 VDD VSS gf180mcu_fd_sc_mcu7t5v0__filltie
XTAP_TAPCELL_ROW_46_806 VDD VSS gf180mcu_fd_sc_mcu7t5v0__filltie
XFILLER_62_107 VDD VDD VSS VSS gf180mcu_fd_sc_mcu7t5v0__fillcap_16
XFILLER_90_427 VDD VDD VSS VSS gf180mcu_fd_sc_mcu7t5v0__fill_2
XFILLER_43_332 VDD VDD VSS VSS gf180mcu_fd_sc_mcu7t5v0__fillcap_16
XTAP_TAPCELL_ROW_26_574 VDD VSS gf180mcu_fd_sc_mcu7t5v0__filltie
XTAP_TAPCELL_ROW_26_563 VDD VSS gf180mcu_fd_sc_mcu7t5v0__filltie
XFILLER_70_184 VDD VDD VSS VSS gf180mcu_fd_sc_mcu7t5v0__fillcap_32
XFILLER_98_505 VDD VDD VSS VSS gf180mcu_fd_sc_mcu7t5v0__fillcap_4
XFILLER_98_527 VDD VDD VSS VSS gf180mcu_fd_sc_mcu7t5v0__fillcap_8
XFILLER_3_483 VDD VDD VSS VSS gf180mcu_fd_sc_mcu7t5v0__fillcap_4
XFILLER_59_80 VDD VDD VSS VSS gf180mcu_fd_sc_mcu7t5v0__fill_1
X_2210_ _2210_/A1 _2224_/C _2211_/B VDD VDD VSS VSS gf180mcu_fd_sc_mcu7t5v0__nand2_1
Xfanout1240 _2588_/RN _2558_/RN VDD VDD VSS VSS gf180mcu_fd_sc_mcu7t5v0__dlyd_1
XPHY_EDGE_ROW_0_Left_119 VDD VSS gf180mcu_fd_sc_mcu7t5v0__endcap
X_2141_ _2141_/A1 _2139_/Z _2141_/B _2150_/B1 VDD VDD VSS VSS gf180mcu_fd_sc_mcu7t5v0__aoi21_1
XFILLER_66_457 VDD VDD VSS VSS gf180mcu_fd_sc_mcu7t5v0__fillcap_16
X_2072_ _2067_/B _2549_/Q _2072_/B _2072_/ZN VDD VDD VSS VSS gf180mcu_fd_sc_mcu7t5v0__oai21_1
XFILLER_34_310 VDD VDD VSS VSS gf180mcu_fd_sc_mcu7t5v0__fillcap_4
XTAP_TAPCELL_ROW_109_1561 VDD VSS gf180mcu_fd_sc_mcu7t5v0__filltie
XFILLER_22_527 VDD VDD VSS VSS gf180mcu_fd_sc_mcu7t5v0__fillcap_64
XFILLER_34_387 VDD VDD VSS VSS gf180mcu_fd_sc_mcu7t5v0__fillcap_4
X_1925_ _1925_/I _1925_/ZN VDD VDD VSS VSS gf180mcu_fd_sc_mcu7t5v0__clkinv_1
XFILLER_30_593 VDD VDD VSS VSS gf180mcu_fd_sc_mcu7t5v0__fill_2
X_1856_ _1856_/A1 _1900_/A2 _1900_/B1 _1856_/B2 _1857_/I VDD VDD VSS VSS gf180mcu_fd_sc_mcu7t5v0__aoi22_1
X_1787_ _1787_/I _1787_/ZN VDD VDD VSS VSS gf180mcu_fd_sc_mcu7t5v0__clkinv_1
XTAP_TAPCELL_ROW_73_1137 VDD VSS gf180mcu_fd_sc_mcu7t5v0__filltie
XFILLER_39_39 VDD VDD VSS VSS gf180mcu_fd_sc_mcu7t5v0__fillcap_16
XFILLER_112_860 VDD VDD VSS VSS gf180mcu_fd_sc_mcu7t5v0__fillcap_4
X_2408_ _2409_/A1 _2409_/A2 _2415_/A2 VDD VDD VSS VSS gf180mcu_fd_sc_mcu7t5v0__nor2_1
X_2339_ input98/Z _2375_/A2 _2379_/A3 _2340_/A2 VDD VDD VSS VSS gf180mcu_fd_sc_mcu7t5v0__nand3_1
XPHY_EDGE_ROW_2_Right_2 VDD VSS gf180mcu_fd_sc_mcu7t5v0__endcap
XFILLER_85_766 VDD VDD VSS VSS gf180mcu_fd_sc_mcu7t5v0__fillcap_4
XFILLER_25_343 VDD VDD VSS VSS gf180mcu_fd_sc_mcu7t5v0__fillcap_4
XFILLER_37_181 VDD VDD VSS VSS gf180mcu_fd_sc_mcu7t5v0__fillcap_16
XFILLER_25_376 VDD VDD VSS VSS gf180mcu_fd_sc_mcu7t5v0__fillcap_8
XFILLER_40_302 VDD VDD VSS VSS gf180mcu_fd_sc_mcu7t5v0__fill_1
XTAP_TAPCELL_ROW_84_1266 VDD VSS gf180mcu_fd_sc_mcu7t5v0__filltie
XTAP_TAPCELL_ROW_51_864 VDD VSS gf180mcu_fd_sc_mcu7t5v0__filltie
XTAP_TAPCELL_ROW_23_533 VDD VSS gf180mcu_fd_sc_mcu7t5v0__filltie
XTAP_TAPCELL_ROW_95_1395 VDD VSS gf180mcu_fd_sc_mcu7t5v0__filltie
XFILLER_0_420 VDD VDD VSS VSS gf180mcu_fd_sc_mcu7t5v0__fill_1
Xinput310 tl_h_d_i[37] _1928_/B2 VDD VDD VSS VSS gf180mcu_fd_sc_mcu7t5v0__dlyd_1
Xinput321 tl_h_d_i[47] _1948_/B2 VDD VDD VSS VSS gf180mcu_fd_sc_mcu7t5v0__dlyd_1
XFILLER_0_475 VDD VDD VSS VSS gf180mcu_fd_sc_mcu7t5v0__fill_1
XFILLER_102_370 VDD VDD VSS VSS gf180mcu_fd_sc_mcu7t5v0__fillcap_8
Xinput332 tl_h_d_i[57] _1968_/B2 VDD VDD VSS VSS gf180mcu_fd_sc_mcu7t5v0__dlyd_1
Xinput343 tl_h_d_i[67] _2726_/I VDD VDD VSS VSS gf180mcu_fd_sc_mcu7t5v0__clkbuf_2
Xinput354 tl_h_d_i[77] _2736_/I VDD VDD VSS VSS gf180mcu_fd_sc_mcu7t5v0__clkbuf_2
XFILLER_48_457 VDD VDD VSS VSS gf180mcu_fd_sc_mcu7t5v0__fill_1
Xinput365 tl_h_d_i[87] _2746_/I VDD VDD VSS VSS gf180mcu_fd_sc_mcu7t5v0__clkbuf_2
Xinput376 tl_h_d_i[97] _2756_/I VDD VDD VSS VSS gf180mcu_fd_sc_mcu7t5v0__dlyd_1
Xinput387 tl_h_i_i[106] _2394_/I0 VDD VDD VSS VSS gf180mcu_fd_sc_mcu7t5v0__dlyd_1
XTAP_TAPCELL_ROW_59_964 VDD VSS gf180mcu_fd_sc_mcu7t5v0__filltie
XFILLER_63_416 VDD VDD VSS VSS gf180mcu_fd_sc_mcu7t5v0__fillcap_4
Xinput398 tl_h_i_i[13] _1880_/A1 VDD VDD VSS VSS gf180mcu_fd_sc_mcu7t5v0__dlyd_1
XFILLER_75_276 VDD VDD VSS VSS gf180mcu_fd_sc_mcu7t5v0__fillcap_4
XFILLER_28_181 VDD VDD VSS VSS gf180mcu_fd_sc_mcu7t5v0__fillcap_16
XTAP_TAPCELL_ROW_3_291 VDD VSS gf180mcu_fd_sc_mcu7t5v0__filltie
XFILLER_44_663 VDD VDD VSS VSS gf180mcu_fd_sc_mcu7t5v0__fill_2
XFILLER_90_279 VDD VDD VSS VSS gf180mcu_fd_sc_mcu7t5v0__fill_2
XFILLER_16_387 VDD VDD VSS VSS gf180mcu_fd_sc_mcu7t5v0__fillcap_64
X_2690_ _2762_/I _2690_/Z VDD VDD VSS VSS gf180mcu_fd_sc_mcu7t5v0__buf_1
X_1710_ _1900_/A1 _1720_/A2 _1720_/B1 _2714_/I _1711_/I VDD VDD VSS VSS gf180mcu_fd_sc_mcu7t5v0__aoi22_1
XANTENNA_3 _2714_/I VDD VDD VSS VSS gf180mcu_fd_sc_mcu7t5v0__antenna
X_1641_ _1954_/B2 _1641_/A2 _1641_/Z VDD VDD VSS VSS gf180mcu_fd_sc_mcu7t5v0__or2_1
XFILLER_6_10 VDD VDD VSS VSS gf180mcu_fd_sc_mcu7t5v0__fillcap_4
Xoutput828 _2709_/Z tl_d_uart_o[18] VDD VDD VSS VSS gf180mcu_fd_sc_mcu7t5v0__dlyd_1
Xoutput817 _2769_/Z tl_d_uart_o[110] VDD VDD VSS VSS gf180mcu_fd_sc_mcu7t5v0__dlyd_1
Xoutput806 _2759_/Z tl_d_uart_o[100] VDD VDD VSS VSS gf180mcu_fd_sc_mcu7t5v0__dlyd_1
Xoutput839 _2719_/Z tl_d_uart_o[28] VDD VDD VSS VSS gf180mcu_fd_sc_mcu7t5v0__dlyd_1
X_1572_ _1872_/B2 _1571_/Z _1600_/S _1572_/Z VDD VDD VSS VSS gf180mcu_fd_sc_mcu7t5v0__mux2_2
XFILLER_20_2 VDD VDD VSS VSS gf180mcu_fd_sc_mcu7t5v0__fillcap_4
XFILLER_39_413 VDD VDD VSS VSS gf180mcu_fd_sc_mcu7t5v0__fill_2
XFILLER_67_766 VDD VDD VSS VSS gf180mcu_fd_sc_mcu7t5v0__fillcap_4
Xfanout1070 _1938_/A2 _1912_/A2 VDD VDD VSS VSS gf180mcu_fd_sc_mcu7t5v0__dlyd_1
X_2124_ input46/Z _2154_/A2 _2125_/A2 VDD VDD VSS VSS gf180mcu_fd_sc_mcu7t5v0__nor2_1
XFILLER_54_427 VDD VDD VSS VSS gf180mcu_fd_sc_mcu7t5v0__fillcap_8
X_2055_ _2055_/I _2055_/ZN VDD VDD VSS VSS gf180mcu_fd_sc_mcu7t5v0__clkinv_1
XFILLER_82_769 VDD VDD VSS VSS gf180mcu_fd_sc_mcu7t5v0__fill_2
XFILLER_81_268 VDD VDD VSS VSS gf180mcu_fd_sc_mcu7t5v0__fillcap_8
XFILLER_23_858 VDD VDD VSS VSS gf180mcu_fd_sc_mcu7t5v0__fillcap_8
XFILLER_35_696 VDD VDD VSS VSS gf180mcu_fd_sc_mcu7t5v0__fillcap_4
XFILLER_22_346 VDD VDD VSS VSS gf180mcu_fd_sc_mcu7t5v0__fillcap_4
X_1908_ _1908_/A1 _1914_/A2 _1930_/B1 _2718_/I _1909_/I VDD VDD VSS VSS gf180mcu_fd_sc_mcu7t5v0__aoi22_1
X_1839_ _1839_/I _1839_/ZN VDD VDD VSS VSS gf180mcu_fd_sc_mcu7t5v0__clkinv_1
XFILLER_89_346 VDD VDD VSS VSS gf180mcu_fd_sc_mcu7t5v0__fillcap_4
XTAP_TAPCELL_ROW_56_923 VDD VSS gf180mcu_fd_sc_mcu7t5v0__filltie
XFILLER_45_438 VDD VDD VSS VSS gf180mcu_fd_sc_mcu7t5v0__fillcap_8
XTAP_TAPCELL_ROW_56_934 VDD VSS gf180mcu_fd_sc_mcu7t5v0__filltie
XTAP_TAPCELL_ROW_0_261 VDD VSS gf180mcu_fd_sc_mcu7t5v0__filltie
XTAP_TAPCELL_ROW_0_250 VDD VSS gf180mcu_fd_sc_mcu7t5v0__filltie
XTAP_TAPCELL_ROW_36_691 VDD VSS gf180mcu_fd_sc_mcu7t5v0__filltie
XFILLER_9_339 VDD VDD VSS VSS gf180mcu_fd_sc_mcu7t5v0__fillcap_8
XTAP_TAPCELL_ROW_97_1424 VDD VSS gf180mcu_fd_sc_mcu7t5v0__filltie
XTAP_TAPCELL_ROW_8_350 VDD VSS gf180mcu_fd_sc_mcu7t5v0__filltie
XFILLER_95_338 VDD VDD VSS VSS gf180mcu_fd_sc_mcu7t5v0__fill_2
XFILLER_49_766 VDD VDD VSS VSS gf180mcu_fd_sc_mcu7t5v0__fillcap_4
Xinput140 tl_d_rom_i[15] _2174_/A1 VDD VDD VSS VSS gf180mcu_fd_sc_mcu7t5v0__dlyd_1
Xinput151 tl_d_rom_i[25] _1328_/A1 VDD VDD VSS VSS gf180mcu_fd_sc_mcu7t5v0__dlyd_1
Xinput162 tl_d_rom_i[35] _1408_/A1 VDD VDD VSS VSS gf180mcu_fd_sc_mcu7t5v0__dlyd_1
Xinput173 tl_d_rom_i[45] _1488_/A1 VDD VDD VSS VSS gf180mcu_fd_sc_mcu7t5v0__dlyd_1
Xinput184 tl_d_rom_i[55] _2212_/A1 VDD VDD VSS VSS gf180mcu_fd_sc_mcu7t5v0__dlyd_1
Xinput195 tl_d_rom_i[65] _1082_/I VDD VDD VSS VSS gf180mcu_fd_sc_mcu7t5v0__dlyd_1
XPHY_EDGE_ROW_90_Left_209 VDD VSS gf180mcu_fd_sc_mcu7t5v0__endcap
XFILLER_63_279 VDD VDD VSS VSS gf180mcu_fd_sc_mcu7t5v0__fill_1
XTAP_TAPCELL_ROW_106_1531 VDD VSS gf180mcu_fd_sc_mcu7t5v0__filltie
XFILLER_17_696 VDD VDD VSS VSS gf180mcu_fd_sc_mcu7t5v0__fillcap_4
XFILLER_31_198 VDD VDD VSS VSS gf180mcu_fd_sc_mcu7t5v0__fillcap_8
X_2742_ _2742_/I _2742_/Z VDD VDD VSS VSS gf180mcu_fd_sc_mcu7t5v0__buf_1
XFILLER_9_851 VDD VDD VSS VSS gf180mcu_fd_sc_mcu7t5v0__fillcap_8
X_2673_ _2745_/I _2673_/Z VDD VDD VSS VSS gf180mcu_fd_sc_mcu7t5v0__buf_1
Xoutput603 _2683_/Z tl_d_dmem_o[96] VDD VDD VSS VSS gf180mcu_fd_sc_mcu7t5v0__dlyd_1
Xoutput614 _2031_/ZN tl_d_esram_o[105] VDD VDD VSS VSS gf180mcu_fd_sc_mcu7t5v0__dlyd_1
Xoutput625 _1879_/ZN tl_d_esram_o[12] VDD VDD VSS VSS gf180mcu_fd_sc_mcu7t5v0__dlyd_1
Xoutput636 _1899_/ZN tl_d_esram_o[22] VDD VDD VSS VSS gf180mcu_fd_sc_mcu7t5v0__dlyd_1
X_1624_ _1920_/B2 _1665_/S _1624_/Z VDD VDD VSS VSS gf180mcu_fd_sc_mcu7t5v0__or2_1
XTAP_TAPCELL_ROW_117_1660 VDD VSS gf180mcu_fd_sc_mcu7t5v0__filltie
Xoutput647 _1919_/ZN tl_d_esram_o[32] VDD VDD VSS VSS gf180mcu_fd_sc_mcu7t5v0__dlyd_1
Xoutput658 _1939_/ZN tl_d_esram_o[42] VDD VDD VSS VSS gf180mcu_fd_sc_mcu7t5v0__dlyd_1
Xoutput669 _1959_/ZN tl_d_esram_o[52] VDD VDD VSS VSS gf180mcu_fd_sc_mcu7t5v0__dlyd_1
X_1555_ _2697_/I _2707_/I _1554_/Z _1555_/Z VDD VDD VSS VSS gf180mcu_fd_sc_mcu7t5v0__xor3_1
XPHY_EDGE_ROW_99_Right_99 VDD VSS gf180mcu_fd_sc_mcu7t5v0__endcap
X_1486_ _1486_/A1 _1486_/A2 _1486_/B1 _2208_/B _1487_/A2 VDD VDD VSS VSS gf180mcu_fd_sc_mcu7t5v0__aoi22_1
XFILLER_39_254 VDD VDD VSS VSS gf180mcu_fd_sc_mcu7t5v0__fillcap_16
XFILLER_94_360 VDD VDD VSS VSS gf180mcu_fd_sc_mcu7t5v0__fill_1
XFILLER_39_298 VDD VDD VSS VSS gf180mcu_fd_sc_mcu7t5v0__fill_2
XFILLER_54_235 VDD VDD VSS VSS gf180mcu_fd_sc_mcu7t5v0__fillcap_8
X_2107_ _2107_/I _2107_/ZN VDD VDD VSS VSS gf180mcu_fd_sc_mcu7t5v0__clkinv_1
XFILLER_82_544 VDD VDD VSS VSS gf180mcu_fd_sc_mcu7t5v0__fill_1
XFILLER_54_279 VDD VDD VSS VSS gf180mcu_fd_sc_mcu7t5v0__fillcap_16
X_2038_ _2038_/A1 _2044_/A2 _2038_/B1 _2768_/I _2039_/I VDD VDD VSS VSS gf180mcu_fd_sc_mcu7t5v0__aoi22_1
XTAP_TAPCELL_ROW_68_1069 VDD VSS gf180mcu_fd_sc_mcu7t5v0__filltie
XTAP_TAPCELL_ROW_81_1225 VDD VSS gf180mcu_fd_sc_mcu7t5v0__filltie
XFILLER_10_305 VDD VDD VSS VSS gf180mcu_fd_sc_mcu7t5v0__fillcap_4
XTAP_TAPCELL_ROW_33_650 VDD VSS gf180mcu_fd_sc_mcu7t5v0__filltie
XTAP_TAPCELL_ROW_61_992 VDD VSS gf180mcu_fd_sc_mcu7t5v0__filltie
XFILLER_104_454 VDD VDD VSS VSS gf180mcu_fd_sc_mcu7t5v0__fill_1
XTAP_TAPCELL_ROW_92_1365 VDD VSS gf180mcu_fd_sc_mcu7t5v0__filltie
XTAP_TAPCELL_ROW_5_320 VDD VSS gf180mcu_fd_sc_mcu7t5v0__filltie
XFILLER_77_349 VDD VDD VSS VSS gf180mcu_fd_sc_mcu7t5v0__fill_1
XFILLER_58_585 VDD VDD VSS VSS gf180mcu_fd_sc_mcu7t5v0__fillcap_8
XFILLER_85_360 VDD VDD VSS VSS gf180mcu_fd_sc_mcu7t5v0__fillcap_4
XFILLER_45_246 VDD VDD VSS VSS gf180mcu_fd_sc_mcu7t5v0__fillcap_16
XFILLER_60_205 VDD VDD VSS VSS gf180mcu_fd_sc_mcu7t5v0__fillcap_32
XTAP_TAPCELL_ROW_101_1472 VDD VSS gf180mcu_fd_sc_mcu7t5v0__filltie
XTAP_TAPCELL_ROW_11_388 VDD VSS gf180mcu_fd_sc_mcu7t5v0__filltie
X_1340_ input20/Z _1396_/A2 _1340_/B1 _1476_/B2 _1341_/I VDD VDD VSS VSS gf180mcu_fd_sc_mcu7t5v0__aoi22_1
XFILLER_68_338 VDD VDD VSS VSS gf180mcu_fd_sc_mcu7t5v0__fill_1
XFILLER_110_457 VDD VDD VSS VSS gf180mcu_fd_sc_mcu7t5v0__fillcap_4
X_1271_ _1399_/A1 _1271_/A2 _1271_/ZN VDD VDD VSS VSS gf180mcu_fd_sc_mcu7t5v0__nor2_1
XFILLER_92_831 VDD VDD VSS VSS gf180mcu_fd_sc_mcu7t5v0__fill_1
XFILLER_64_555 VDD VDD VSS VSS gf180mcu_fd_sc_mcu7t5v0__fillcap_8
XFILLER_64_577 VDD VDD VSS VSS gf180mcu_fd_sc_mcu7t5v0__fill_1
XFILLER_91_352 VDD VDD VSS VSS gf180mcu_fd_sc_mcu7t5v0__fillcap_8
XFILLER_24_419 VDD VDD VSS VSS gf180mcu_fd_sc_mcu7t5v0__fill_2
XFILLER_51_227 VDD VDD VSS VSS gf180mcu_fd_sc_mcu7t5v0__fillcap_32
XFILLER_64_588 VDD VDD VSS VSS gf180mcu_fd_sc_mcu7t5v0__fillcap_4
XTAP_TAPCELL_ROW_19_488 VDD VSS gf180mcu_fd_sc_mcu7t5v0__filltie
XFILLER_32_430 VDD VDD VSS VSS gf180mcu_fd_sc_mcu7t5v0__fillcap_16
XTAP_TAPCELL_ROW_30_620 VDD VSS gf180mcu_fd_sc_mcu7t5v0__filltie
X_2725_ _2725_/I _2725_/Z VDD VDD VSS VSS gf180mcu_fd_sc_mcu7t5v0__buf_1
X_2656_ _2728_/I _2656_/Z VDD VDD VSS VSS gf180mcu_fd_sc_mcu7t5v0__buf_1
X_1607_ _2753_/I _2755_/I _1606_/Z _1607_/Z VDD VDD VSS VSS gf180mcu_fd_sc_mcu7t5v0__xor3_1
X_2587_ _2587_/D _2587_/RN _2596_/CLK _2587_/Q VDD VDD VSS VSS gf180mcu_fd_sc_mcu7t5v0__dffrnq_1
Xoutput499 _2691_/Z tl_d_dmem_o[104] VDD VDD VSS VSS gf180mcu_fd_sc_mcu7t5v0__dlyd_1
X_1538_ _1964_/B2 _1619_/S _1538_/Z VDD VDD VSS VSS gf180mcu_fd_sc_mcu7t5v0__or2_1
X_1469_ _1469_/I _1470_/B1 VDD VDD VSS VSS gf180mcu_fd_sc_mcu7t5v0__clkinv_1
XFILLER_86_168 VDD VDD VSS VSS gf180mcu_fd_sc_mcu7t5v0__fillcap_4
XFILLER_86_157 VDD VDD VSS VSS gf180mcu_fd_sc_mcu7t5v0__fillcap_4
XFILLER_74_319 VDD VDD VSS VSS gf180mcu_fd_sc_mcu7t5v0__fill_1
XFILLER_83_842 VDD VDD VSS VSS gf180mcu_fd_sc_mcu7t5v0__fillcap_4
XFILLER_28_769 VDD VDD VSS VSS gf180mcu_fd_sc_mcu7t5v0__fill_2
XFILLER_82_341 VDD VDD VSS VSS gf180mcu_fd_sc_mcu7t5v0__fillcap_8
XFILLER_35_290 VDD VDD VSS VSS gf180mcu_fd_sc_mcu7t5v0__fillcap_4
XFILLER_18_224 VDD VDD VSS VSS gf180mcu_fd_sc_mcu7t5v0__fill_1
XFILLER_74_831 VDD VDD VSS VSS gf180mcu_fd_sc_mcu7t5v0__fill_1
XFILLER_73_352 VDD VDD VSS VSS gf180mcu_fd_sc_mcu7t5v0__fillcap_64
XFILLER_46_588 VDD VDD VSS VSS gf180mcu_fd_sc_mcu7t5v0__fillcap_4
XTAP_TAPCELL_ROW_16_447 VDD VSS gf180mcu_fd_sc_mcu7t5v0__filltie
XTAP_TAPCELL_ROW_44_789 VDD VSS gf180mcu_fd_sc_mcu7t5v0__filltie
XFILLER_41_282 VDD VDD VSS VSS gf180mcu_fd_sc_mcu7t5v0__fillcap_16
X_2510_ _2594_/Q _2507_/B _2514_/B VDD VDD VSS VSS gf180mcu_fd_sc_mcu7t5v0__nand2_1
X_2441_ _2435_/I _2442_/A3 _2441_/B _2445_/B VDD VDD VSS VSS gf180mcu_fd_sc_mcu7t5v0__aoi21_1
XTAP_TAPCELL_ROW_114_1630 VDD VSS gf180mcu_fd_sc_mcu7t5v0__filltie
XFILLER_68_102 VDD VDD VSS VSS gf180mcu_fd_sc_mcu7t5v0__fill_2
X_2372_ _2372_/A1 _2372_/A2 _2376_/B _2372_/ZN VDD VDD VSS VSS gf180mcu_fd_sc_mcu7t5v0__aoi21_1
X_1323_ _1491_/A1 _1321_/Z _1323_/B _1324_/B1 VDD VDD VSS VSS gf180mcu_fd_sc_mcu7t5v0__oai21_1
X_1254_ _2571_/Q _2574_/Q _1255_/A4 VDD VDD VSS VSS gf180mcu_fd_sc_mcu7t5v0__nor2_1
XFILLER_65_842 VDD VDD VSS VSS gf180mcu_fd_sc_mcu7t5v0__fillcap_16
XFILLER_77_680 VDD VDD VSS VSS gf180mcu_fd_sc_mcu7t5v0__fillcap_8
X_1185_ _2740_/I _2741_/I _2457_/A1 _1188_/A3 VDD VDD VSS VSS gf180mcu_fd_sc_mcu7t5v0__nor3_1
XFILLER_80_801 VDD VDD VSS VSS gf180mcu_fd_sc_mcu7t5v0__fillcap_4
XFILLER_80_823 VDD VDD VSS VSS gf180mcu_fd_sc_mcu7t5v0__fillcap_8
XTAP_TAPCELL_ROW_65_1039 VDD VSS gf180mcu_fd_sc_mcu7t5v0__filltie
XFILLER_60_591 VDD VDD VSS VSS gf180mcu_fd_sc_mcu7t5v0__fillcap_4
X_2708_ _2708_/I _2708_/Z VDD VDD VSS VSS gf180mcu_fd_sc_mcu7t5v0__buf_1
X_2639_ _2711_/I _2639_/Z VDD VDD VSS VSS gf180mcu_fd_sc_mcu7t5v0__buf_1
XTAP_TAPCELL_ROW_76_1168 VDD VSS gf180mcu_fd_sc_mcu7t5v0__filltie
XFILLER_99_293 VDD VDD VSS VSS gf180mcu_fd_sc_mcu7t5v0__fill_2
XFILLER_87_422 VDD VDD VSS VSS gf180mcu_fd_sc_mcu7t5v0__fillcap_8
XFILLER_75_628 VDD VDD VSS VSS gf180mcu_fd_sc_mcu7t5v0__fill_2
XFILLER_56_831 VDD VDD VSS VSS gf180mcu_fd_sc_mcu7t5v0__fill_1
XFILLER_55_352 VDD VDD VSS VSS gf180mcu_fd_sc_mcu7t5v0__fill_2
XFILLER_28_588 VDD VDD VSS VSS gf180mcu_fd_sc_mcu7t5v0__fillcap_4
XFILLER_70_311 VDD VDD VSS VSS gf180mcu_fd_sc_mcu7t5v0__fillcap_4
XTAP_TAPCELL_ROW_87_1297 VDD VSS gf180mcu_fd_sc_mcu7t5v0__filltie
XFILLER_70_333 VDD VDD VSS VSS gf180mcu_fd_sc_mcu7t5v0__fillcap_8
Xclkbuf_3_0__f_clk_i clkbuf_0_clk_i/Z clkload0/I VDD VDD VSS VSS gf180mcu_fd_sc_mcu7t5v0__clkbuf_16
XFILLER_11_422 VDD VDD VSS VSS gf180mcu_fd_sc_mcu7t5v0__fillcap_64
XFILLER_23_282 VDD VDD VSS VSS gf180mcu_fd_sc_mcu7t5v0__fillcap_16
XFILLER_51_591 VDD VDD VSS VSS gf180mcu_fd_sc_mcu7t5v0__fillcap_32
XTAP_TAPCELL_ROW_41_748 VDD VSS gf180mcu_fd_sc_mcu7t5v0__filltie
XTAP_TAPCELL_ROW_13_417 VDD VSS gf180mcu_fd_sc_mcu7t5v0__filltie
XFILLER_78_433 VDD VDD VSS VSS gf180mcu_fd_sc_mcu7t5v0__fillcap_8
XFILLER_66_617 VDD VDD VSS VSS gf180mcu_fd_sc_mcu7t5v0__fill_2
XTAP_TAPCELL_ROW_49_848 VDD VSS gf180mcu_fd_sc_mcu7t5v0__filltie
XFILLER_47_864 VDD VDD VSS VSS gf180mcu_fd_sc_mcu7t5v0__fill_2
XFILLER_62_801 VDD VDD VSS VSS gf180mcu_fd_sc_mcu7t5v0__fillcap_4
XFILLER_74_661 VDD VDD VSS VSS gf180mcu_fd_sc_mcu7t5v0__fillcap_4
XFILLER_62_823 VDD VDD VSS VSS gf180mcu_fd_sc_mcu7t5v0__fillcap_8
XFILLER_30_731 VDD VDD VSS VSS gf180mcu_fd_sc_mcu7t5v0__fillcap_4
X_1941_ _1941_/I _1941_/ZN VDD VDD VSS VSS gf180mcu_fd_sc_mcu7t5v0__clkinv_1
X_1872_ _1872_/A1 _1900_/A2 _1900_/B1 _1872_/B2 _1873_/I VDD VDD VSS VSS gf180mcu_fd_sc_mcu7t5v0__aoi22_1
XFILLER_50_2 VDD VDD VSS VSS gf180mcu_fd_sc_mcu7t5v0__fillcap_32
XFILLER_103_508 VDD VDD VSS VSS gf180mcu_fd_sc_mcu7t5v0__fillcap_4
X_2424_ _2421_/I _2434_/A3 _2424_/Z VDD VDD VSS VSS gf180mcu_fd_sc_mcu7t5v0__xor2_1
X_2355_ _2355_/A1 _2363_/A2 _2355_/A3 _2356_/A2 VDD VDD VSS VSS gf180mcu_fd_sc_mcu7t5v0__nand3_1
XFILLER_69_422 VDD VDD VSS VSS gf180mcu_fd_sc_mcu7t5v0__fillcap_64
X_1306_ input82/Z _1418_/A2 _2311_/A3 _1307_/B VDD VDD VSS VSS gf180mcu_fd_sc_mcu7t5v0__nand3_1
XFILLER_38_831 VDD VDD VSS VSS gf180mcu_fd_sc_mcu7t5v0__fill_1
X_2286_ _2302_/A1 _2286_/A2 _2288_/A1 VDD VDD VSS VSS gf180mcu_fd_sc_mcu7t5v0__nand2_1
XFILLER_37_330 VDD VDD VSS VSS gf180mcu_fd_sc_mcu7t5v0__fillcap_16
X_1237_ _1247_/A1 _1247_/A2 _1237_/ZN VDD VDD VSS VSS gf180mcu_fd_sc_mcu7t5v0__nand2_1
XFILLER_37_352 VDD VDD VSS VSS gf180mcu_fd_sc_mcu7t5v0__fillcap_8
XFILLER_65_694 VDD VDD VSS VSS gf180mcu_fd_sc_mcu7t5v0__fillcap_4
X_1168_ _1164_/Z _1173_/A2 _2383_/A1 VDD VDD VSS VSS gf180mcu_fd_sc_mcu7t5v0__nor2_1
XFILLER_52_333 VDD VDD VSS VSS gf180mcu_fd_sc_mcu7t5v0__fillcap_4
X_1099_ _1099_/I _2204_/A1 VDD VDD VSS VSS gf180mcu_fd_sc_mcu7t5v0__clkinv_1
XFILLER_80_675 VDD VDD VSS VSS gf180mcu_fd_sc_mcu7t5v0__fillcap_4
XFILLER_60_28 VDD VDD VSS VSS gf180mcu_fd_sc_mcu7t5v0__fillcap_4
XFILLER_106_357 VDD VDD VSS VSS gf180mcu_fd_sc_mcu7t5v0__fill_1
XFILLER_47_127 VDD VDD VSS VSS gf180mcu_fd_sc_mcu7t5v0__fillcap_8
XTAP_TAPCELL_ROW_89_1326 VDD VSS gf180mcu_fd_sc_mcu7t5v0__filltie
XFILLER_87_274 VDD VDD VSS VSS gf180mcu_fd_sc_mcu7t5v0__fillcap_4
XFILLER_75_414 VDD VDD VSS VSS gf180mcu_fd_sc_mcu7t5v0__fillcap_4
XFILLER_29_842 VDD VDD VSS VSS gf180mcu_fd_sc_mcu7t5v0__fillcap_16
XTAP_TAPCELL_ROW_46_807 VDD VSS gf180mcu_fd_sc_mcu7t5v0__filltie
XFILLER_44_823 VDD VDD VSS VSS gf180mcu_fd_sc_mcu7t5v0__fillcap_8
XTAP_TAPCELL_ROW_26_564 VDD VSS gf180mcu_fd_sc_mcu7t5v0__filltie
XFILLER_71_664 VDD VDD VSS VSS gf180mcu_fd_sc_mcu7t5v0__fillcap_8
XFILLER_12_731 VDD VDD VSS VSS gf180mcu_fd_sc_mcu7t5v0__fillcap_4
XFILLER_24_591 VDD VDD VSS VSS gf180mcu_fd_sc_mcu7t5v0__fillcap_4
XFILLER_71_697 VDD VDD VSS VSS gf180mcu_fd_sc_mcu7t5v0__fill_2
X_2140_ _2141_/A1 _2139_/Z _2140_/B _2141_/B VDD VDD VSS VSS gf180mcu_fd_sc_mcu7t5v0__oai21_1
X_2071_ input71/Z _2343_/A2 _2345_/A1 _2157_/A1 _2072_/B VDD VDD VSS VSS gf180mcu_fd_sc_mcu7t5v0__aoi22_1
XFILLER_19_352 VDD VDD VSS VSS gf180mcu_fd_sc_mcu7t5v0__fillcap_4
XTAP_TAPCELL_ROW_109_1562 VDD VSS gf180mcu_fd_sc_mcu7t5v0__filltie
XFILLER_93_266 VDD VDD VSS VSS gf180mcu_fd_sc_mcu7t5v0__fillcap_4
XFILLER_93_299 VDD VDD VSS VSS gf180mcu_fd_sc_mcu7t5v0__fillcap_4
XFILLER_62_664 VDD VDD VSS VSS gf180mcu_fd_sc_mcu7t5v0__fill_1
XFILLER_61_174 VDD VDD VSS VSS gf180mcu_fd_sc_mcu7t5v0__fillcap_32
X_1924_ _1924_/A1 _1938_/A2 _1930_/B1 _1924_/B2 _1925_/I VDD VDD VSS VSS gf180mcu_fd_sc_mcu7t5v0__aoi22_1
XFILLER_30_561 VDD VDD VSS VSS gf180mcu_fd_sc_mcu7t5v0__fillcap_32
X_1855_ _1855_/I _1855_/ZN VDD VDD VSS VSS gf180mcu_fd_sc_mcu7t5v0__clkinv_1
X_1786_ _1976_/A1 _1818_/A2 _1838_/B1 _2720_/I _1787_/I VDD VDD VSS VSS gf180mcu_fd_sc_mcu7t5v0__aoi22_1
XFILLER_104_828 VDD VDD VSS VSS gf180mcu_fd_sc_mcu7t5v0__fillcap_4
XTAP_TAPCELL_ROW_73_1138 VDD VSS gf180mcu_fd_sc_mcu7t5v0__filltie
XTAP_TAPCELL_ROW_73_1127 VDD VSS gf180mcu_fd_sc_mcu7t5v0__filltie
X_2407_ _2560_/Q _2434_/B _2409_/A2 VDD VDD VSS VSS gf180mcu_fd_sc_mcu7t5v0__xnor2_1
XPHY_EDGE_ROW_110_Left_229 VDD VSS gf180mcu_fd_sc_mcu7t5v0__endcap
XFILLER_57_414 VDD VDD VSS VSS gf180mcu_fd_sc_mcu7t5v0__fillcap_4
XFILLER_57_436 VDD VDD VSS VSS gf180mcu_fd_sc_mcu7t5v0__fill_1
X_2338_ _2374_/A1 _2338_/A2 _2340_/A1 VDD VDD VSS VSS gf180mcu_fd_sc_mcu7t5v0__nand2_1
XFILLER_69_263 VDD VDD VSS VSS gf180mcu_fd_sc_mcu7t5v0__fillcap_16
X_2269_ _2293_/A1 _2269_/A2 _2270_/A2 VDD VDD VSS VSS gf180mcu_fd_sc_mcu7t5v0__nand2_1
XFILLER_84_244 VDD VDD VSS VSS gf180mcu_fd_sc_mcu7t5v0__fill_1
XFILLER_26_801 VDD VDD VSS VSS gf180mcu_fd_sc_mcu7t5v0__fillcap_4
XFILLER_26_823 VDD VDD VSS VSS gf180mcu_fd_sc_mcu7t5v0__fillcap_8
XFILLER_38_661 VDD VDD VSS VSS gf180mcu_fd_sc_mcu7t5v0__fillcap_4
XFILLER_53_620 VDD VDD VSS VSS gf180mcu_fd_sc_mcu7t5v0__fillcap_8
XTAP_TAPCELL_ROW_84_1267 VDD VSS gf180mcu_fd_sc_mcu7t5v0__filltie
XFILLER_80_461 VDD VDD VSS VSS gf180mcu_fd_sc_mcu7t5v0__fill_1
XFILLER_25_388 VDD VDD VSS VSS gf180mcu_fd_sc_mcu7t5v0__fill_2
XFILLER_40_314 VDD VDD VSS VSS gf180mcu_fd_sc_mcu7t5v0__fill_1
XFILLER_41_859 VDD VDD VSS VSS gf180mcu_fd_sc_mcu7t5v0__fillcap_4
XFILLER_52_174 VDD VDD VSS VSS gf180mcu_fd_sc_mcu7t5v0__fill_1
XTAP_TAPCELL_ROW_51_865 VDD VSS gf180mcu_fd_sc_mcu7t5v0__filltie
XTAP_TAPCELL_ROW_23_534 VDD VSS gf180mcu_fd_sc_mcu7t5v0__filltie
XTAP_TAPCELL_ROW_95_1396 VDD VSS gf180mcu_fd_sc_mcu7t5v0__filltie
XFILLER_0_410 VDD VDD VSS VSS gf180mcu_fd_sc_mcu7t5v0__fill_2
Xinput300 tl_h_d_i[28] _2719_/I VDD VDD VSS VSS gf180mcu_fd_sc_mcu7t5v0__dlyd_1
Xinput311 tl_h_d_i[38] _1930_/B2 VDD VDD VSS VSS gf180mcu_fd_sc_mcu7t5v0__dlyd_1
XFILLER_102_382 VDD VDD VSS VSS gf180mcu_fd_sc_mcu7t5v0__fill_2
Xinput322 tl_h_d_i[48] _1950_/B2 VDD VDD VSS VSS gf180mcu_fd_sc_mcu7t5v0__dlyd_1
Xinput333 tl_h_d_i[58] _1970_/B2 VDD VDD VSS VSS gf180mcu_fd_sc_mcu7t5v0__dlyd_1
Xinput344 tl_h_d_i[68] _2727_/I VDD VDD VSS VSS gf180mcu_fd_sc_mcu7t5v0__clkbuf_2
Xinput355 tl_h_d_i[78] _2737_/I VDD VDD VSS VSS gf180mcu_fd_sc_mcu7t5v0__clkbuf_2
Xinput366 tl_h_d_i[88] _2747_/I VDD VDD VSS VSS gf180mcu_fd_sc_mcu7t5v0__clkbuf_2
Xinput377 tl_h_d_i[98] _2757_/I VDD VDD VSS VSS gf180mcu_fd_sc_mcu7t5v0__dlyd_1
Xinput388 tl_h_i_i[107] _2034_/A1 VDD VDD VSS VSS gf180mcu_fd_sc_mcu7t5v0__dlyd_1
XTAP_TAPCELL_ROW_59_965 VDD VSS gf180mcu_fd_sc_mcu7t5v0__filltie
Xinput399 tl_h_i_i[14] _1882_/A1 VDD VDD VSS VSS gf180mcu_fd_sc_mcu7t5v0__dlyd_1
XFILLER_16_311 VDD VDD VSS VSS gf180mcu_fd_sc_mcu7t5v0__fillcap_4
XTAP_TAPCELL_ROW_3_292 VDD VSS gf180mcu_fd_sc_mcu7t5v0__filltie
XFILLER_90_247 VDD VDD VSS VSS gf180mcu_fd_sc_mcu7t5v0__fillcap_32
XFILLER_71_450 VDD VDD VSS VSS gf180mcu_fd_sc_mcu7t5v0__fill_1
XFILLER_43_174 VDD VDD VSS VSS gf180mcu_fd_sc_mcu7t5v0__fillcap_16
XFILLER_31_347 VDD VDD VSS VSS gf180mcu_fd_sc_mcu7t5v0__fill_2
XFILLER_8_521 VDD VDD VSS VSS gf180mcu_fd_sc_mcu7t5v0__fillcap_4
X_1640_ _1952_/B2 _1641_/A2 _1640_/Z VDD VDD VSS VSS gf180mcu_fd_sc_mcu7t5v0__or2_1
XANTENNA_4 _2162_/ZN VDD VDD VSS VSS gf180mcu_fd_sc_mcu7t5v0__antenna
Xoutput818 _2770_/Z tl_d_uart_o[111] VDD VDD VSS VSS gf180mcu_fd_sc_mcu7t5v0__dlyd_1
Xoutput807 _2760_/Z tl_d_uart_o[101] VDD VDD VSS VSS gf180mcu_fd_sc_mcu7t5v0__dlyd_1
X_1571_ _1558_/Z _1566_/Z _1570_/Z _1571_/Z VDD VDD VSS VSS gf180mcu_fd_sc_mcu7t5v0__xor3_1
Xoutput829 _2710_/Z tl_d_uart_o[19] VDD VDD VSS VSS gf180mcu_fd_sc_mcu7t5v0__dlyd_1
XFILLER_98_303 VDD VDD VSS VSS gf180mcu_fd_sc_mcu7t5v0__fillcap_8
XFILLER_98_347 VDD VDD VSS VSS gf180mcu_fd_sc_mcu7t5v0__fillcap_16
Xfanout1060 _1184_/ZN _2537_/A2 VDD VDD VSS VSS gf180mcu_fd_sc_mcu7t5v0__dlyd_1
X_2123_ _2123_/A1 _2238_/A2 _2238_/B1 _2123_/B2 _2178_/C _2125_/A1 VDD VDD VSS VSS
+ gf180mcu_fd_sc_mcu7t5v0__aoi221_2
Xfanout1093 _1830_/A2 _1768_/A2 VDD VDD VSS VSS gf180mcu_fd_sc_mcu7t5v0__dlyd_1
XFILLER_94_597 VDD VDD VSS VSS gf180mcu_fd_sc_mcu7t5v0__fillcap_32
XFILLER_94_575 VDD VDD VSS VSS gf180mcu_fd_sc_mcu7t5v0__fillcap_4
XFILLER_82_737 VDD VDD VSS VSS gf180mcu_fd_sc_mcu7t5v0__fillcap_32
XFILLER_54_439 VDD VDD VSS VSS gf180mcu_fd_sc_mcu7t5v0__fill_2
X_2054_ _2126_/B2 _2064_/B _2102_/B2 _2126_/A1 _2055_/I VDD VDD VSS VSS gf180mcu_fd_sc_mcu7t5v0__oai22_1
XFILLER_81_225 VDD VDD VSS VSS gf180mcu_fd_sc_mcu7t5v0__fill_1
XFILLER_22_314 VDD VDD VSS VSS gf180mcu_fd_sc_mcu7t5v0__fill_1
XFILLER_34_174 VDD VDD VSS VSS gf180mcu_fd_sc_mcu7t5v0__fill_1
XFILLER_62_483 VDD VDD VSS VSS gf180mcu_fd_sc_mcu7t5v0__fillcap_32
XFILLER_50_645 VDD VDD VSS VSS gf180mcu_fd_sc_mcu7t5v0__fillcap_4
XFILLER_50_667 VDD VDD VSS VSS gf180mcu_fd_sc_mcu7t5v0__fillcap_64
X_1907_ _1907_/I _1907_/ZN VDD VDD VSS VSS gf180mcu_fd_sc_mcu7t5v0__clkinv_1
X_1838_ _2401_/I0 _1854_/A2 _1838_/B1 _2762_/I _1839_/I VDD VDD VSS VSS gf180mcu_fd_sc_mcu7t5v0__aoi22_1
X_1769_ _1769_/I _1769_/ZN VDD VDD VSS VSS gf180mcu_fd_sc_mcu7t5v0__clkinv_1
XFILLER_100_831 VDD VDD VSS VSS gf180mcu_fd_sc_mcu7t5v0__fill_1
XTAP_TAPCELL_ROW_56_924 VDD VSS gf180mcu_fd_sc_mcu7t5v0__filltie
XFILLER_72_203 VDD VDD VSS VSS gf180mcu_fd_sc_mcu7t5v0__fillcap_4
XTAP_TAPCELL_ROW_0_262 VDD VSS gf180mcu_fd_sc_mcu7t5v0__filltie
XTAP_TAPCELL_ROW_0_251 VDD VSS gf180mcu_fd_sc_mcu7t5v0__filltie
XTAP_TAPCELL_ROW_0_240 VDD VSS gf180mcu_fd_sc_mcu7t5v0__filltie
XFILLER_72_247 VDD VDD VSS VSS gf180mcu_fd_sc_mcu7t5v0__fillcap_64
XTAP_TAPCELL_ROW_36_692 VDD VSS gf180mcu_fd_sc_mcu7t5v0__filltie
XFILLER_40_155 VDD VDD VSS VSS gf180mcu_fd_sc_mcu7t5v0__fillcap_16
XFILLER_40_177 VDD VDD VSS VSS gf180mcu_fd_sc_mcu7t5v0__fillcap_64
XFILLER_41_678 VDD VDD VSS VSS gf180mcu_fd_sc_mcu7t5v0__fillcap_16
XTAP_TAPCELL_ROW_97_1425 VDD VSS gf180mcu_fd_sc_mcu7t5v0__filltie
XFILLER_107_485 VDD VDD VSS VSS gf180mcu_fd_sc_mcu7t5v0__fill_2
XFILLER_68_509 VDD VDD VSS VSS gf180mcu_fd_sc_mcu7t5v0__fill_1
XTAP_TAPCELL_ROW_8_351 VDD VSS gf180mcu_fd_sc_mcu7t5v0__filltie
XFILLER_96_807 VDD VDD VSS VSS gf180mcu_fd_sc_mcu7t5v0__fillcap_16
XFILLER_0_240 VDD VDD VSS VSS gf180mcu_fd_sc_mcu7t5v0__fillcap_32
Xinput130 tl_d_esram_i[6] _2130_/B2 VDD VDD VSS VSS gf180mcu_fd_sc_mcu7t5v0__dlyd_1
Xinput141 tl_d_rom_i[16] _1252_/A1 VDD VDD VSS VSS gf180mcu_fd_sc_mcu7t5v0__dlyd_1
Xinput152 tl_d_rom_i[26] _1336_/A1 VDD VDD VSS VSS gf180mcu_fd_sc_mcu7t5v0__dlyd_1
Xinput163 tl_d_rom_i[36] _1416_/A1 VDD VDD VSS VSS gf180mcu_fd_sc_mcu7t5v0__dlyd_1
XFILLER_76_520 VDD VDD VSS VSS gf180mcu_fd_sc_mcu7t5v0__fillcap_4
Xinput174 tl_d_rom_i[46] _1496_/A1 VDD VDD VSS VSS gf180mcu_fd_sc_mcu7t5v0__dlyd_1
Xinput185 tl_d_rom_i[56] _2218_/A1 VDD VDD VSS VSS gf180mcu_fd_sc_mcu7t5v0__dlyd_1
Xinput196 tl_d_rom_i[6] _2130_/A1 VDD VDD VSS VSS gf180mcu_fd_sc_mcu7t5v0__dlyd_1
XFILLER_64_737 VDD VDD VSS VSS gf180mcu_fd_sc_mcu7t5v0__fillcap_64
XFILLER_76_597 VDD VDD VSS VSS gf180mcu_fd_sc_mcu7t5v0__fillcap_16
XTAP_TAPCELL_ROW_106_1532 VDD VSS gf180mcu_fd_sc_mcu7t5v0__filltie
XFILLER_20_807 VDD VDD VSS VSS gf180mcu_fd_sc_mcu7t5v0__fillcap_16
XFILLER_32_667 VDD VDD VSS VSS gf180mcu_fd_sc_mcu7t5v0__fillcap_64
XFILLER_31_166 VDD VDD VSS VSS gf180mcu_fd_sc_mcu7t5v0__fillcap_32
X_2741_ _2741_/I _2741_/Z VDD VDD VSS VSS gf180mcu_fd_sc_mcu7t5v0__buf_1
XFILLER_9_863 VDD VDD VSS VSS gf180mcu_fd_sc_mcu7t5v0__fill_2
X_2672_ _2744_/I _2672_/Z VDD VDD VSS VSS gf180mcu_fd_sc_mcu7t5v0__buf_1
XFILLER_8_395 VDD VDD VSS VSS gf180mcu_fd_sc_mcu7t5v0__fillcap_4
Xoutput604 _2684_/Z tl_d_dmem_o[97] VDD VDD VSS VSS gf180mcu_fd_sc_mcu7t5v0__dlyd_1
Xoutput615 _2033_/ZN tl_d_esram_o[106] VDD VDD VSS VSS gf180mcu_fd_sc_mcu7t5v0__dlyd_1
Xoutput626 _1881_/ZN tl_d_esram_o[13] VDD VDD VSS VSS gf180mcu_fd_sc_mcu7t5v0__dlyd_1
X_1623_ _1918_/B2 _1664_/S _1623_/Z VDD VDD VSS VSS gf180mcu_fd_sc_mcu7t5v0__or2_1
XTAP_TAPCELL_ROW_117_1661 VDD VSS gf180mcu_fd_sc_mcu7t5v0__filltie
XFILLER_113_422 VDD VDD VSS VSS gf180mcu_fd_sc_mcu7t5v0__fill_2
Xoutput637 _1901_/ZN tl_d_esram_o[23] VDD VDD VSS VSS gf180mcu_fd_sc_mcu7t5v0__dlyd_1
Xoutput648 _1921_/ZN tl_d_esram_o[33] VDD VDD VSS VSS gf180mcu_fd_sc_mcu7t5v0__dlyd_1
Xoutput659 _1941_/ZN tl_d_esram_o[43] VDD VDD VSS VSS gf180mcu_fd_sc_mcu7t5v0__dlyd_1
X_1554_ _2721_/I _2720_/I _1554_/Z VDD VDD VSS VSS gf180mcu_fd_sc_mcu7t5v0__xor2_1
X_1485_ _1485_/I _1486_/B1 VDD VDD VSS VSS gf180mcu_fd_sc_mcu7t5v0__clkinv_1
XFILLER_86_317 VDD VDD VSS VSS gf180mcu_fd_sc_mcu7t5v0__fillcap_16
.ends
